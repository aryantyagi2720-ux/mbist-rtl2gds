* NGSPICE file created from mbist_top.ext - technology: sky130A

* Black-box entry subcircuit for sky130_fd_sc_hd__tapvpwrvgnd_1 abstract view
.subckt sky130_fd_sc_hd__tapvpwrvgnd_1 VGND VPWR
.ends

* Black-box entry subcircuit for sky130_fd_sc_hd__decap_6 abstract view
.subckt sky130_fd_sc_hd__decap_6 VGND VNB VPB VPWR
.ends

* Black-box entry subcircuit for sky130_ef_sc_hd__decap_12 abstract view
.subckt sky130_ef_sc_hd__decap_12 VPWR VGND VPB VNB
.ends

* Black-box entry subcircuit for sky130_fd_sc_hd__decap_3 abstract view
.subckt sky130_fd_sc_hd__decap_3 VGND VNB VPB VPWR
.ends

* Black-box entry subcircuit for sky130_fd_sc_hd__fill_1 abstract view
.subckt sky130_fd_sc_hd__fill_1 VGND VNB VPB VPWR
.ends

* Black-box entry subcircuit for sky130_fd_sc_hd__diode_2 abstract view
.subckt sky130_fd_sc_hd__diode_2 DIODE VGND VNB VPB VPWR
.ends

* Black-box entry subcircuit for sky130_fd_sc_hd__decap_8 abstract view
.subckt sky130_fd_sc_hd__decap_8 VGND VNB VPB VPWR
.ends

* Black-box entry subcircuit for sky130_fd_sc_hd__o211a_1 abstract view
.subckt sky130_fd_sc_hd__o211a_1 A1 A2 B1 C1 VGND VNB VPB VPWR X
.ends

* Black-box entry subcircuit for sky130_fd_sc_hd__o21ai_1 abstract view
.subckt sky130_fd_sc_hd__o21ai_1 A1 A2 B1 VGND VNB VPB VPWR Y
.ends

* Black-box entry subcircuit for sky130_fd_sc_hd__or4_1 abstract view
.subckt sky130_fd_sc_hd__or4_1 A B C D VGND VNB VPB VPWR X
.ends

* Black-box entry subcircuit for sky130_fd_sc_hd__a21o_1 abstract view
.subckt sky130_fd_sc_hd__a21o_1 A1 A2 B1 VGND VNB VPB VPWR X
.ends

* Black-box entry subcircuit for sky130_fd_sc_hd__decap_4 abstract view
.subckt sky130_fd_sc_hd__decap_4 VGND VNB VPB VPWR
.ends

* Black-box entry subcircuit for sky130_fd_sc_hd__fill_2 abstract view
.subckt sky130_fd_sc_hd__fill_2 VGND VNB VPB VPWR
.ends

* Black-box entry subcircuit for sky130_fd_sc_hd__buf_2 abstract view
.subckt sky130_fd_sc_hd__buf_2 A VGND VNB VPB VPWR X
.ends

* Black-box entry subcircuit for sky130_fd_sc_hd__clkbuf_4 abstract view
.subckt sky130_fd_sc_hd__clkbuf_4 A VGND VNB VPB VPWR X
.ends

* Black-box entry subcircuit for sky130_fd_sc_hd__nor2_1 abstract view
.subckt sky130_fd_sc_hd__nor2_1 A B VGND VNB VPB VPWR Y
.ends

* Black-box entry subcircuit for sky130_fd_sc_hd__mux2_1 abstract view
.subckt sky130_fd_sc_hd__mux2_1 A0 A1 S VGND VNB VPB VPWR X
.ends

* Black-box entry subcircuit for sky130_fd_sc_hd__clkbuf_8 abstract view
.subckt sky130_fd_sc_hd__clkbuf_8 A VGND VNB VPB VPWR X
.ends

* Black-box entry subcircuit for sky130_fd_sc_hd__dfxtp_1 abstract view
.subckt sky130_fd_sc_hd__dfxtp_1 CLK D VGND VNB VPB VPWR Q
.ends

* Black-box entry subcircuit for sky130_fd_sc_hd__nand2_1 abstract view
.subckt sky130_fd_sc_hd__nand2_1 A B VGND VNB VPB VPWR Y
.ends

* Black-box entry subcircuit for sky130_fd_sc_hd__xnor2_1 abstract view
.subckt sky130_fd_sc_hd__xnor2_1 A B VGND VNB VPB VPWR Y
.ends

* Black-box entry subcircuit for sky130_fd_sc_hd__and3_1 abstract view
.subckt sky130_fd_sc_hd__and3_1 A B C VGND VNB VPB VPWR X
.ends

* Black-box entry subcircuit for sky130_fd_sc_hd__and2_1 abstract view
.subckt sky130_fd_sc_hd__and2_1 A B VGND VNB VPB VPWR X
.ends

* Black-box entry subcircuit for sky130_fd_sc_hd__o21a_1 abstract view
.subckt sky130_fd_sc_hd__o21a_1 A1 A2 B1 VGND VNB VPB VPWR X
.ends

* Black-box entry subcircuit for sky130_fd_sc_hd__and2_4 abstract view
.subckt sky130_fd_sc_hd__and2_4 A B VGND VNB VPB VPWR X
.ends

* Black-box entry subcircuit for sky130_fd_sc_hd__nor2_2 abstract view
.subckt sky130_fd_sc_hd__nor2_2 A B VGND VNB VPB VPWR Y
.ends

* Black-box entry subcircuit for sky130_fd_sc_hd__clkbuf_2 abstract view
.subckt sky130_fd_sc_hd__clkbuf_2 A VGND VNB VPB VPWR X
.ends

* Black-box entry subcircuit for sky130_fd_sc_hd__and2b_1 abstract view
.subckt sky130_fd_sc_hd__and2b_1 A_N B VGND VNB VPB VPWR X
.ends

* Black-box entry subcircuit for sky130_fd_sc_hd__o211ai_4 abstract view
.subckt sky130_fd_sc_hd__o211ai_4 A1 A2 B1 C1 VGND VNB VPB VPWR Y
.ends

* Black-box entry subcircuit for sky130_fd_sc_hd__o311a_1 abstract view
.subckt sky130_fd_sc_hd__o311a_1 A1 A2 A3 B1 C1 VGND VNB VPB VPWR X
.ends

* Black-box entry subcircuit for sky130_fd_sc_hd__inv_2 abstract view
.subckt sky130_fd_sc_hd__inv_2 A VGND VNB VPB VPWR Y
.ends

* Black-box entry subcircuit for sky130_fd_sc_hd__a211o_1 abstract view
.subckt sky130_fd_sc_hd__a211o_1 A1 A2 B1 C1 VGND VNB VPB VPWR X
.ends

* Black-box entry subcircuit for sky130_fd_sc_hd__or2_1 abstract view
.subckt sky130_fd_sc_hd__or2_1 A B VGND VNB VPB VPWR X
.ends

* Black-box entry subcircuit for sky130_fd_sc_hd__a21oi_1 abstract view
.subckt sky130_fd_sc_hd__a21oi_1 A1 A2 B1 VGND VNB VPB VPWR Y
.ends

* Black-box entry subcircuit for sky130_fd_sc_hd__inv_6 abstract view
.subckt sky130_fd_sc_hd__inv_6 A VGND VNB VPB VPWR Y
.ends

* Black-box entry subcircuit for sky130_fd_sc_hd__dfxtp_2 abstract view
.subckt sky130_fd_sc_hd__dfxtp_2 CLK D VGND VNB VPB VPWR Q
.ends

* Black-box entry subcircuit for sky130_fd_sc_hd__clkinvlp_4 abstract view
.subckt sky130_fd_sc_hd__clkinvlp_4 A VGND VNB VPB VPWR Y
.ends

* Black-box entry subcircuit for sky130_sram_1kbyte_1rw1r_32x256_8 abstract view
.subckt sky130_sram_1kbyte_1rw1r_32x256_8 din0[0] din0[1] din0[2] din0[3] din0[4]
+ din0[5] din0[6] din0[7] din0[8] din0[9] din0[10] din0[11] din0[12] din0[13] din0[14]
+ din0[15] din0[16] din0[17] din0[18] din0[19] din0[20] din0[21] din0[22] din0[23]
+ din0[24] din0[25] din0[26] din0[27] din0[28] din0[29] din0[30] din0[31] addr0[0]
+ addr0[1] addr0[2] addr0[3] addr0[4] addr0[5] addr0[6] addr0[7] addr1[0] addr1[1]
+ addr1[2] addr1[3] addr1[4] addr1[5] addr1[6] addr1[7] csb0 csb1 web0 clk0 clk1 wmask0[0]
+ wmask0[1] wmask0[2] wmask0[3] dout0[0] dout0[1] dout0[2] dout0[3] dout0[4] dout0[5]
+ dout0[6] dout0[7] dout0[8] dout0[9] dout0[10] dout0[11] dout0[12] dout0[13] dout0[14]
+ dout0[15] dout0[16] dout0[17] dout0[18] dout0[19] dout0[20] dout0[21] dout0[22]
+ dout0[23] dout0[24] dout0[25] dout0[26] dout0[27] dout0[28] dout0[29] dout0[30]
+ dout0[31] dout1[0] dout1[1] dout1[2] dout1[3] dout1[4] dout1[5] dout1[6] dout1[7]
+ dout1[8] dout1[9] dout1[10] dout1[11] dout1[12] dout1[13] dout1[14] dout1[15] dout1[16]
+ dout1[17] dout1[18] dout1[19] dout1[20] dout1[21] dout1[22] dout1[23] dout1[24]
+ dout1[25] dout1[26] dout1[27] dout1[28] dout1[29] dout1[30] dout1[31] vccd1 vssd1
.ends

* Black-box entry subcircuit for sky130_fd_sc_hd__xor2_1 abstract view
.subckt sky130_fd_sc_hd__xor2_1 A B VGND VNB VPB VPWR X
.ends

* Black-box entry subcircuit for sky130_fd_sc_hd__inv_8 abstract view
.subckt sky130_fd_sc_hd__inv_8 A VGND VNB VPB VPWR Y
.ends

* Black-box entry subcircuit for sky130_fd_sc_hd__clkbuf_16 abstract view
.subckt sky130_fd_sc_hd__clkbuf_16 A VGND VNB VPB VPWR X
.ends

* Black-box entry subcircuit for sky130_fd_sc_hd__xor2_2 abstract view
.subckt sky130_fd_sc_hd__xor2_2 A B VGND VNB VPB VPWR X
.ends

* Black-box entry subcircuit for sky130_fd_sc_hd__or4_4 abstract view
.subckt sky130_fd_sc_hd__or4_4 A B C D VGND VNB VPB VPWR X
.ends

* Black-box entry subcircuit for sky130_fd_sc_hd__clkbuf_1 abstract view
.subckt sky130_fd_sc_hd__clkbuf_1 A VGND VNB VPB VPWR X
.ends

* Black-box entry subcircuit for sky130_fd_sc_hd__or2_2 abstract view
.subckt sky130_fd_sc_hd__or2_2 A B VGND VNB VPB VPWR X
.ends

* Black-box entry subcircuit for sky130_fd_sc_hd__buf_1 abstract view
.subckt sky130_fd_sc_hd__buf_1 A VGND VNB VPB VPWR X
.ends

* Black-box entry subcircuit for sky130_fd_sc_hd__o21ai_4 abstract view
.subckt sky130_fd_sc_hd__o21ai_4 A1 A2 B1 VGND VNB VPB VPWR Y
.ends

* Black-box entry subcircuit for sky130_fd_sc_hd__a21oi_2 abstract view
.subckt sky130_fd_sc_hd__a21oi_2 A1 A2 B1 VGND VNB VPB VPWR Y
.ends

* Black-box entry subcircuit for sky130_fd_sc_hd__a32o_1 abstract view
.subckt sky130_fd_sc_hd__a32o_1 A1 A2 A3 B1 B2 VGND VNB VPB VPWR X
.ends

* Black-box entry subcircuit for sky130_fd_sc_hd__o31a_1 abstract view
.subckt sky130_fd_sc_hd__o31a_1 A1 A2 A3 B1 VGND VNB VPB VPWR X
.ends

* Black-box entry subcircuit for sky130_fd_sc_hd__a22o_1 abstract view
.subckt sky130_fd_sc_hd__a22o_1 A1 A2 B1 B2 VGND VNB VPB VPWR X
.ends

* Black-box entry subcircuit for sky130_fd_sc_hd__or3_1 abstract view
.subckt sky130_fd_sc_hd__or3_1 A B C VGND VNB VPB VPWR X
.ends

* Black-box entry subcircuit for sky130_fd_sc_hd__o31ai_1 abstract view
.subckt sky130_fd_sc_hd__o31ai_1 A1 A2 A3 B1 VGND VNB VPB VPWR Y
.ends

* Black-box entry subcircuit for sky130_fd_sc_hd__a21boi_1 abstract view
.subckt sky130_fd_sc_hd__a21boi_1 A1 A2 B1_N VGND VNB VPB VPWR Y
.ends

* Black-box entry subcircuit for sky130_fd_sc_hd__conb_1 abstract view
.subckt sky130_fd_sc_hd__conb_1 VGND VNB VPB VPWR HI LO
.ends

* Black-box entry subcircuit for sky130_fd_sc_hd__nor3b_1 abstract view
.subckt sky130_fd_sc_hd__nor3b_1 A B C_N VGND VNB VPB VPWR Y
.ends

* Black-box entry subcircuit for sky130_fd_sc_hd__a22oi_2 abstract view
.subckt sky130_fd_sc_hd__a22oi_2 A1 A2 B1 B2 VGND VNB VPB VPWR Y
.ends

* Black-box entry subcircuit for sky130_fd_sc_hd__dlygate4sd3_1 abstract view
.subckt sky130_fd_sc_hd__dlygate4sd3_1 A VGND VNB VPB VPWR X
.ends

* Black-box entry subcircuit for sky130_fd_sc_hd__a31oi_2 abstract view
.subckt sky130_fd_sc_hd__a31oi_2 A1 A2 A3 B1 VGND VNB VPB VPWR Y
.ends

* Black-box entry subcircuit for sky130_fd_sc_hd__and4bb_1 abstract view
.subckt sky130_fd_sc_hd__and4bb_1 A_N B_N C D VGND VNB VPB VPWR X
.ends

* Black-box entry subcircuit for sky130_fd_sc_hd__dfxtp_4 abstract view
.subckt sky130_fd_sc_hd__dfxtp_4 CLK D VGND VNB VPB VPWR Q
.ends

* Black-box entry subcircuit for sky130_fd_sc_hd__and4_1 abstract view
.subckt sky130_fd_sc_hd__and4_1 A B C D VGND VNB VPB VPWR X
.ends

* Black-box entry subcircuit for sky130_fd_sc_hd__buf_4 abstract view
.subckt sky130_fd_sc_hd__buf_4 A VGND VNB VPB VPWR X
.ends

* Black-box entry subcircuit for sky130_fd_sc_hd__nor3_1 abstract view
.subckt sky130_fd_sc_hd__nor3_1 A B C VGND VNB VPB VPWR Y
.ends

* Black-box entry subcircuit for sky130_fd_sc_hd__dlymetal6s2s_1 abstract view
.subckt sky130_fd_sc_hd__dlymetal6s2s_1 A VGND VNB VPB VPWR X
.ends

* Black-box entry subcircuit for sky130_fd_sc_hd__a2bb2o_1 abstract view
.subckt sky130_fd_sc_hd__a2bb2o_1 A1_N A2_N B1 B2 VGND VNB VPB VPWR X
.ends

* Black-box entry subcircuit for sky130_fd_sc_hd__a31o_1 abstract view
.subckt sky130_fd_sc_hd__a31o_1 A1 A2 A3 B1 VGND VNB VPB VPWR X
.ends

* Black-box entry subcircuit for sky130_fd_sc_hd__mux2_4 abstract view
.subckt sky130_fd_sc_hd__mux2_4 A0 A1 S VGND VNB VPB VPWR X
.ends

.subckt mbist_top VGND VPWR bist_busy bist_done bist_fail bist_fail_addr[0] bist_fail_addr[1]
+ bist_fail_addr[2] bist_fail_addr[3] bist_fail_addr[4] bist_fail_addr[5] bist_fail_addr[6]
+ bist_fail_addr[7] bist_fail_bits[0] bist_fail_bits[10] bist_fail_bits[11] bist_fail_bits[12]
+ bist_fail_bits[13] bist_fail_bits[14] bist_fail_bits[15] bist_fail_bits[16] bist_fail_bits[17]
+ bist_fail_bits[18] bist_fail_bits[19] bist_fail_bits[1] bist_fail_bits[20] bist_fail_bits[21]
+ bist_fail_bits[22] bist_fail_bits[23] bist_fail_bits[24] bist_fail_bits[25] bist_fail_bits[26]
+ bist_fail_bits[27] bist_fail_bits[28] bist_fail_bits[29] bist_fail_bits[2] bist_fail_bits[30]
+ bist_fail_bits[31] bist_fail_bits[3] bist_fail_bits[4] bist_fail_bits[5] bist_fail_bits[6]
+ bist_fail_bits[7] bist_fail_bits[8] bist_fail_bits[9] bist_mode bist_start clk func_addr[0]
+ func_addr[1] func_addr[2] func_addr[3] func_addr[4] func_addr[5] func_addr[6] func_addr[7]
+ func_ce func_rdata[0] func_rdata[10] func_rdata[11] func_rdata[12] func_rdata[13]
+ func_rdata[14] func_rdata[15] func_rdata[16] func_rdata[17] func_rdata[18] func_rdata[19]
+ func_rdata[1] func_rdata[20] func_rdata[21] func_rdata[22] func_rdata[23] func_rdata[24]
+ func_rdata[25] func_rdata[26] func_rdata[27] func_rdata[28] func_rdata[29] func_rdata[2]
+ func_rdata[30] func_rdata[31] func_rdata[3] func_rdata[4] func_rdata[5] func_rdata[6]
+ func_rdata[7] func_rdata[8] func_rdata[9] func_wdata[0] func_wdata[10] func_wdata[11]
+ func_wdata[12] func_wdata[13] func_wdata[14] func_wdata[15] func_wdata[16] func_wdata[17]
+ func_wdata[18] func_wdata[19] func_wdata[1] func_wdata[20] func_wdata[21] func_wdata[22]
+ func_wdata[23] func_wdata[24] func_wdata[25] func_wdata[26] func_wdata[27] func_wdata[28]
+ func_wdata[29] func_wdata[2] func_wdata[30] func_wdata[31] func_wdata[3] func_wdata[4]
+ func_wdata[5] func_wdata[6] func_wdata[7] func_wdata[8] func_wdata[9] func_we rst_n
XTAP_TAPCELL_ROW_206_2611 VGND VPWR sky130_fd_sc_hd__tapvpwrvgnd_1
XTAP_TAPCELL_ROW_206_2600 VGND VPWR sky130_fd_sc_hd__tapvpwrvgnd_1
XFILLER_171_1393 VGND VGND VPWR VPWR sky130_fd_sc_hd__decap_6
XTAP_TAPCELL_ROW_206_2622 VGND VPWR sky130_fd_sc_hd__tapvpwrvgnd_1
XFILLER_215_529 VPWR VGND VPWR VGND sky130_ef_sc_hd__decap_12
XTAP_TAPCELL_ROW_202_2508 VGND VPWR sky130_fd_sc_hd__tapvpwrvgnd_1
XPHY_EDGE_ROW_103_2_Right_160 VGND VGND VPWR VPWR sky130_fd_sc_hd__decap_3
XFILLER_208_581 VGND VGND VPWR VPWR sky130_fd_sc_hd__decap_6
XPHY_EDGE_ROW_103_2_Left_535 VGND VGND VPWR VPWR sky130_fd_sc_hd__decap_3
XFILLER_196_937 VPWR VGND VPWR VGND sky130_ef_sc_hd__decap_12
XFILLER_165_1175 VGND VGND VPWR VPWR sky130_fd_sc_hd__fill_1
XFILLER_17_1410 VPWR VGND VPWR VGND sky130_ef_sc_hd__decap_12
XFILLER_52_29 VPWR VGND VPWR VGND sky130_ef_sc_hd__decap_12
XFILLER_210_245 VGND VGND VPWR VPWR sky130_fd_sc_hd__decap_6
XFILLER_195_447 VGND VGND VPWR VPWR sky130_fd_sc_hd__fill_1
XFILLER_168_29 VPWR VGND VPWR VGND sky130_ef_sc_hd__decap_12
XFILLER_167_105 VGND VGND VPWR VPWR sky130_fd_sc_hd__decap_6
XFILLER_143_1440 VGND VGND VPWR VPWR sky130_fd_sc_hd__fill_1
XANTENNA__338__A1 b_addr\[0\] VGND VGND VPWR VPWR sky130_fd_sc_hd__diode_2
XFILLER_56_1470 VPWR VGND VPWR VGND sky130_ef_sc_hd__decap_12
XFILLER_206_1161 VPWR VGND VPWR VGND sky130_ef_sc_hd__decap_12
XFILLER_183_609 VGND VGND VPWR VPWR sky130_fd_sc_hd__decap_6
XFILLER_167_149 VPWR VGND VPWR VGND sky130_ef_sc_hd__decap_12
XFILLER_108_1582 VPWR VGND VPWR VGND sky130_ef_sc_hd__decap_12
XFILLER_17_1454 VPWR VGND VPWR VGND sky130_ef_sc_hd__decap_12
XFILLER_52_1356 VGND VGND VPWR VPWR sky130_fd_sc_hd__fill_1
XFILLER_210_289 VPWR VGND VPWR VGND sky130_ef_sc_hd__decap_12
XFILLER_104_1468 VGND VGND VPWR VPWR sky130_fd_sc_hd__fill_1
XFILLER_17_1498 VPWR VGND VPWR VGND sky130_ef_sc_hd__decap_12
XFILLER_191_653 VPWR VGND VPWR VGND sky130_ef_sc_hd__decap_12
XFILLER_175_193 VPWR VGND VPWR VGND sky130_ef_sc_hd__decap_12
XFILLER_164_867 VGND VGND VPWR VPWR sky130_fd_sc_hd__fill_1
XFILLER_163_333 VGND VGND VPWR VPWR sky130_fd_sc_hd__decap_3
XFILLER_190_141 VPWR VGND VPWR VGND sky130_ef_sc_hd__decap_12
XFILLER_163_377 VPWR VGND VPWR VGND sky130_ef_sc_hd__decap_12
XFILLER_191_697 VPWR VGND VPWR VGND sky130_ef_sc_hd__decap_12
XFILLER_89_111 VGND VGND VPWR VPWR sky130_fd_sc_hd__fill_1
XPHY_EDGE_ROW_165_Right_10 VGND VGND VPWR VPWR sky130_fd_sc_hd__decap_3
XFILLER_137_1244 VPWR VGND VPWR VGND sky130_ef_sc_hd__decap_12
XTAP_TAPCELL_ROW_134_2_3847 VGND VPWR sky130_fd_sc_hd__tapvpwrvgnd_1
XFILLER_117_55 VGND VGND VPWR VPWR sky130_fd_sc_hd__fill_1
XFILLER_77_15 VPWR VGND VPWR VGND sky130_ef_sc_hd__decap_12
XFILLER_28_1550 VPWR VGND VPWR VGND sky130_ef_sc_hd__decap_12
XPHY_EDGE_ROW_61_1_Right_647 VGND VGND VPWR VPWR sky130_fd_sc_hd__decap_3
XFILLER_219_813 VPWR VGND VPWR VGND sky130_ef_sc_hd__decap_12
XFILLER_218_301 VGND VGND VPWR VPWR sky130_fd_sc_hd__decap_6
XFILLER_213_1121 VPWR VGND VPWR VGND sky130_ef_sc_hd__decap_12
XTAP_TAPCELL_ROW_164_1401 VGND VPWR sky130_fd_sc_hd__tapvpwrvgnd_1
XFILLER_154_1580 VGND VGND VPWR VPWR sky130_fd_sc_hd__fill_1
XFILLER_24_1414 VPWR VGND VPWR VGND sky130_ef_sc_hd__decap_12
XFILLER_28_1594 VGND VGND VPWR VPWR sky130_fd_sc_hd__decap_8
XFILLER_218_345 VPWR VGND VPWR VGND sky130_ef_sc_hd__decap_12
XTAP_TAPCELL_ROW_164_1423 VGND VPWR sky130_fd_sc_hd__tapvpwrvgnd_1
XTAP_TAPCELL_ROW_164_1412 VGND VPWR sky130_fd_sc_hd__tapvpwrvgnd_1
XFILLER_98_1526 VPWR VGND VPWR VGND sky130_ef_sc_hd__decap_12
XFILLER_63_1496 VGND VGND VPWR VPWR sky130_fd_sc_hd__fill_1
XANTENNA__610__CLK clknet_3_7_0_clk VGND VGND VPWR VPWR sky130_fd_sc_hd__diode_2
XFILLER_172_3 VPWR VGND VPWR VGND sky130_ef_sc_hd__decap_12
XTAP_TAPCELL_ROW_82_2_3512 VGND VPWR sky130_fd_sc_hd__tapvpwrvgnd_1
XPHY_EDGE_ROW_35_2_Left_467 VGND VGND VPWR VPWR sky130_fd_sc_hd__decap_3
XFILLER_218_389 VPWR VGND VPWR VGND sky130_ef_sc_hd__decap_12
XFILLER_93_69 VPWR VGND VPWR VGND sky130_ef_sc_hd__decap_12
X_501_ net171 net121 net135 _224_ VGND VGND VPWR VPWR _034_ sky130_fd_sc_hd__o211a_1
XFILLER_199_753 VPWR VGND VPWR VGND sky130_ef_sc_hd__decap_12
XFILLER_183_1231 VGND VGND VPWR VPWR sky130_fd_sc_hd__fill_1
XFILLER_96_1294 VGND VGND VPWR VPWR sky130_fd_sc_hd__decap_6
XFILLER_26_63 VGND VGND VPWR VPWR sky130_fd_sc_hd__decap_3
X_432_ _157_ _160_ _164_ VGND VGND VPWR VPWR _165_ sky130_fd_sc_hd__o21ai_1
XFILLER_202_713 VPWR VGND VPWR VGND sky130_ef_sc_hd__decap_12
XFILLER_26_85 VPWR VGND VPWR VGND sky130_ef_sc_hd__decap_12
XFILLER_57_1256 VPWR VGND VPWR VGND sky130_ef_sc_hd__decap_12
XFILLER_202_757 VPWR VGND VPWR VGND sky130_ef_sc_hd__decap_12
XFILLER_201_223 VGND VGND VPWR VPWR sky130_fd_sc_hd__fill_1
XFILLER_199_797 VPWR VGND VPWR VGND sky130_ef_sc_hd__decap_12
XFILLER_70_1412 VGND VGND VPWR VPWR sky130_fd_sc_hd__fill_1
X_363_ b_addr\[7\] b_addr\[6\] b_addr\[5\] b_addr\[4\] VGND VGND VPWR VPWR _106_ sky130_fd_sc_hd__or4_1
XFILLER_35_1510 VPWR VGND VPWR VGND sky130_ef_sc_hd__decap_12
XFILLER_186_469 VGND VGND VPWR VPWR sky130_fd_sc_hd__decap_6
XFILLER_122_1524 VGND VGND VPWR VPWR sky130_fd_sc_hd__fill_1
X_294_ net23 net141 net131 VGND VGND VPWR VPWR s_wdata\[1\] sky130_fd_sc_hd__a21o_1
XFILLER_35_1554 VPWR VGND VPWR VGND sky130_ef_sc_hd__decap_12
XFILLER_6_811 VGND VGND VPWR VPWR sky130_fd_sc_hd__fill_1
XFILLER_5_321 VGND VGND VPWR VPWR sky130_fd_sc_hd__decap_4
XFILLER_177_1057 VGND VGND VPWR VPWR sky130_fd_sc_hd__decap_6
XFILLER_120_1270 VPWR VGND VPWR VGND sky130_ef_sc_hd__decap_12
XFILLER_194_1371 VGND VGND VPWR VPWR sky130_fd_sc_hd__fill_1
XFILLER_170_837 VPWR VGND VPWR VGND sky130_ef_sc_hd__decap_12
XFILLER_155_1322 VGND VGND VPWR VPWR sky130_fd_sc_hd__decap_6
XFILLER_5_376 VGND VGND VPWR VPWR sky130_fd_sc_hd__decap_8
XTAP_TAPCELL_ROW_61_1_1140 VGND VPWR sky130_fd_sc_hd__tapvpwrvgnd_1
XFILLER_174_83 VGND VGND VPWR VPWR sky130_fd_sc_hd__fill_1
XPHY_EDGE_ROW_142_2_Right_199 VGND VGND VPWR VPWR sky130_fd_sc_hd__decap_3
XTAP_TAPCELL_ROW_23_2_3127 VGND VPWR sky130_fd_sc_hd__tapvpwrvgnd_1
XFILLER_155_1366 VPWR VGND VPWR VGND sky130_ef_sc_hd__decap_12
XFILLER_81_1552 VGND VGND VPWR VPWR sky130_fd_sc_hd__fill_1
XFILLER_95_125 VGND VGND VPWR VPWR sky130_fd_sc_hd__fill_2
XFILLER_7_1121 VPWR VGND VPWR VGND sky130_ef_sc_hd__decap_12
XFILLER_67_81 VPWR VGND VPWR VGND sky130_ef_sc_hd__decap_12
XFILLER_3_1007 VGND VGND VPWR VPWR sky130_fd_sc_hd__fill_1
XFILLER_184_1017 VPWR VGND VPWR VGND sky130_ef_sc_hd__decap_12
XFILLER_40_1282 VPWR VGND VPWR VGND sky130_ef_sc_hd__decap_12
XFILLER_188_1197 VGND VGND VPWR VPWR sky130_fd_sc_hd__decap_6
XFILLER_205_573 VPWR VGND VPWR VGND sky130_ef_sc_hd__decap_12
XFILLER_178_937 VPWR VGND VPWR VGND sky130_ef_sc_hd__decap_12
XFILLER_162_1326 VPWR VGND VPWR VGND sky130_ef_sc_hd__decap_12
XFILLER_149_105 VGND VGND VPWR VPWR sky130_fd_sc_hd__decap_6
XFILLER_75_1378 VGND VGND VPWR VPWR sky130_fd_sc_hd__decap_6
XFILLER_207_1481 VPWR VGND VPWR VGND sky130_ef_sc_hd__decap_12
XFILLER_203_1301 VPWR VGND VPWR VGND sky130_ef_sc_hd__decap_12
XFILLER_177_447 VGND VGND VPWR VPWR sky130_fd_sc_hd__fill_1
XFILLER_165_609 VGND VGND VPWR VPWR sky130_fd_sc_hd__decap_6
XFILLER_140_1602 VGND VGND VPWR VPWR sky130_fd_sc_hd__decap_3
XFILLER_203_1345 VPWR VGND VPWR VGND sky130_ef_sc_hd__decap_12
XFILLER_186_981 VPWR VGND VPWR VGND sky130_ef_sc_hd__decap_12
XFILLER_195_1113 VGND VGND VPWR VPWR sky130_fd_sc_hd__decap_6
XFILLER_195_1157 VPWR VGND VPWR VGND sky130_ef_sc_hd__decap_12
XFILLER_173_653 VPWR VGND VPWR VGND sky130_ef_sc_hd__decap_12
XFILLER_172_141 VPWR VGND VPWR VGND sky130_ef_sc_hd__decap_12
XFILLER_103_1490 VGND VGND VPWR VPWR sky130_fd_sc_hd__decap_6
XFILLER_218_65 VPWR VGND VPWR VGND sky130_ef_sc_hd__decap_12
XFILLER_173_697 VPWR VGND VPWR VGND sky130_ef_sc_hd__decap_12
XTAP_TAPCELL_ROW_120_2_3755 VGND VPWR sky130_fd_sc_hd__tapvpwrvgnd_1
XTAP_TAPCELL_ROW_119_2_3749 VGND VPWR sky130_fd_sc_hd__tapvpwrvgnd_1
XFILLER_173_1455 VGND VGND VPWR VPWR sky130_fd_sc_hd__fill_1
XFILLER_134_1406 VGND VGND VPWR VPWR sky130_fd_sc_hd__decap_6
XFILLER_82_1338 VPWR VGND VPWR VGND sky130_ef_sc_hd__decap_12
XANTENNA__633__CLK clknet_3_3_0_clk VGND VGND VPWR VPWR sky130_fd_sc_hd__diode_2
Xfanout127 net130 VGND VGND VPWR VPWR net127 sky130_fd_sc_hd__buf_2
Xfanout138 net139 VGND VGND VPWR VPWR net138 sky130_fd_sc_hd__clkbuf_4
XFILLER_219_109 VGND VGND VPWR VPWR sky130_fd_sc_hd__decap_3
XFILLER_214_1441 VPWR VGND VPWR VGND sky130_ef_sc_hd__decap_12
XTAP_TAPCELL_ROW_100_2_3631 VGND VPWR sky130_fd_sc_hd__tapvpwrvgnd_1
Xfanout149 net48 VGND VGND VPWR VPWR net149 sky130_fd_sc_hd__clkbuf_4
XFILLER_214_1485 VPWR VGND VPWR VGND sky130_ef_sc_hd__decap_12
XPHY_EDGE_ROW_20_1_Left_239 VGND VGND VPWR VPWR sky130_fd_sc_hd__decap_3
XFILLER_216_805 VGND VGND VPWR VPWR sky130_fd_sc_hd__decap_6
XTAP_TAPCELL_ROW_67_2_3414 VGND VPWR sky130_fd_sc_hd__tapvpwrvgnd_1
XTAP_TAPCELL_ROW_3_869 VGND VPWR sky130_fd_sc_hd__tapvpwrvgnd_1
XFILLER_216_849 VPWR VGND VPWR VGND sky130_ef_sc_hd__decap_12
XFILLER_215_337 VPWR VGND VPWR VGND sky130_ef_sc_hd__decap_12
XPHY_EDGE_ROW_145_1_Left_364 VGND VGND VPWR VPWR sky130_fd_sc_hd__decap_3
XFILLER_110_1450 VPWR VGND VPWR VGND sky130_ef_sc_hd__decap_12
XFILLER_103_57 VPWR VGND VPWR VGND sky130_ef_sc_hd__decap_12
XPHY_EDGE_ROW_104_2_Right_161 VGND VGND VPWR VPWR sky130_fd_sc_hd__decap_3
XFILLER_63_39 VPWR VGND VPWR VGND sky130_ef_sc_hd__decap_12
XFILLER_196_701 VPWR VGND VPWR VGND sky130_ef_sc_hd__decap_12
XFILLER_179_39 VPWR VGND VPWR VGND sky130_ef_sc_hd__decap_12
XFILLER_110_1494 VPWR VGND VPWR VGND sky130_ef_sc_hd__decap_12
XFILLER_93_1434 VGND VGND VPWR VPWR sky130_fd_sc_hd__decap_6
XFILLER_184_1595 VGND VGND VPWR VPWR sky130_fd_sc_hd__fill_1
XFILLER_145_1546 VGND VGND VPWR VPWR sky130_fd_sc_hd__decap_6
XFILLER_93_1478 VPWR VGND VPWR VGND sky130_ef_sc_hd__decap_12
XPHY_EDGE_ROW_82_1_Left_301 VGND VGND VPWR VPWR sky130_fd_sc_hd__decap_3
XTAP_TAPCELL_ROW_16_2_3081 VGND VPWR sky130_fd_sc_hd__tapvpwrvgnd_1
XFILLER_168_469 VGND VGND VPWR VPWR sky130_fd_sc_hd__decap_6
XFILLER_195_27 VPWR VGND VPWR VGND sky130_ef_sc_hd__decap_12
XFILLER_183_417 VPWR VGND VPWR VGND sky130_ef_sc_hd__decap_12
XFILLER_104_1232 VPWR VGND VPWR VGND sky130_ef_sc_hd__decap_12
XFILLER_192_973 VGND VGND VPWR VPWR sky130_fd_sc_hd__decap_6
XFILLER_191_461 VPWR VGND VPWR VGND sky130_ef_sc_hd__decap_12
XFILLER_163_141 VPWR VGND VPWR VGND sky130_ef_sc_hd__decap_12
XFILLER_30_1462 VGND VGND VPWR VPWR sky130_fd_sc_hd__decap_6
XFILLER_139_1328 VGND VGND VPWR VPWR sky130_fd_sc_hd__fill_1
XFILLER_128_65 VPWR VGND VPWR VGND sky130_ef_sc_hd__decap_12
XFILLER_121_1590 VPWR VGND VPWR VGND sky130_ef_sc_hd__decap_12
XFILLER_219_1341 VGND VGND VPWR VPWR sky130_fd_sc_hd__decap_3
XFILLER_191_1511 VGND VGND VPWR VPWR sky130_fd_sc_hd__fill_1
XANTENNA__495__B1 net135 VGND VGND VPWR VPWR sky130_fd_sc_hd__diode_2
XFILLER_219_1385 VPWR VGND VPWR VGND sky130_ef_sc_hd__decap_12
XFILLER_152_1506 VPWR VGND VPWR VGND sky130_ef_sc_hd__decap_12
XFILLER_144_53 VPWR VGND VPWR VGND sky130_ef_sc_hd__decap_12
XFILLER_77_125 VGND VGND VPWR VPWR sky130_fd_sc_hd__fill_2
XPHY_EDGE_ROW_62_1_Right_648 VGND VGND VPWR VPWR sky130_fd_sc_hd__decap_3
XFILLER_144_97 VPWR VGND VPWR VGND sky130_ef_sc_hd__decap_12
XFILLER_24_1244 VGND VGND VPWR VPWR sky130_fd_sc_hd__fill_1
XFILLER_218_153 VPWR VGND VPWR VGND sky130_ef_sc_hd__decap_12
XPHY_EDGE_ROW_77_1_Left_296 VGND VGND VPWR VPWR sky130_fd_sc_hd__decap_3
XFILLER_37_51 VGND VGND VPWR VPWR sky130_fd_sc_hd__decap_4
XFILLER_218_197 VPWR VGND VPWR VGND sky130_ef_sc_hd__decap_12
XFILLER_160_41 VPWR VGND VPWR VGND sky130_ef_sc_hd__decap_12
XTAP_TAPCELL_ROW_158_2_4007 VGND VPWR sky130_fd_sc_hd__tapvpwrvgnd_1
XFILLER_98_1356 VGND VGND VPWR VPWR sky130_fd_sc_hd__fill_1
XFILLER_209_1009 VPWR VGND VPWR VGND sky130_ef_sc_hd__decap_12
XFILLER_185_1337 VGND VGND VPWR VPWR sky130_fd_sc_hd__decap_6
XFILLER_160_85 VPWR VGND VPWR VGND sky130_ef_sc_hd__decap_12
XFILLER_2_1073 VPWR VGND VPWR VGND sky130_ef_sc_hd__decap_12
XFILLER_199_561 VPWR VGND VPWR VGND sky130_ef_sc_hd__decap_12
XFILLER_72_1518 VGND VGND VPWR VPWR sky130_fd_sc_hd__decap_6
X_415_ b_addr\[5\] _104_ VGND VGND VPWR VPWR _150_ sky130_fd_sc_hd__nor2_1
XFILLER_186_233 VPWR VGND VPWR VGND sky130_ef_sc_hd__decap_12
XFILLER_70_1220 VPWR VGND VPWR VGND sky130_ef_sc_hd__decap_12
X_346_ u_ctrl.cmp_addr\[4\] b_addr\[4\] net154 VGND VGND VPWR VPWR _094_ sky130_fd_sc_hd__mux2_1
XFILLER_202_587 VGND VGND VPWR VPWR sky130_fd_sc_hd__fill_1
XFILLER_186_277 VPWR VGND VPWR VGND sky130_ef_sc_hd__decap_12
XFILLER_168_981 VPWR VGND VPWR VGND sky130_ef_sc_hd__decap_12
XFILLER_35_1384 VGND VGND VPWR VPWR sky130_fd_sc_hd__fill_1
XFILLER_183_951 VGND VGND VPWR VPWR sky130_fd_sc_hd__fill_1
XFILLER_179_1119 VGND VGND VPWR VPWR sky130_fd_sc_hd__fill_1
X_277_ net47 u_ctrl.state\[0\] VGND VGND VPWR VPWR _075_ sky130_fd_sc_hd__nor2_1
XFILLER_170_601 VPWR VGND VPWR VGND sky130_ef_sc_hd__decap_12
XFILLER_196_1477 VGND VGND VPWR VPWR sky130_fd_sc_hd__decap_6
XFILLER_185_93 VPWR VGND VPWR VGND sky130_ef_sc_hd__decap_12
XTAP_TAPCELL_ROW_92_1_1201 VGND VPWR sky130_fd_sc_hd__tapvpwrvgnd_1
XFILLER_170_645 VPWR VGND VPWR VGND sky130_ef_sc_hd__decap_12
XFILLER_42_1300 VGND VGND VPWR VPWR sky130_fd_sc_hd__fill_1
XTAP_TAPCELL_ROW_53_2_3322 VGND VPWR sky130_fd_sc_hd__tapvpwrvgnd_1
XTAP_TAPCELL_ROW_0_806 VGND VPWR sky130_fd_sc_hd__tapvpwrvgnd_1
XFILLER_212_307 VGND VGND VPWR VPWR sky130_fd_sc_hd__fill_1
XFILLER_206_893 VPWR VGND VPWR VGND sky130_ef_sc_hd__decap_12
XFILLER_178_701 VPWR VGND VPWR VGND sky130_ef_sc_hd__decap_12
XFILLER_127_1232 VPWR VGND VPWR VGND sky130_ef_sc_hd__decap_12
XPHY_EDGE_ROW_24_1_Right_610 VGND VGND VPWR VPWR sky130_fd_sc_hd__decap_3
XFILLER_53_1440 VGND VGND VPWR VPWR sky130_fd_sc_hd__fill_1
XFILLER_165_417 VPWR VGND VPWR VGND sky130_ef_sc_hd__decap_12
XFILLER_127_1298 VPWR VGND VPWR VGND sky130_ef_sc_hd__decap_12
XFILLER_18_1582 VPWR VGND VPWR VGND sky130_ef_sc_hd__decap_12
XFILLER_203_1175 VGND VGND VPWR VPWR sky130_fd_sc_hd__fill_1
XFILLER_105_1552 VGND VGND VPWR VPWR sky130_fd_sc_hd__fill_1
XFILLER_174_973 VGND VGND VPWR VPWR sky130_fd_sc_hd__decap_6
XFILLER_173_461 VPWR VGND VPWR VGND sky130_ef_sc_hd__decap_12
XFILLER_14_1468 VGND VGND VPWR VPWR sky130_fd_sc_hd__fill_1
XTAP_TAPCELL_ROW_150_2_3950 VGND VPWR sky130_fd_sc_hd__tapvpwrvgnd_1
XFILLER_138_1350 VGND VGND VPWR VPWR sky130_fd_sc_hd__decap_6
XFILLER_86_1282 VPWR VGND VPWR VGND sky130_ef_sc_hd__decap_12
XFILLER_0_817 VGND VGND VPWR VPWR sky130_fd_sc_hd__fill_2
XFILLER_47_1244 VPWR VGND VPWR VGND sky130_ef_sc_hd__decap_12
XTAP_TAPCELL_ROW_149_2_3944 VGND VPWR sky130_fd_sc_hd__tapvpwrvgnd_1
XFILLER_138_1394 VPWR VGND VPWR VGND sky130_ef_sc_hd__decap_12
XFILLER_59_125 VGND VGND VPWR VPWR sky130_fd_sc_hd__fill_2
XFILLER_134_1258 VPWR VGND VPWR VGND sky130_ef_sc_hd__decap_12
XFILLER_64_1580 VGND VGND VPWR VPWR sky130_fd_sc_hd__fill_1
XTAP_TAPCELL_ROW_118_1_1254 VGND VPWR sky130_fd_sc_hd__tapvpwrvgnd_1
XFILLER_216_613 VPWR VGND VPWR VGND sky130_ef_sc_hd__decap_12
XFILLER_167_1001 VGND VGND VPWR VPWR sky130_fd_sc_hd__decap_6
XFILLER_74_27 VGND VGND VPWR VPWR sky130_fd_sc_hd__fill_1
XFILLER_216_657 VPWR VGND VPWR VGND sky130_ef_sc_hd__decap_12
XFILLER_167_1045 VPWR VGND VPWR VGND sky130_ef_sc_hd__decap_12
XFILLER_215_167 VGND VGND VPWR VPWR sky130_fd_sc_hd__fill_1
XFILLER_203_329 VGND VGND VPWR VPWR sky130_fd_sc_hd__decap_6
XPHY_EDGE_ROW_105_2_Right_162 VGND VGND VPWR VPWR sky130_fd_sc_hd__decap_3
XFILLER_93_1220 VPWR VGND VPWR VGND sky130_ef_sc_hd__decap_12
XFILLER_3_1393 VGND VGND VPWR VPWR sky130_fd_sc_hd__decap_6
XFILLER_167_1089 VPWR VGND VPWR VGND sky130_ef_sc_hd__decap_12
XFILLER_149_1490 VGND VGND VPWR VPWR sky130_fd_sc_hd__decap_6
XFILLER_145_1310 VPWR VGND VPWR VGND sky130_ef_sc_hd__decap_12
XFILLER_130_77 VGND VGND VPWR VPWR sky130_fd_sc_hd__decap_6
XFILLER_90_15 VPWR VGND VPWR VGND sky130_ef_sc_hd__decap_12
XFILLER_196_531 VGND VGND VPWR VPWR sky130_fd_sc_hd__fill_1
XFILLER_168_233 VPWR VGND VPWR VGND sky130_ef_sc_hd__decap_12
XFILLER_145_1354 VPWR VGND VPWR VGND sky130_ef_sc_hd__decap_12
XFILLER_93_1286 VPWR VGND VPWR VGND sky130_ef_sc_hd__decap_12
XFILLER_211_373 VPWR VGND VPWR VGND sky130_ef_sc_hd__decap_12
XFILLER_184_737 VPWR VGND VPWR VGND sky130_ef_sc_hd__decap_12
XFILLER_168_277 VPWR VGND VPWR VGND sky130_ef_sc_hd__decap_12
XFILLER_145_1398 VPWR VGND VPWR VGND sky130_ef_sc_hd__decap_12
XFILLER_135_3 VPWR VGND VPWR VGND sky130_ef_sc_hd__decap_12
XFILLER_106_1338 VPWR VGND VPWR VGND sky130_ef_sc_hd__decap_12
XFILLER_7_405 VPWR VGND VPWR VGND sky130_ef_sc_hd__decap_12
XFILLER_23_31 VGND VGND VPWR VPWR sky130_fd_sc_hd__fill_1
XFILLER_183_225 VPWR VGND VPWR VGND sky130_ef_sc_hd__decap_12
XFILLER_7_449 VPWR VGND VPWR VGND sky130_ef_sc_hd__decap_12
XFILLER_32_1524 VGND VGND VPWR VPWR sky130_fd_sc_hd__fill_1
XFILLER_178_1141 VGND VGND VPWR VPWR sky130_fd_sc_hd__decap_6
XFILLER_165_951 VGND VGND VPWR VPWR sky130_fd_sc_hd__fill_1
XFILLER_192_781 VPWR VGND VPWR VGND sky130_ef_sc_hd__decap_12
XFILLER_174_1005 VPWR VGND VPWR VGND sky130_ef_sc_hd__decap_12
XFILLER_151_111 VGND VGND VPWR VPWR sky130_fd_sc_hd__fill_1
XFILLER_99_57 VPWR VGND VPWR VGND sky130_ef_sc_hd__decap_12
XFILLER_3_611 VGND VGND VPWR VPWR sky130_fd_sc_hd__decap_4
XFILLER_30_1270 VPWR VGND VPWR VGND sky130_ef_sc_hd__decap_12
XFILLER_178_1185 VPWR VGND VPWR VGND sky130_ef_sc_hd__decap_12
XFILLER_65_1322 VGND VGND VPWR VPWR sky130_fd_sc_hd__decap_6
XFILLER_174_1049 VPWR VGND VPWR VGND sky130_ef_sc_hd__decap_12
XFILLER_156_1450 VPWR VGND VPWR VGND sky130_ef_sc_hd__decap_12
XFILLER_156_1494 VPWR VGND VPWR VGND sky130_ef_sc_hd__decap_12
XFILLER_152_1314 VPWR VGND VPWR VGND sky130_ef_sc_hd__decap_12
XFILLER_117_1434 VGND VGND VPWR VPWR sky130_fd_sc_hd__decap_6
XFILLER_65_1366 VPWR VGND VPWR VGND sky130_ef_sc_hd__decap_12
XTAP_TAPCELL_ROW_38_2_3224 VGND VPWR sky130_fd_sc_hd__tapvpwrvgnd_1
XFILLER_215_1057 VGND VGND VPWR VPWR sky130_fd_sc_hd__decap_6
XFILLER_152_1358 VPWR VGND VPWR VGND sky130_ef_sc_hd__decap_12
XFILLER_117_1478 VPWR VGND VPWR VGND sky130_ef_sc_hd__decap_12
XTAP_TAPCELL_ROW_7_983 VGND VPWR sky130_fd_sc_hd__tapvpwrvgnd_1
XTAP_TAPCELL_ROW_7_994 VGND VPWR sky130_fd_sc_hd__tapvpwrvgnd_1
XFILLER_171_51 VGND VGND VPWR VPWR sky130_fd_sc_hd__decap_4
XPHY_EDGE_ROW_63_1_Right_649 VGND VGND VPWR VPWR sky130_fd_sc_hd__decap_3
XFILLER_8_1282 VPWR VGND VPWR VGND sky130_ef_sc_hd__decap_12
XFILLER_219_473 VGND VGND VPWR VPWR sky130_fd_sc_hd__decap_3
XFILLER_185_1101 VPWR VGND VPWR VGND sky130_ef_sc_hd__decap_12
XFILLER_189_1281 VGND VGND VPWR VPWR sky130_fd_sc_hd__decap_6
XFILLER_80_109 VPWR VGND VPWR VGND sky130_ef_sc_hd__decap_12
XFILLER_0_57 VGND VGND VPWR VPWR sky130_fd_sc_hd__decap_4
XFILLER_185_1145 VPWR VGND VPWR VGND sky130_ef_sc_hd__decap_12
XFILLER_181_1009 VPWR VGND VPWR VGND sky130_ef_sc_hd__decap_12
XFILLER_206_189 VGND VGND VPWR VPWR sky130_fd_sc_hd__decap_6
XFILLER_203_841 VPWR VGND VPWR VGND sky130_ef_sc_hd__decap_12
XFILLER_185_1189 VPWR VGND VPWR VGND sky130_ef_sc_hd__decap_12
XFILLER_76_1462 VGND VGND VPWR VPWR sky130_fd_sc_hd__decap_6
XFILLER_199_391 VGND VGND VPWR VPWR sky130_fd_sc_hd__fill_1
XFILLER_187_553 VGND VGND VPWR VPWR sky130_fd_sc_hd__decap_6
XFILLER_128_1574 VGND VGND VPWR VPWR sky130_fd_sc_hd__decap_6
XFILLER_72_1326 VPWR VGND VPWR VGND sky130_ef_sc_hd__decap_12
XFILLER_124_1438 VPWR VGND VPWR VGND sky130_ef_sc_hd__decap_12
XFILLER_9_55 VGND VGND VPWR VPWR sky130_fd_sc_hd__fill_1
XFILLER_9_88 VGND VGND VPWR VPWR sky130_fd_sc_hd__decap_8
XFILLER_50_1602 VGND VGND VPWR VPWR sky130_fd_sc_hd__decap_3
XFILLER_198_1539 VGND VGND VPWR VPWR sky130_fd_sc_hd__fill_1
XFILLER_187_597 VPWR VGND VPWR VGND sky130_ef_sc_hd__decap_12
X_329_ b_addr\[4\] net7 net140 VGND VGND VPWR VPWR s_addr\[4\] sky130_fd_sc_hd__mux2_1
XFILLER_200_1315 VGND VGND VPWR VPWR sky130_fd_sc_hd__fill_1
XTAP_TAPCELL_ROW_155_2_3987 VGND VPWR sky130_fd_sc_hd__tapvpwrvgnd_1
XFILLER_196_1241 VPWR VGND VPWR VGND sky130_ef_sc_hd__decap_12
XFILLER_171_921 VPWR VGND VPWR VGND sky130_ef_sc_hd__decap_12
XFILLER_13_1490 VGND VGND VPWR VPWR sky130_fd_sc_hd__decap_6
XFILLER_196_1285 VPWR VGND VPWR VGND sky130_ef_sc_hd__decap_12
XFILLER_192_1105 VPWR VGND VPWR VGND sky130_ef_sc_hd__decap_12
XFILLER_171_965 VPWR VGND VPWR VGND sky130_ef_sc_hd__decap_12
XPHY_EDGE_ROW_112_2_Left_544 VGND VGND VPWR VPWR sky130_fd_sc_hd__decap_3
Xclkbuf_3_1_0_clk clknet_0_clk VGND VGND VPWR VPWR clknet_3_1_0_clk sky130_fd_sc_hd__clkbuf_8
XFILLER_192_1149 VPWR VGND VPWR VGND sky130_ef_sc_hd__decap_12
XFILLER_170_475 VGND VGND VPWR VPWR sky130_fd_sc_hd__fill_1
XFILLER_100_1482 VPWR VGND VPWR VGND sky130_ef_sc_hd__decap_12
XFILLER_83_1422 VPWR VGND VPWR VGND sky130_ef_sc_hd__decap_12
XFILLER_135_1534 VPWR VGND VPWR VGND sky130_ef_sc_hd__decap_12
XFILLER_83_1466 VPWR VGND VPWR VGND sky130_ef_sc_hd__decap_12
XFILLER_44_1406 VGND VGND VPWR VPWR sky130_fd_sc_hd__decap_6
XFILLER_215_55 VGND VGND VPWR VPWR sky130_fd_sc_hd__fill_1
XFILLER_135_1578 VPWR VGND VPWR VGND sky130_ef_sc_hd__decap_12
XFILLER_211_1455 VGND VGND VPWR VPWR sky130_fd_sc_hd__fill_1
XFILLER_20_1450 VPWR VGND VPWR VGND sky130_ef_sc_hd__decap_12
XPHY_EDGE_ROW_190_Left_409 VGND VGND VPWR VPWR sky130_fd_sc_hd__decap_3
XFILLER_168_1365 VGND VGND VPWR VPWR sky130_fd_sc_hd__decap_6
XFILLER_197_317 VPWR VGND VPWR VGND sky130_ef_sc_hd__decap_12
XFILLER_164_1229 VPWR VGND VPWR VGND sky130_ef_sc_hd__decap_12
XFILLER_94_1562 VPWR VGND VPWR VGND sky130_ef_sc_hd__decap_12
XFILLER_20_1494 VPWR VGND VPWR VGND sky130_ef_sc_hd__decap_12
XFILLER_178_531 VGND VGND VPWR VPWR sky130_fd_sc_hd__fill_1
XFILLER_90_1426 VPWR VGND VPWR VGND sky130_ef_sc_hd__decap_12
XPHY_EDGE_ROW_25_1_Right_611 VGND VGND VPWR VPWR sky130_fd_sc_hd__decap_3
XFILLER_55_1546 VGND VGND VPWR VPWR sky130_fd_sc_hd__decap_6
XTAP_TAPCELL_ROW_195_2289 VGND VPWR sky130_fd_sc_hd__tapvpwrvgnd_1
XFILLER_142_1538 VPWR VGND VPWR VGND sky130_ef_sc_hd__decap_12
XFILLER_176_29 VPWR VGND VPWR VGND sky130_ef_sc_hd__decap_12
XFILLER_166_737 VPWR VGND VPWR VGND sky130_ef_sc_hd__decap_12
XFILLER_165_225 VPWR VGND VPWR VGND sky130_ef_sc_hd__decap_12
XFILLER_14_1232 VPWR VGND VPWR VGND sky130_ef_sc_hd__decap_12
XFILLER_60_29 VPWR VGND VPWR VGND sky130_ef_sc_hd__decap_12
XFILLER_181_729 VPWR VGND VPWR VGND sky130_ef_sc_hd__decap_12
XFILLER_88_1300 VGND VGND VPWR VPWR sky130_fd_sc_hd__fill_1
XFILLER_5_909 VPWR VGND VPWR VGND sky130_ef_sc_hd__decap_12
XTAP_TAPCELL_ROW_44_2_3267 VGND VPWR sky130_fd_sc_hd__tapvpwrvgnd_1
XFILLER_174_781 VPWR VGND VPWR VGND sky130_ef_sc_hd__decap_12
XFILLER_4_408 VGND VGND VPWR VPWR sky130_fd_sc_hd__decap_8
XPHY_EDGE_ROW_44_2_Left_476 VGND VGND VPWR VPWR sky130_fd_sc_hd__decap_3
XFILLER_175_1325 VPWR VGND VPWR VGND sky130_ef_sc_hd__decap_12
XFILLER_133_111 VGND VGND VPWR VPWR sky130_fd_sc_hd__fill_1
XFILLER_101_1268 VGND VGND VPWR VPWR sky130_fd_sc_hd__decap_4
XFILLER_69_27 VPWR VGND VPWR VGND sky130_ef_sc_hd__decap_12
XFILLER_31_1590 VPWR VGND VPWR VGND sky130_ef_sc_hd__decap_12
XFILLER_49_1328 VGND VGND VPWR VPWR sky130_fd_sc_hd__fill_1
XFILLER_175_1369 VPWR VGND VPWR VGND sky130_ef_sc_hd__decap_12
XTAP_TAPCELL_ROW_24_2_3132 VGND VPWR sky130_fd_sc_hd__tapvpwrvgnd_1
XFILLER_62_1506 VPWR VGND VPWR VGND sky130_ef_sc_hd__decap_12
XFILLER_125_55 VGND VGND VPWR VPWR sky130_fd_sc_hd__fill_1
XFILLER_85_15 VPWR VGND VPWR VGND sky130_ef_sc_hd__decap_12
XFILLER_0_669 VGND VGND VPWR VPWR sky130_fd_sc_hd__fill_1
XTAP_TAPCELL_ROW_149_1_1315 VGND VPWR sky130_fd_sc_hd__tapvpwrvgnd_1
XTAP_TAPCELL_ROW_4_920 VGND VPWR sky130_fd_sc_hd__tapvpwrvgnd_1
XFILLER_217_933 VPWR VGND VPWR VGND sky130_ef_sc_hd__decap_12
XTAP_TAPCELL_ROW_184_1993 VGND VPWR sky130_fd_sc_hd__tapvpwrvgnd_1
XTAP_TAPCELL_ROW_184_1982 VGND VPWR sky130_fd_sc_hd__tapvpwrvgnd_1
XTAP_TAPCELL_ROW_184_1971 VGND VPWR sky130_fd_sc_hd__tapvpwrvgnd_1
XFILLER_99_1440 VGND VGND VPWR VPWR sky130_fd_sc_hd__fill_1
XFILLER_5_1455 VGND VGND VPWR VPWR sky130_fd_sc_hd__fill_1
XFILLER_18_53 VPWR VGND VPWR VGND sky130_ef_sc_hd__decap_12
XTAP_TAPCELL_ROW_54_1_1126 VGND VPWR sky130_fd_sc_hd__tapvpwrvgnd_1
XFILLER_217_977 VPWR VGND VPWR VGND sky130_ef_sc_hd__decap_12
XFILLER_216_421 VPWR VGND VPWR VGND sky130_ef_sc_hd__decap_12
XFILLER_186_1421 VGND VGND VPWR VPWR sky130_fd_sc_hd__decap_6
XTAP_TAPCELL_ROW_180_1857 VGND VPWR sky130_fd_sc_hd__tapvpwrvgnd_1
XFILLER_62_109 VPWR VGND VPWR VGND sky130_ef_sc_hd__decap_12
XFILLER_186_1465 VPWR VGND VPWR VGND sky130_ef_sc_hd__decap_12
XTAP_TAPCELL_ROW_180_1879 VGND VPWR sky130_fd_sc_hd__tapvpwrvgnd_1
XTAP_TAPCELL_ROW_180_1868 VGND VPWR sky130_fd_sc_hd__tapvpwrvgnd_1
XFILLER_18_97 VGND VGND VPWR VPWR sky130_fd_sc_hd__decap_8
XFILLER_203_137 VPWR VGND VPWR VGND sky130_ef_sc_hd__decap_12
XFILLER_182_1329 VPWR VGND VPWR VGND sky130_ef_sc_hd__decap_12
XFILLER_73_1602 VGND VGND VPWR VPWR sky130_fd_sc_hd__decap_3
XPHY_EDGE_ROW_108_1_Left_327 VGND VGND VPWR VPWR sky130_fd_sc_hd__decap_3
XPHY_EDGE_ROW_106_2_Right_163 VGND VGND VPWR VPWR sky130_fd_sc_hd__decap_3
XFILLER_34_41 VPWR VGND VPWR VGND sky130_ef_sc_hd__decap_12
XFILLER_212_693 VGND VGND VPWR VPWR sky130_fd_sc_hd__decap_6
XFILLER_200_811 VGND VGND VPWR VPWR sky130_fd_sc_hd__fill_1
XFILLER_197_895 VGND VGND VPWR VPWR sky130_fd_sc_hd__fill_1
XFILLER_184_501 VPWR VGND VPWR VGND sky130_ef_sc_hd__decap_12
XFILLER_169_553 VGND VGND VPWR VPWR sky130_fd_sc_hd__decap_6
XFILLER_34_85 VPWR VGND VPWR VGND sky130_ef_sc_hd__decap_12
XFILLER_211_181 VPWR VGND VPWR VGND sky130_ef_sc_hd__decap_12
XFILLER_184_545 VPWR VGND VPWR VGND sky130_ef_sc_hd__decap_12
XFILLER_169_597 VPWR VGND VPWR VGND sky130_ef_sc_hd__decap_12
XTAP_TAPCELL_ROW_141_2_3895 VGND VPWR sky130_fd_sc_hd__tapvpwrvgnd_1
XFILLER_197_1561 VGND VGND VPWR VPWR sky130_fd_sc_hd__decap_6
XFILLER_184_589 VPWR VGND VPWR VGND sky130_ef_sc_hd__decap_12
XFILLER_171_217 VGND VGND VPWR VPWR sky130_fd_sc_hd__decap_6
XFILLER_193_1425 VPWR VGND VPWR VGND sky130_ef_sc_hd__decap_12
XFILLER_217_1119 VGND VGND VPWR VPWR sky130_fd_sc_hd__fill_1
XFILLER_193_1469 VPWR VGND VPWR VGND sky130_ef_sc_hd__decap_12
XFILLER_117_1220 VPWR VGND VPWR VGND sky130_ef_sc_hd__decap_12
XFILLER_59_93 VPWR VGND VPWR VGND sky130_ef_sc_hd__decap_12
XFILLER_182_83 VGND VGND VPWR VPWR sky130_fd_sc_hd__fill_1
XFILLER_117_1286 VPWR VGND VPWR VGND sky130_ef_sc_hd__decap_12
XANTENNA__548__S net122 VGND VGND VPWR VPWR sky130_fd_sc_hd__diode_2
XFILLER_219_281 VPWR VGND VPWR VGND sky130_ef_sc_hd__decap_12
XFILLER_78_1524 VGND VGND VPWR VPWR sky130_fd_sc_hd__fill_1
XFILLER_75_81 VPWR VGND VPWR VGND sky130_ef_sc_hd__decap_12
XFILLER_165_1505 VGND VGND VPWR VPWR sky130_fd_sc_hd__decap_6
XFILLER_179_317 VPWR VGND VPWR VGND sky130_ef_sc_hd__decap_12
XFILLER_165_1549 VPWR VGND VPWR VGND sky130_ef_sc_hd__decap_12
XFILLER_201_57 VPWR VGND VPWR VGND sky130_ef_sc_hd__decap_12
XFILLER_98_3 VPWR VGND VPWR VGND sky130_ef_sc_hd__decap_12
XFILLER_76_1270 VPWR VGND VPWR VGND sky130_ef_sc_hd__decap_12
XFILLER_37_1232 VPWR VGND VPWR VGND sky130_ef_sc_hd__decap_12
XFILLER_203_671 VGND VGND VPWR VPWR sky130_fd_sc_hd__fill_1
XFILLER_194_309 VPWR VGND VPWR VGND sky130_ef_sc_hd__decap_12
XFILLER_187_361 VPWR VGND VPWR VGND sky130_ef_sc_hd__decap_12
XFILLER_163_1273 VPWR VGND VPWR VGND sky130_ef_sc_hd__decap_12
XFILLER_128_1382 VPWR VGND VPWR VGND sky130_ef_sc_hd__decap_12
XFILLER_124_1246 VPWR VGND VPWR VGND sky130_ef_sc_hd__decap_12
XTAP_TAPCELL_ROW_30_2_3175 VGND VPWR sky130_fd_sc_hd__tapvpwrvgnd_1
XFILLER_37_1298 VPWR VGND VPWR VGND sky130_ef_sc_hd__decap_12
XTAP_TAPCELL_ROW_190_2164 VGND VPWR sky130_fd_sc_hd__tapvpwrvgnd_1
XTAP_TAPCELL_ROW_190_2153 VGND VPWR sky130_fd_sc_hd__tapvpwrvgnd_1
XTAP_TAPCELL_ROW_190_2142 VGND VPWR sky130_fd_sc_hd__tapvpwrvgnd_1
XFILLER_15_1552 VGND VGND VPWR VPWR sky130_fd_sc_hd__fill_1
XTAP_TAPCELL_ROW_29_2_3169 VGND VPWR sky130_fd_sc_hd__tapvpwrvgnd_1
XTAP_TAPCELL_ROW_215_2871 VGND VPWR sky130_fd_sc_hd__tapvpwrvgnd_1
XTAP_TAPCELL_ROW_215_2860 VGND VPWR sky130_fd_sc_hd__tapvpwrvgnd_1
XFILLER_163_729 VPWR VGND VPWR VGND sky130_ef_sc_hd__decap_12
XTAP_TAPCELL_ROW_211_2746 VGND VPWR sky130_fd_sc_hd__tapvpwrvgnd_1
XFILLER_115_111 VGND VGND VPWR VPWR sky130_fd_sc_hd__fill_1
XTAP_TAPCELL_ROW_10_2_3040 VGND VPWR sky130_fd_sc_hd__tapvpwrvgnd_1
XTAP_TAPCELL_ROW_211_2757 VGND VPWR sky130_fd_sc_hd__tapvpwrvgnd_1
XFILLER_196_1093 VPWR VGND VPWR VGND sky130_ef_sc_hd__decap_12
XFILLER_172_1509 VPWR VGND VPWR VGND sky130_ef_sc_hd__decap_12
XPHY_EDGE_ROW_154_1_Left_373 VGND VGND VPWR VPWR sky130_fd_sc_hd__decap_3
XFILLER_48_1350 VGND VGND VPWR VPWR sky130_fd_sc_hd__decap_6
XTAP_TAPCELL_ROW_188_2093 VGND VPWR sky130_fd_sc_hd__tapvpwrvgnd_1
XFILLER_135_1342 VPWR VGND VPWR VGND sky130_ef_sc_hd__decap_12
XFILLER_83_1274 VPWR VGND VPWR VGND sky130_ef_sc_hd__decap_12
XFILLER_48_1394 VPWR VGND VPWR VGND sky130_ef_sc_hd__decap_12
XFILLER_135_1386 VPWR VGND VPWR VGND sky130_ef_sc_hd__decap_12
XPHY_EDGE_ROW_91_1_Left_310 VGND VGND VPWR VPWR sky130_fd_sc_hd__decap_3
XFILLER_44_1258 VPWR VGND VPWR VGND sky130_ef_sc_hd__decap_12
XTAP_TAPCELL_ROW_209_2697 VGND VPWR sky130_fd_sc_hd__tapvpwrvgnd_1
XTAP_TAPCELL_ROW_209_2686 VGND VPWR sky130_fd_sc_hd__tapvpwrvgnd_1
XTAP_TAPCELL_ROW_159_2_4012 VGND VPWR sky130_fd_sc_hd__tapvpwrvgnd_1
XFILLER_96_1602 VGND VGND VPWR VPWR sky130_fd_sc_hd__decap_3
XFILLER_44_109 VPWR VGND VPWR VGND sky130_ef_sc_hd__decap_12
XFILLER_214_925 VPWR VGND VPWR VGND sky130_ef_sc_hd__decap_12
XFILLER_198_637 VGND VGND VPWR VPWR sky130_fd_sc_hd__decap_6
XFILLER_168_1173 VPWR VGND VPWR VGND sky130_ef_sc_hd__decap_12
XFILLER_0_1341 VGND VGND VPWR VPWR sky130_fd_sc_hd__decap_3
XFILLER_205_1001 VGND VGND VPWR VPWR sky130_fd_sc_hd__decap_6
XFILLER_197_125 VPWR VGND VPWR VGND sky130_ef_sc_hd__decap_12
XFILLER_164_1037 VPWR VGND VPWR VGND sky130_ef_sc_hd__decap_12
XFILLER_111_57 VPWR VGND VPWR VGND sky130_ef_sc_hd__decap_12
XFILLER_94_1370 VPWR VGND VPWR VGND sky130_ef_sc_hd__decap_12
XFILLER_0_1385 VPWR VGND VPWR VGND sky130_ef_sc_hd__decap_12
XFILLER_55_1310 VPWR VGND VPWR VGND sky130_ef_sc_hd__decap_12
XFILLER_59_1490 VGND VGND VPWR VPWR sky130_fd_sc_hd__decap_6
XFILLER_197_169 VPWR VGND VPWR VGND sky130_ef_sc_hd__decap_12
XFILLER_166_501 VPWR VGND VPWR VGND sky130_ef_sc_hd__decap_12
XFILLER_146_1482 VPWR VGND VPWR VGND sky130_ef_sc_hd__decap_12
XFILLER_142_1302 VPWR VGND VPWR VGND sky130_ef_sc_hd__decap_12
XTAP_TAPCELL_ROW_126_2_3797 VGND VPWR sky130_fd_sc_hd__tapvpwrvgnd_1
XFILLER_107_1422 VPWR VGND VPWR VGND sky130_ef_sc_hd__decap_12
XFILLER_71_39 VPWR VGND VPWR VGND sky130_ef_sc_hd__decap_12
XFILLER_55_1354 VPWR VGND VPWR VGND sky130_ef_sc_hd__decap_12
XFILLER_205_1045 VPWR VGND VPWR VGND sky130_ef_sc_hd__decap_12
XFILLER_187_39 VPWR VGND VPWR VGND sky130_ef_sc_hd__decap_12
XFILLER_179_895 VGND VGND VPWR VPWR sky130_fd_sc_hd__fill_1
XFILLER_107_1466 VPWR VGND VPWR VGND sky130_ef_sc_hd__decap_12
XFILLER_16_1338 VPWR VGND VPWR VGND sky130_ef_sc_hd__decap_12
XPHY_EDGE_ROW_26_1_Right_612 VGND VGND VPWR VPWR sky130_fd_sc_hd__decap_3
XFILLER_55_1398 VPWR VGND VPWR VGND sky130_ef_sc_hd__decap_12
XFILLER_205_1089 VPWR VGND VPWR VGND sky130_ef_sc_hd__decap_12
XFILLER_166_545 VPWR VGND VPWR VGND sky130_ef_sc_hd__decap_12
XTAP_TAPCELL_ROW_94_2_3586 VGND VPWR sky130_fd_sc_hd__tapvpwrvgnd_1
XTAP_TAPCELL_ROW_173_1672 VGND VPWR sky130_fd_sc_hd__tapvpwrvgnd_1
XTAP_TAPCELL_ROW_173_1661 VGND VPWR sky130_fd_sc_hd__tapvpwrvgnd_1
XFILLER_166_589 VPWR VGND VPWR VGND sky130_ef_sc_hd__decap_12
XFILLER_181_559 VGND VGND VPWR VPWR sky130_fd_sc_hd__fill_1
XTAP_TAPCELL_ROW_173_1683 VGND VPWR sky130_fd_sc_hd__tapvpwrvgnd_1
XFILLER_4_249 VGND VGND VPWR VPWR sky130_fd_sc_hd__decap_3
XFILLER_175_1133 VPWR VGND VPWR VGND sky130_ef_sc_hd__decap_12
XTAP_TAPCELL_ROW_74_2_3462 VGND VPWR sky130_fd_sc_hd__tapvpwrvgnd_1
XFILLER_175_1177 VPWR VGND VPWR VGND sky130_ef_sc_hd__decap_12
XFILLER_136_65 VPWR VGND VPWR VGND sky130_ef_sc_hd__decap_12
XFILLER_121_125 VGND VGND VPWR VPWR sky130_fd_sc_hd__fill_2
XFILLER_66_1450 VPWR VGND VPWR VGND sky130_ef_sc_hd__decap_12
XFILLER_216_1141 VGND VGND VPWR VPWR sky130_fd_sc_hd__decap_6
XFILLER_153_1442 VPWR VGND VPWR VGND sky130_ef_sc_hd__decap_12
XFILLER_118_1562 VPWR VGND VPWR VGND sky130_ef_sc_hd__decap_12
XFILLER_66_1494 VPWR VGND VPWR VGND sky130_ef_sc_hd__decap_12
XFILLER_27_1434 VGND VGND VPWR VPWR sky130_fd_sc_hd__decap_6
XFILLER_62_1314 VPWR VGND VPWR VGND sky130_ef_sc_hd__decap_12
XFILLER_216_1185 VPWR VGND VPWR VGND sky130_ef_sc_hd__decap_12
XFILLER_212_1005 VPWR VGND VPWR VGND sky130_ef_sc_hd__decap_12
XFILLER_114_1426 VPWR VGND VPWR VGND sky130_ef_sc_hd__decap_12
XFILLER_1_989 VPWR VGND VPWR VGND sky130_ef_sc_hd__decap_12
XFILLER_27_1478 VPWR VGND VPWR VGND sky130_ef_sc_hd__decap_12
XFILLER_29_52 VGND VGND VPWR VPWR sky130_fd_sc_hd__decap_4
XFILLER_62_1358 VPWR VGND VPWR VGND sky130_ef_sc_hd__decap_12
XFILLER_212_1049 VPWR VGND VPWR VGND sky130_ef_sc_hd__decap_12
XTAP_TAPCELL_ROW_182_1919 VGND VPWR sky130_fd_sc_hd__tapvpwrvgnd_1
XTAP_TAPCELL_ROW_167_1487 VGND VPWR sky130_fd_sc_hd__tapvpwrvgnd_1
XFILLER_152_53 VPWR VGND VPWR VGND sky130_ef_sc_hd__decap_12
XFILLER_217_741 VPWR VGND VPWR VGND sky130_ef_sc_hd__decap_12
XTAP_TAPCELL_ROW_167_1498 VGND VPWR sky130_fd_sc_hd__tapvpwrvgnd_1
XFILLER_152_97 VPWR VGND VPWR VGND sky130_ef_sc_hd__decap_12
XANTENNA_input18_A func_wdata[15] VGND VGND VPWR VPWR sky130_fd_sc_hd__diode_2
XFILLER_217_785 VPWR VGND VPWR VGND sky130_ef_sc_hd__decap_12
XFILLER_216_251 VGND VGND VPWR VPWR sky130_fd_sc_hd__fill_1
XFILLER_204_413 VGND VGND VPWR VPWR sky130_fd_sc_hd__decap_6
XFILLER_189_615 VGND VGND VPWR VPWR sky130_fd_sc_hd__fill_1
XFILLER_186_1273 VPWR VGND VPWR VGND sky130_ef_sc_hd__decap_12
X_594_ clknet_3_4_0_clk _028_ VGND VGND VPWR VPWR net79 sky130_fd_sc_hd__dfxtp_1
XFILLER_45_51 VGND VGND VPWR VPWR sky130_fd_sc_hd__decap_4
XFILLER_204_457 VPWR VGND VPWR VGND sky130_ef_sc_hd__decap_12
XFILLER_147_1268 VGND VGND VPWR VPWR sky130_fd_sc_hd__decap_4
XFILLER_77_1590 VPWR VGND VPWR VGND sky130_ef_sc_hd__decap_12
XFILLER_73_1410 VPWR VGND VPWR VGND sky130_ef_sc_hd__decap_12
XFILLER_176_309 VPWR VGND VPWR VGND sky130_ef_sc_hd__decap_12
XFILLER_169_361 VPWR VGND VPWR VGND sky130_ef_sc_hd__decap_12
XFILLER_125_1522 VPWR VGND VPWR VGND sky130_ef_sc_hd__decap_12
XPHY_EDGE_ROW_107_2_Right_164 VGND VGND VPWR VPWR sky130_fd_sc_hd__decap_3
XFILLER_73_1454 VPWR VGND VPWR VGND sky130_ef_sc_hd__decap_12
XFILLER_38_1574 VGND VGND VPWR VPWR sky130_fd_sc_hd__decap_6
XFILLER_185_821 VPWR VGND VPWR VGND sky130_ef_sc_hd__decap_12
XFILLER_125_1566 VPWR VGND VPWR VGND sky130_ef_sc_hd__decap_12
XFILLER_73_1498 VPWR VGND VPWR VGND sky130_ef_sc_hd__decap_12
XTAP_TAPCELL_ROW_15_2_3077 VGND VPWR sky130_fd_sc_hd__tapvpwrvgnd_1
XFILLER_34_1438 VPWR VGND VPWR VGND sky130_ef_sc_hd__decap_12
XFILLER_185_865 VPWR VGND VPWR VGND sky130_ef_sc_hd__decap_12
XFILLER_160_1468 VGND VGND VPWR VPWR sky130_fd_sc_hd__fill_1
XFILLER_193_1233 VPWR VGND VPWR VGND sky130_ef_sc_hd__decap_12
XTAP_TAPCELL_ROW_141_1_1299 VGND VPWR sky130_fd_sc_hd__tapvpwrvgnd_1
XFILLER_180_581 VGND VGND VPWR VPWR sky130_fd_sc_hd__decap_6
XFILLER_84_1550 VPWR VGND VPWR VGND sky130_ef_sc_hd__decap_12
XFILLER_10_1482 VPWR VGND VPWR VGND sky130_ef_sc_hd__decap_12
XFILLER_193_93 VPWR VGND VPWR VGND sky130_ef_sc_hd__decap_12
XFILLER_84_1594 VGND VGND VPWR VPWR sky130_fd_sc_hd__decap_8
XFILLER_80_1414 VPWR VGND VPWR VGND sky130_ef_sc_hd__decap_12
XFILLER_3_293 VGND VGND VPWR VPWR sky130_fd_sc_hd__decap_4
XFILLER_45_1534 VPWR VGND VPWR VGND sky130_ef_sc_hd__decap_12
XFILLER_132_1526 VPWR VGND VPWR VGND sky130_ef_sc_hd__decap_12
XTAP_TAPCELL_ROW_7_1000 VGND VPWR sky130_fd_sc_hd__tapvpwrvgnd_1
XFILLER_6_1005 VPWR VGND VPWR VGND sky130_ef_sc_hd__decap_12
XFILLER_45_1578 VPWR VGND VPWR VGND sky130_ef_sc_hd__decap_12
XTAP_TAPCELL_ROW_7_1011 VGND VPWR sky130_fd_sc_hd__tapvpwrvgnd_1
XFILLER_6_1049 VPWR VGND VPWR VGND sky130_ef_sc_hd__decap_12
XTAP_TAPCELL_ROW_7_1022 VGND VPWR sky130_fd_sc_hd__tapvpwrvgnd_1
XTAP_TAPCELL_ROW_7_1033 VGND VPWR sky130_fd_sc_hd__tapvpwrvgnd_1
XFILLER_13_3 VPWR VGND VPWR VGND sky130_ef_sc_hd__decap_12
XTAP_TAPCELL_ROW_204_2561 VGND VPWR sky130_fd_sc_hd__tapvpwrvgnd_1
XTAP_TAPCELL_ROW_204_2550 VGND VPWR sky130_fd_sc_hd__tapvpwrvgnd_1
XFILLER_130_1294 VGND VGND VPWR VPWR sky130_fd_sc_hd__decap_6
XFILLER_207_273 VGND VGND VPWR VPWR sky130_fd_sc_hd__decap_6
XFILLER_169_1493 VPWR VGND VPWR VGND sky130_ef_sc_hd__decap_12
XFILLER_165_1313 VPWR VGND VPWR VGND sky130_ef_sc_hd__decap_12
XTAP_TAPCELL_ROW_200_2447 VGND VPWR sky130_fd_sc_hd__tapvpwrvgnd_1
XTAP_TAPCELL_ROW_200_2436 VGND VPWR sky130_fd_sc_hd__tapvpwrvgnd_1
XTAP_TAPCELL_ROW_196_2340 VGND VPWR sky130_fd_sc_hd__tapvpwrvgnd_1
XFILLER_179_125 VPWR VGND VPWR VGND sky130_ef_sc_hd__decap_12
XFILLER_165_1357 VPWR VGND VPWR VGND sky130_ef_sc_hd__decap_12
XFILLER_91_1510 VPWR VGND VPWR VGND sky130_ef_sc_hd__decap_12
XFILLER_195_629 VPWR VGND VPWR VGND sky130_ef_sc_hd__decap_12
XTAP_TAPCELL_ROW_192_2215 VGND VPWR sky130_fd_sc_hd__tapvpwrvgnd_1
XTAP_TAPCELL_ROW_192_2204 VGND VPWR sky130_fd_sc_hd__tapvpwrvgnd_1
XFILLER_179_169 VPWR VGND VPWR VGND sky130_ef_sc_hd__decap_12
XFILLER_91_1554 VPWR VGND VPWR VGND sky130_ef_sc_hd__decap_12
XTAP_TAPCELL_ROW_217_2933 VGND VPWR sky130_fd_sc_hd__tapvpwrvgnd_1
XTAP_TAPCELL_ROW_217_2922 VGND VPWR sky130_fd_sc_hd__tapvpwrvgnd_1
XTAP_TAPCELL_ROW_217_2911 VGND VPWR sky130_fd_sc_hd__tapvpwrvgnd_1
XFILLER_206_1365 VGND VGND VPWR VPWR sky130_fd_sc_hd__decap_6
XFILLER_194_139 VGND VGND VPWR VPWR sky130_fd_sc_hd__fill_1
XTAP_TAPCELL_ROW_192_2226 VGND VPWR sky130_fd_sc_hd__tapvpwrvgnd_1
XFILLER_188_681 VPWR VGND VPWR VGND sky130_ef_sc_hd__decap_12
XFILLER_52_1538 VPWR VGND VPWR VGND sky130_ef_sc_hd__decap_12
XFILLER_202_1229 VPWR VGND VPWR VGND sky130_ef_sc_hd__decap_12
XTAP_TAPCELL_ROW_213_2819 VGND VPWR sky130_fd_sc_hd__tapvpwrvgnd_1
XTAP_TAPCELL_ROW_213_2808 VGND VPWR sky130_fd_sc_hd__tapvpwrvgnd_1
XFILLER_190_301 VGND VGND VPWR VPWR sky130_fd_sc_hd__decap_6
XFILLER_190_345 VPWR VGND VPWR VGND sky130_ef_sc_hd__decap_12
XTAP_TAPCELL_ROW_60_2_3370 VGND VPWR sky130_fd_sc_hd__tapvpwrvgnd_1
XTAP_TAPCELL_ROW_59_2_3364 VGND VPWR sky130_fd_sc_hd__tapvpwrvgnd_1
XFILLER_176_1453 VPWR VGND VPWR VGND sky130_ef_sc_hd__decap_12
XTAP_TAPCELL_ROW_78_1_1174 VGND VPWR sky130_fd_sc_hd__tapvpwrvgnd_1
XFILLER_11_1268 VGND VGND VPWR VPWR sky130_fd_sc_hd__decap_4
XFILLER_190_389 VPWR VGND VPWR VGND sky130_ef_sc_hd__decap_12
XFILLER_176_1497 VPWR VGND VPWR VGND sky130_ef_sc_hd__decap_12
XFILLER_172_1317 VPWR VGND VPWR VGND sky130_ef_sc_hd__decap_12
XFILLER_103_125 VGND VGND VPWR VPWR sky130_fd_sc_hd__fill_2
XFILLER_213_1325 VPWR VGND VPWR VGND sky130_ef_sc_hd__decap_12
XFILLER_213_1369 VPWR VGND VPWR VGND sky130_ef_sc_hd__decap_12
XFILLER_170_1085 VGND VGND VPWR VPWR sky130_fd_sc_hd__decap_6
XTAP_TAPCELL_ROW_52_2_3318 VGND VPWR sky130_fd_sc_hd__tapvpwrvgnd_1
XFILLER_198_401 VPWR VGND VPWR VGND sky130_ef_sc_hd__decap_12
XFILLER_187_1593 VPWR VGND VPWR VGND sky130_ef_sc_hd__decap_12
XFILLER_183_1413 VPWR VGND VPWR VGND sky130_ef_sc_hd__decap_12
XFILLER_82_27 VGND VGND VPWR VPWR sky130_fd_sc_hd__fill_1
XFILLER_214_755 VGND VGND VPWR VPWR sky130_fd_sc_hd__fill_1
XFILLER_202_917 VGND VGND VPWR VPWR sky130_fd_sc_hd__decap_6
XFILLER_198_445 VPWR VGND VPWR VGND sky130_ef_sc_hd__decap_12
XFILLER_198_27 VGND VGND VPWR VPWR sky130_fd_sc_hd__fill_1
XFILLER_183_1457 VPWR VGND VPWR VGND sky130_ef_sc_hd__decap_12
XFILLER_201_405 VPWR VGND VPWR VGND sky130_ef_sc_hd__decap_12
XFILLER_198_489 VPWR VGND VPWR VGND sky130_ef_sc_hd__decap_12
XFILLER_15_65 VGND VGND VPWR VPWR sky130_fd_sc_hd__fill_2
XFILLER_201_449 VPWR VGND VPWR VGND sky130_ef_sc_hd__decap_12
XTAP_TAPCELL_ROW_175_1723 VGND VPWR sky130_fd_sc_hd__tapvpwrvgnd_1
XFILLER_167_821 VPWR VGND VPWR VGND sky130_ef_sc_hd__decap_12
XFILLER_210_961 VPWR VGND VPWR VGND sky130_ef_sc_hd__decap_12
XTAP_TAPCELL_ROW_175_1734 VGND VPWR sky130_fd_sc_hd__tapvpwrvgnd_1
XFILLER_167_865 VPWR VGND VPWR VGND sky130_ef_sc_hd__decap_12
XFILLER_107_1274 VPWR VGND VPWR VGND sky130_ef_sc_hd__decap_12
XPHY_EDGE_ROW_27_1_Right_613 VGND VGND VPWR VPWR sky130_fd_sc_hd__decap_3
XFILLER_215_3 VPWR VGND VPWR VGND sky130_ef_sc_hd__decap_12
XFILLER_193_161 VGND VGND VPWR VPWR sky130_fd_sc_hd__decap_6
XFILLER_182_813 VPWR VGND VPWR VGND sky130_ef_sc_hd__decap_12
XTAP_TAPCELL_ROW_171_1609 VGND VPWR sky130_fd_sc_hd__tapvpwrvgnd_1
XTAP_TAPCELL_ROW_156_2_3992 VGND VPWR sky130_fd_sc_hd__tapvpwrvgnd_1
XFILLER_5_503 VGND VGND VPWR VPWR sky130_fd_sc_hd__fill_1
XFILLER_218_1203 VGND VGND VPWR VPWR sky130_fd_sc_hd__fill_1
XFILLER_194_1553 VPWR VGND VPWR VGND sky130_ef_sc_hd__decap_12
XFILLER_194_1597 VGND VGND VPWR VPWR sky130_fd_sc_hd__decap_8
XTAP_TAPCELL_ROW_169_1549 VGND VPWR sky130_fd_sc_hd__tapvpwrvgnd_1
Xoutput75 net75 VGND VGND VPWR VPWR bist_fail_bits[26] sky130_fd_sc_hd__buf_2
Xoutput64 net64 VGND VGND VPWR VPWR bist_fail_bits[16] sky130_fd_sc_hd__buf_2
Xoutput53 net53 VGND VGND VPWR VPWR bist_fail_addr[4] sky130_fd_sc_hd__buf_2
XFILLER_27_1220 VPWR VGND VPWR VGND sky130_ef_sc_hd__decap_12
XFILLER_163_41 VPWR VGND VPWR VGND sky130_ef_sc_hd__decap_12
XFILLER_118_1370 VPWR VGND VPWR VGND sky130_ef_sc_hd__decap_12
Xoutput97 net97 VGND VGND VPWR VPWR func_rdata[17] sky130_fd_sc_hd__buf_2
Xoutput86 net86 VGND VGND VPWR VPWR bist_fail_bits[7] sky130_fd_sc_hd__buf_2
XFILLER_209_505 VPWR VGND VPWR VGND sky130_ef_sc_hd__decap_12
XFILLER_163_85 VPWR VGND VPWR VGND sky130_ef_sc_hd__decap_12
XFILLER_7_1369 VGND VGND VPWR VPWR sky130_fd_sc_hd__decap_3
XFILLER_27_1286 VPWR VGND VPWR VGND sky130_ef_sc_hd__decap_12
XFILLER_56_83 VGND VGND VPWR VPWR sky130_fd_sc_hd__fill_1
XTAP_TAPCELL_ROW_96_2_3605 VGND VPWR sky130_fd_sc_hd__tapvpwrvgnd_1
XPHY_EDGE_ROW_69_2_Left_501 VGND VGND VPWR VPWR sky130_fd_sc_hd__decap_3
XFILLER_205_777 VGND VGND VPWR VPWR sky130_fd_sc_hd__decap_6
XFILLER_204_221 VPWR VGND VPWR VGND sky130_ef_sc_hd__decap_12
X_577_ clknet_3_2_0_clk _000_ VGND VGND VPWR VPWR u_ctrl.state\[1\] sky130_fd_sc_hd__dfxtp_1
XFILLER_31_101 VGND VGND VPWR VPWR sky130_fd_sc_hd__decap_8
XFILLER_204_265 VPWR VGND VPWR VGND sky130_ef_sc_hd__decap_12
XPHY_EDGE_ROW_121_2_Left_553 VGND VGND VPWR VPWR sky130_fd_sc_hd__decap_3
XFILLER_203_1505 VGND VGND VPWR VPWR sky130_fd_sc_hd__decap_6
XFILLER_177_629 VPWR VGND VPWR VGND sky130_ef_sc_hd__decap_12
XFILLER_125_1330 VPWR VGND VPWR VGND sky130_ef_sc_hd__decap_12
XFILLER_38_1382 VPWR VGND VPWR VGND sky130_ef_sc_hd__decap_12
XFILLER_203_1549 VPWR VGND VPWR VGND sky130_ef_sc_hd__decap_12
XFILLER_176_139 VGND VGND VPWR VPWR sky130_fd_sc_hd__fill_1
XFILLER_160_1232 VPWR VGND VPWR VGND sky130_ef_sc_hd__decap_12
XPHY_EDGE_ROW_108_2_Right_165 VGND VGND VPWR VPWR sky130_fd_sc_hd__decap_3
XFILLER_34_1246 VPWR VGND VPWR VGND sky130_ef_sc_hd__decap_12
XFILLER_185_673 VPWR VGND VPWR VGND sky130_ef_sc_hd__decap_12
XFILLER_172_301 VGND VGND VPWR VPWR sky130_fd_sc_hd__decap_6
XTAP_TAPCELL_ROW_45_2_3272 VGND VPWR sky130_fd_sc_hd__tapvpwrvgnd_1
XFILLER_172_345 VPWR VGND VPWR VGND sky130_ef_sc_hd__decap_12
XFILLER_193_1063 VGND VGND VPWR VPWR sky130_fd_sc_hd__fill_1
XFILLER_172_389 VPWR VGND VPWR VGND sky130_ef_sc_hd__decap_12
XFILLER_136_1470 VPWR VGND VPWR VGND sky130_ef_sc_hd__decap_12
XFILLER_80_1244 VGND VGND VPWR VPWR sky130_fd_sc_hd__fill_1
XFILLER_45_1342 VPWR VGND VPWR VGND sky130_ef_sc_hd__decap_12
XFILLER_210_1509 VPWR VGND VPWR VGND sky130_ef_sc_hd__decap_12
XTAP_TAPCELL_ROW_206_2612 VGND VPWR sky130_fd_sc_hd__tapvpwrvgnd_1
XTAP_TAPCELL_ROW_206_2601 VGND VPWR sky130_fd_sc_hd__tapvpwrvgnd_1
XFILLER_45_1386 VPWR VGND VPWR VGND sky130_ef_sc_hd__decap_12
XTAP_TAPCELL_ROW_206_2623 VGND VPWR sky130_fd_sc_hd__tapvpwrvgnd_1
XFILLER_132_1356 VGND VGND VPWR VPWR sky130_fd_sc_hd__fill_1
XTAP_TAPCELL_ROW_202_2509 VGND VPWR sky130_fd_sc_hd__tapvpwrvgnd_1
XFILLER_208_1427 VGND VGND VPWR VPWR sky130_fd_sc_hd__fill_1
XFILLER_165_1121 VPWR VGND VPWR VGND sky130_ef_sc_hd__decap_12
XPHY_EDGE_ROW_53_2_Left_485 VGND VGND VPWR VPWR sky130_fd_sc_hd__decap_3
XFILLER_196_905 VPWR VGND VPWR VGND sky130_ef_sc_hd__decap_12
XANTENNA_fanout155_A net156 VGND VGND VPWR VPWR sky130_fd_sc_hd__diode_2
XFILLER_196_949 VPWR VGND VPWR VGND sky130_ef_sc_hd__decap_12
XFILLER_108_1550 VPWR VGND VPWR VGND sky130_ef_sc_hd__decap_12
XFILLER_17_1422 VPWR VGND VPWR VGND sky130_ef_sc_hd__decap_12
XFILLER_52_1302 VPWR VGND VPWR VGND sky130_ef_sc_hd__decap_12
XFILLER_56_1482 VPWR VGND VPWR VGND sky130_ef_sc_hd__decap_12
XFILLER_206_1173 VPWR VGND VPWR VGND sky130_ef_sc_hd__decap_12
XPHY_EDGE_ROW_154_1_Right_740 VGND VGND VPWR VPWR sky130_fd_sc_hd__decap_3
XFILLER_108_1594 VGND VGND VPWR VPWR sky130_fd_sc_hd__decap_8
XFILLER_104_1414 VPWR VGND VPWR VGND sky130_ef_sc_hd__decap_12
XFILLER_91_1384 VGND VGND VPWR VPWR sky130_fd_sc_hd__fill_1
XFILLER_17_1466 VPWR VGND VPWR VGND sky130_ef_sc_hd__decap_12
XFILLER_202_1037 VPWR VGND VPWR VGND sky130_ef_sc_hd__decap_12
XFILLER_182_109 VPWR VGND VPWR VGND sky130_ef_sc_hd__decap_12
XFILLER_175_161 VGND VGND VPWR VPWR sky130_fd_sc_hd__decap_6
XFILLER_164_813 VPWR VGND VPWR VGND sky130_ef_sc_hd__decap_12
XFILLER_143_1496 VGND VGND VPWR VPWR sky130_fd_sc_hd__fill_1
XFILLER_191_665 VGND VGND VPWR VPWR sky130_fd_sc_hd__decap_6
XFILLER_190_153 VPWR VGND VPWR VGND sky130_ef_sc_hd__decap_12
XFILLER_184_29 VPWR VGND VPWR VGND sky130_ef_sc_hd__decap_12
XFILLER_190_197 VPWR VGND VPWR VGND sky130_ef_sc_hd__decap_12
XFILLER_176_1261 VPWR VGND VPWR VGND sky130_ef_sc_hd__decap_12
XFILLER_163_389 VGND VGND VPWR VPWR sky130_fd_sc_hd__decap_3
XFILLER_137_1256 VPWR VGND VPWR VGND sky130_ef_sc_hd__decap_12
XTAP_TAPCELL_ROW_134_2_3848 VGND VPWR sky130_fd_sc_hd__tapvpwrvgnd_1
XFILLER_77_27 VPWR VGND VPWR VGND sky130_ef_sc_hd__decap_12
XFILLER_172_1147 VGND VGND VPWR VPWR sky130_fd_sc_hd__fill_1
XFILLER_115_1510 VPWR VGND VPWR VGND sky130_ef_sc_hd__decap_12
XFILLER_63_1442 VPWR VGND VPWR VGND sky130_ef_sc_hd__decap_12
XFILLER_28_1562 VPWR VGND VPWR VGND sky130_ef_sc_hd__decap_12
XFILLER_219_825 VPWR VGND VPWR VGND sky130_ef_sc_hd__decap_12
XFILLER_213_1133 VPWR VGND VPWR VGND sky130_ef_sc_hd__decap_12
XTAP_TAPCELL_ROW_164_1402 VGND VPWR sky130_fd_sc_hd__tapvpwrvgnd_1
XFILLER_150_1412 VGND VGND VPWR VPWR sky130_fd_sc_hd__fill_1
XPHY_EDGE_ROW_117_1_Left_336 VGND VGND VPWR VPWR sky130_fd_sc_hd__decap_3
XFILLER_115_1554 VPWR VGND VPWR VGND sky130_ef_sc_hd__decap_12
XFILLER_4_1509 VPWR VGND VPWR VGND sky130_ef_sc_hd__decap_12
XFILLER_24_1426 VPWR VGND VPWR VGND sky130_ef_sc_hd__decap_12
XFILLER_219_869 VPWR VGND VPWR VGND sky130_ef_sc_hd__decap_12
XFILLER_213_1177 VPWR VGND VPWR VGND sky130_ef_sc_hd__decap_12
XTAP_TAPCELL_ROW_164_1424 VGND VPWR sky130_fd_sc_hd__tapvpwrvgnd_1
XTAP_TAPCELL_ROW_164_1413 VGND VPWR sky130_fd_sc_hd__tapvpwrvgnd_1
XFILLER_133_55 VGND VGND VPWR VPWR sky130_fd_sc_hd__fill_1
XFILLER_93_15 VPWR VGND VPWR VGND sky130_ef_sc_hd__decap_12
XFILLER_218_357 VGND VGND VPWR VPWR sky130_fd_sc_hd__decap_6
XFILLER_98_1538 VPWR VGND VPWR VGND sky130_ef_sc_hd__decap_12
XTAP_TAPCELL_ROW_82_2_3513 VGND VPWR sky130_fd_sc_hd__tapvpwrvgnd_1
X_500_ _183_ net121 VGND VGND VPWR VPWR _224_ sky130_fd_sc_hd__nand2_1
XFILLER_26_20 VGND VGND VPWR VPWR sky130_fd_sc_hd__fill_2
XFILLER_199_721 VGND VGND VPWR VPWR sky130_fd_sc_hd__decap_6
XFILLER_165_3 VPWR VGND VPWR VGND sky130_ef_sc_hd__decap_12
X_431_ b_addr\[7\] _104_ VGND VGND VPWR VPWR _164_ sky130_fd_sc_hd__xnor2_1
XFILLER_202_725 VPWR VGND VPWR VGND sky130_ef_sc_hd__decap_12
XFILLER_199_765 VPWR VGND VPWR VGND sky130_ef_sc_hd__decap_12
XFILLER_198_253 VPWR VGND VPWR VGND sky130_ef_sc_hd__decap_12
X_362_ b_addr\[3\] b_addr\[2\] b_addr\[1\] b_addr\[0\] VGND VGND VPWR VPWR _105_ sky130_fd_sc_hd__or4_1
XFILLER_26_97 VGND VGND VPWR VPWR sky130_fd_sc_hd__decap_3
XFILLER_57_1268 VGND VGND VPWR VPWR sky130_fd_sc_hd__decap_4
XFILLER_202_769 VPWR VGND VPWR VGND sky130_ef_sc_hd__decap_12
XFILLER_183_1287 VGND VGND VPWR VPWR sky130_fd_sc_hd__fill_1
XFILLER_74_1582 VPWR VGND VPWR VGND sky130_ef_sc_hd__decap_12
XFILLER_35_1522 VPWR VGND VPWR VGND sky130_ef_sc_hd__decap_12
XFILLER_161_1552 VGND VGND VPWR VPWR sky130_fd_sc_hd__fill_1
X_293_ net12 net141 net131 VGND VGND VPWR VPWR s_wdata\[0\] sky130_fd_sc_hd__a21o_1
XTAP_TAPCELL_ROW_31_2_3180 VGND VPWR sky130_fd_sc_hd__tapvpwrvgnd_1
XFILLER_35_1566 VPWR VGND VPWR VGND sky130_ef_sc_hd__decap_12
XFILLER_42_41 VPWR VGND VPWR VGND sky130_ef_sc_hd__decap_12
XFILLER_201_279 VGND VGND VPWR VPWR sky130_fd_sc_hd__fill_1
XFILLER_167_673 VPWR VGND VPWR VGND sky130_ef_sc_hd__decap_12
XFILLER_158_41 VPWR VGND VPWR VGND sky130_ef_sc_hd__decap_12
XFILLER_70_1468 VGND VGND VPWR VPWR sky130_fd_sc_hd__fill_1
XFILLER_42_85 VPWR VGND VPWR VGND sky130_ef_sc_hd__decap_12
XFILLER_182_643 VGND VGND VPWR VPWR sky130_fd_sc_hd__fill_1
XFILLER_158_85 VPWR VGND VPWR VGND sky130_ef_sc_hd__decap_12
XPHY_EDGE_ROW_28_1_Right_614 VGND VGND VPWR VPWR sky130_fd_sc_hd__decap_3
XFILLER_170_805 VGND VGND VPWR VPWR sky130_fd_sc_hd__decap_6
XTAP_TAPCELL_ROW_156_1_1330 VGND VPWR sky130_fd_sc_hd__tapvpwrvgnd_1
XFILLER_170_849 VPWR VGND VPWR VGND sky130_ef_sc_hd__decap_12
XFILLER_120_1282 VPWR VGND VPWR VGND sky130_ef_sc_hd__decap_12
XFILLER_190_1203 VGND VGND VPWR VPWR sky130_fd_sc_hd__fill_1
XTAP_TAPCELL_ROW_23_2_3128 VGND VPWR sky130_fd_sc_hd__tapvpwrvgnd_1
XFILLER_155_1378 VGND VGND VPWR VPWR sky130_fd_sc_hd__decap_6
XFILLER_1_561 VPWR VGND VPWR VGND sky130_ef_sc_hd__decap_12
XPHY_EDGE_ROW_49_1_Left_268 VGND VGND VPWR VPWR sky130_fd_sc_hd__decap_3
XFILLER_3_57 VPWR VGND VPWR VGND sky130_ef_sc_hd__decap_12
XFILLER_7_1133 VPWR VGND VPWR VGND sky130_ef_sc_hd__decap_12
XFILLER_42_1526 VPWR VGND VPWR VGND sky130_ef_sc_hd__decap_12
XFILLER_209_335 VGND VGND VPWR VPWR sky130_fd_sc_hd__fill_1
XFILLER_67_93 VPWR VGND VPWR VGND sky130_ef_sc_hd__decap_12
XFILLER_7_1177 VPWR VGND VPWR VGND sky130_ef_sc_hd__decap_12
XFILLER_190_83 VGND VGND VPWR VPWR sky130_fd_sc_hd__fill_1
XANTENNA__585__CLK clknet_3_0_0_clk VGND VGND VPWR VPWR sky130_fd_sc_hd__diode_2
XFILLER_205_541 VPWR VGND VPWR VGND sky130_ef_sc_hd__decap_12
XFILLER_184_1029 VGND VGND VPWR VPWR sky130_fd_sc_hd__decap_6
XFILLER_166_1441 VPWR VGND VPWR VGND sky130_ef_sc_hd__decap_12
XANTENNA__556__S net122 VGND VGND VPWR VPWR sky130_fd_sc_hd__diode_2
X_629_ clknet_3_3_0_clk _063_ VGND VGND VPWR VPWR net54 sky130_fd_sc_hd__dfxtp_1
XFILLER_40_1294 VGND VGND VPWR VPWR sky130_fd_sc_hd__decap_6
XFILLER_205_585 VPWR VGND VPWR VGND sky130_ef_sc_hd__decap_12
XFILLER_199_81 VPWR VGND VPWR VGND sky130_ef_sc_hd__decap_12
XFILLER_178_905 VPWR VGND VPWR VGND sky130_ef_sc_hd__decap_12
XFILLER_166_1485 VPWR VGND VPWR VGND sky130_ef_sc_hd__decap_12
XFILLER_83_81 VPWR VGND VPWR VGND sky130_ef_sc_hd__decap_12
XFILLER_178_949 VPWR VGND VPWR VGND sky130_ef_sc_hd__decap_12
XFILLER_162_1338 VPWR VGND VPWR VGND sky130_ef_sc_hd__decap_12
XFILLER_203_1313 VPWR VGND VPWR VGND sky130_ef_sc_hd__decap_12
XFILLER_80_3 VPWR VGND VPWR VGND sky130_ef_sc_hd__decap_12
XFILLER_207_1493 VPWR VGND VPWR VGND sky130_ef_sc_hd__decap_12
XFILLER_203_1357 VPWR VGND VPWR VGND sky130_ef_sc_hd__decap_12
XFILLER_186_993 VPWR VGND VPWR VGND sky130_ef_sc_hd__decap_12
XFILLER_164_109 VPWR VGND VPWR VGND sky130_ef_sc_hd__decap_12
XPHY_EDGE_ROW_109_2_Right_166 VGND VGND VPWR VPWR sky130_fd_sc_hd__decap_3
XFILLER_173_665 VGND VGND VPWR VPWR sky130_fd_sc_hd__decap_6
XFILLER_172_153 VPWR VGND VPWR VGND sky130_ef_sc_hd__decap_12
XFILLER_218_77 VGND VGND VPWR VPWR sky130_fd_sc_hd__decap_6
XFILLER_195_1169 VGND VGND VPWR VPWR sky130_fd_sc_hd__decap_6
XFILLER_173_1401 VPWR VGND VPWR VGND sky130_ef_sc_hd__decap_12
XTAP_TAPCELL_ROW_120_2_3756 VGND VPWR sky130_fd_sc_hd__tapvpwrvgnd_1
XFILLER_177_1581 VPWR VGND VPWR VGND sky130_ef_sc_hd__decap_12
XFILLER_172_197 VPWR VGND VPWR VGND sky130_ef_sc_hd__decap_12
XTAP_TAPCELL_ROW_12_1_1041 VGND VPWR sky130_fd_sc_hd__tapvpwrvgnd_1
Xfanout128 net129 VGND VGND VPWR VPWR net128 sky130_fd_sc_hd__buf_2
XFILLER_214_1453 VPWR VGND VPWR VGND sky130_ef_sc_hd__decap_12
Xfanout139 _215_ VGND VGND VPWR VPWR net139 sky130_fd_sc_hd__clkbuf_4
XFILLER_210_1317 VPWR VGND VPWR VGND sky130_ef_sc_hd__decap_12
XFILLER_214_1497 VPWR VGND VPWR VGND sky130_ef_sc_hd__decap_12
XTAP_TAPCELL_ROW_100_1_1217 VGND VPWR sky130_fd_sc_hd__tapvpwrvgnd_1
XTAP_TAPCELL_ROW_67_2_3415 VGND VPWR sky130_fd_sc_hd__tapvpwrvgnd_1
XFILLER_215_305 VPWR VGND VPWR VGND sky130_ef_sc_hd__decap_12
XFILLER_215_349 VPWR VGND VPWR VGND sky130_ef_sc_hd__decap_12
XFILLER_184_1541 VPWR VGND VPWR VGND sky130_ef_sc_hd__decap_12
XFILLER_110_1462 VGND VGND VPWR VPWR sky130_fd_sc_hd__decap_6
XFILLER_103_69 VPWR VGND VPWR VGND sky130_ef_sc_hd__decap_12
XFILLER_196_713 VPWR VGND VPWR VGND sky130_ef_sc_hd__decap_12
XFILLER_180_1427 VGND VGND VPWR VPWR sky130_fd_sc_hd__fill_1
XFILLER_196_757 VPWR VGND VPWR VGND sky130_ef_sc_hd__decap_12
XFILLER_195_223 VGND VGND VPWR VPWR sky130_fd_sc_hd__fill_1
XTAP_TAPCELL_ROW_16_2_3082 VGND VPWR sky130_fd_sc_hd__tapvpwrvgnd_1
XFILLER_183_429 VPWR VGND VPWR VGND sky130_ef_sc_hd__decap_12
XPHY_EDGE_ROW_155_1_Right_741 VGND VGND VPWR VPWR sky130_fd_sc_hd__decap_3
XFILLER_17_1274 VPWR VGND VPWR VGND sky130_ef_sc_hd__decap_12
XFILLER_195_39 VPWR VGND VPWR VGND sky130_ef_sc_hd__decap_12
XFILLER_164_643 VGND VGND VPWR VPWR sky130_fd_sc_hd__fill_1
XFILLER_104_1244 VGND VGND VPWR VPWR sky130_fd_sc_hd__fill_1
XFILLER_163_153 VPWR VGND VPWR VGND sky130_ef_sc_hd__decap_12
XFILLER_191_473 VPWR VGND VPWR VGND sky130_ef_sc_hd__decap_12
XFILLER_128_77 VGND VGND VPWR VPWR sky130_fd_sc_hd__decap_6
XFILLER_88_15 VPWR VGND VPWR VGND sky130_ef_sc_hd__decap_12
XFILLER_163_197 VPWR VGND VPWR VGND sky130_ef_sc_hd__decap_12
XFILLER_3_859 VGND VGND VPWR VPWR sky130_fd_sc_hd__fill_1
XANTENNA__495__A1 net149 VGND VGND VPWR VPWR sky130_fd_sc_hd__diode_2
XFILLER_2_325 VGND VGND VPWR VPWR sky130_fd_sc_hd__decap_4
XFILLER_219_1397 VGND VGND VPWR VPWR sky130_fd_sc_hd__decap_3
XFILLER_191_1567 VGND VGND VPWR VPWR sky130_fd_sc_hd__fill_1
XFILLER_176_1091 VGND VGND VPWR VPWR sky130_fd_sc_hd__fill_1
XFILLER_152_1518 VGND VGND VPWR VPWR sky130_fd_sc_hd__decap_6
XFILLER_144_65 VPWR VGND VPWR VGND sky130_ef_sc_hd__decap_12
XFILLER_28_1370 VPWR VGND VPWR VGND sky130_ef_sc_hd__decap_12
XFILLER_150_1220 VPWR VGND VPWR VGND sky130_ef_sc_hd__decap_12
XFILLER_98_1302 VPWR VGND VPWR VGND sky130_ef_sc_hd__decap_12
XFILLER_63_1272 VGND VGND VPWR VPWR sky130_fd_sc_hd__fill_1
XFILLER_4_1317 VPWR VGND VPWR VGND sky130_ef_sc_hd__decap_12
XFILLER_218_121 VPWR VGND VPWR VGND sky130_ef_sc_hd__decap_12
XFILLER_115_1384 VGND VGND VPWR VPWR sky130_fd_sc_hd__fill_1
XFILLER_218_165 VPWR VGND VPWR VGND sky130_ef_sc_hd__decap_12
XFILLER_207_839 VGND VGND VPWR VPWR sky130_fd_sc_hd__fill_1
XFILLER_160_53 VPWR VGND VPWR VGND sky130_ef_sc_hd__decap_12
XTAP_TAPCELL_ROW_158_2_4008 VGND VPWR sky130_fd_sc_hd__tapvpwrvgnd_1
XFILLER_160_97 VPWR VGND VPWR VGND sky130_ef_sc_hd__decap_12
XFILLER_2_1085 VGND VGND VPWR VPWR sky130_fd_sc_hd__decap_6
X_414_ b_addr\[5\] _084_ _103_ VGND VGND VPWR VPWR _149_ sky130_fd_sc_hd__and3_1
XFILLER_202_533 VPWR VGND VPWR VGND sky130_ef_sc_hd__decap_12
XFILLER_199_573 VPWR VGND VPWR VGND sky130_ef_sc_hd__decap_12
XFILLER_53_51 VGND VGND VPWR VPWR sky130_fd_sc_hd__decap_4
XFILLER_186_245 VGND VGND VPWR VPWR sky130_fd_sc_hd__decap_6
XFILLER_169_51 VGND VGND VPWR VPWR sky130_fd_sc_hd__decap_4
X_345_ net155 _093_ VGND VGND VPWR VPWR _009_ sky130_fd_sc_hd__and2_1
XFILLER_35_1330 VPWR VGND VPWR VGND sky130_ef_sc_hd__decap_12
XFILLER_146_109 VPWR VGND VPWR VGND sky130_ef_sc_hd__decap_12
XFILLER_122_1300 VGND VGND VPWR VPWR sky130_fd_sc_hd__fill_1
XFILLER_70_1232 VPWR VGND VPWR VGND sky130_ef_sc_hd__decap_12
X_276_ net173 _074_ net155 VGND VGND VPWR VPWR _003_ sky130_fd_sc_hd__o21a_1
XFILLER_186_289 VPWR VGND VPWR VGND sky130_ef_sc_hd__decap_12
XFILLER_168_993 VPWR VGND VPWR VGND sky130_ef_sc_hd__decap_12
XTAP_TAPCELL_ROW_105_2_3658 VGND VPWR sky130_fd_sc_hd__tapvpwrvgnd_1
XFILLER_6_631 VPWR VGND VPWR VGND sky130_ef_sc_hd__decap_12
XPHY_EDGE_ROW_29_1_Right_615 VGND VGND VPWR VPWR sky130_fd_sc_hd__decap_3
XFILLER_192_1309 VGND VGND VPWR VPWR sky130_fd_sc_hd__decap_6
XFILLER_170_613 VPWR VGND VPWR VGND sky130_ef_sc_hd__decap_12
XTAP_TAPCELL_ROW_92_1_1202 VGND VPWR sky130_fd_sc_hd__tapvpwrvgnd_1
XFILLER_170_657 VPWR VGND VPWR VGND sky130_ef_sc_hd__decap_12
XFILLER_5_185 VGND VGND VPWR VPWR sky130_fd_sc_hd__fill_1
XFILLER_46_1470 VPWR VGND VPWR VGND sky130_ef_sc_hd__decap_12
XFILLER_133_1440 VGND VGND VPWR VPWR sky130_fd_sc_hd__fill_1
XTAP_TAPCELL_ROW_53_2_3323 VGND VPWR sky130_fd_sc_hd__tapvpwrvgnd_1
XFILLER_42_1356 VGND VGND VPWR VPWR sky130_fd_sc_hd__fill_1
XPHY_EDGE_ROW_184_Right_29 VGND VGND VPWR VPWR sky130_fd_sc_hd__decap_3
XFILLER_213_809 VPWR VGND VPWR VGND sky130_ef_sc_hd__decap_12
XFILLER_209_1511 VGND VGND VPWR VPWR sky130_fd_sc_hd__fill_1
XFILLER_206_861 VGND VGND VPWR VPWR sky130_fd_sc_hd__decap_6
XFILLER_205_393 VPWR VGND VPWR VGND sky130_ef_sc_hd__decap_12
XFILLER_178_713 VPWR VGND VPWR VGND sky130_ef_sc_hd__decap_12
XFILLER_127_1244 VPWR VGND VPWR VGND sky130_ef_sc_hd__decap_12
XFILLER_178_757 VPWR VGND VPWR VGND sky130_ef_sc_hd__decap_12
XFILLER_177_223 VGND VGND VPWR VPWR sky130_fd_sc_hd__fill_1
XFILLER_18_1550 VPWR VGND VPWR VGND sky130_ef_sc_hd__decap_12
XFILLER_203_1121 VPWR VGND VPWR VGND sky130_ef_sc_hd__decap_12
XFILLER_193_727 VGND VGND VPWR VPWR sky130_fd_sc_hd__fill_1
XFILLER_144_1580 VGND VGND VPWR VPWR sky130_fd_sc_hd__fill_1
XFILLER_14_1414 VPWR VGND VPWR VGND sky130_ef_sc_hd__decap_12
XPHY_EDGE_ROW_193_Right_38 VGND VGND VPWR VPWR sky130_fd_sc_hd__decap_3
XFILLER_165_429 VPWR VGND VPWR VGND sky130_ef_sc_hd__decap_12
XFILLER_18_1594 VGND VGND VPWR VPWR sky130_fd_sc_hd__decap_8
XFILLER_53_1496 VGND VGND VPWR VPWR sky130_fd_sc_hd__fill_1
XFILLER_88_1526 VPWR VGND VPWR VGND sky130_ef_sc_hd__decap_12
XANTENNA__600__CLK clknet_3_1_0_clk VGND VGND VPWR VPWR sky130_fd_sc_hd__diode_2
XFILLER_173_473 VPWR VGND VPWR VGND sky130_ef_sc_hd__decap_12
XFILLER_173_1231 VGND VGND VPWR VPWR sky130_fd_sc_hd__fill_1
XTAP_TAPCELL_ROW_150_2_3951 VGND VPWR sky130_fd_sc_hd__tapvpwrvgnd_1
XFILLER_86_1294 VGND VGND VPWR VPWR sky130_fd_sc_hd__decap_6
XFILLER_47_1256 VPWR VGND VPWR VGND sky130_ef_sc_hd__decap_12
XFILLER_58_29 VPWR VGND VPWR VGND sky130_ef_sc_hd__decap_12
XTAP_TAPCELL_ROW_149_2_3945 VGND VPWR sky130_fd_sc_hd__tapvpwrvgnd_1
XFILLER_25_1510 VPWR VGND VPWR VGND sky130_ef_sc_hd__decap_12
XFILLER_214_1261 VPWR VGND VPWR VGND sky130_ef_sc_hd__decap_12
XFILLER_25_1554 VPWR VGND VPWR VGND sky130_ef_sc_hd__decap_12
XFILLER_60_1412 VGND VGND VPWR VPWR sky130_fd_sc_hd__fill_1
XFILLER_112_1524 VGND VGND VPWR VPWR sky130_fd_sc_hd__fill_1
XFILLER_216_625 VPWR VGND VPWR VGND sky130_ef_sc_hd__decap_12
XFILLER_210_1147 VGND VGND VPWR VPWR sky130_fd_sc_hd__fill_1
XFILLER_216_669 VPWR VGND VPWR VGND sky130_ef_sc_hd__decap_12
XFILLER_215_113 VPWR VGND VPWR VGND sky130_ef_sc_hd__decap_12
XTAP_TAPCELL_ROW_97_2_3610 VGND VPWR sky130_fd_sc_hd__tapvpwrvgnd_1
XPHY_EDGE_ROW_13_2_Right_70 VGND VGND VPWR VPWR sky130_fd_sc_hd__decap_3
XFILLER_167_1057 VGND VGND VPWR VPWR sky130_fd_sc_hd__decap_6
XFILLER_110_1270 VPWR VGND VPWR VGND sky130_ef_sc_hd__decap_12
XFILLER_93_1232 VPWR VGND VPWR VGND sky130_ef_sc_hd__decap_12
XFILLER_184_1371 VGND VGND VPWR VPWR sky130_fd_sc_hd__fill_1
XFILLER_145_1322 VGND VGND VPWR VPWR sky130_fd_sc_hd__decap_6
XFILLER_90_27 VGND VGND VPWR VPWR sky130_fd_sc_hd__fill_1
XFILLER_168_245 VGND VGND VPWR VPWR sky130_fd_sc_hd__decap_6
XFILLER_145_1366 VPWR VGND VPWR VGND sky130_ef_sc_hd__decap_12
XFILLER_93_1298 VPWR VGND VPWR VGND sky130_ef_sc_hd__decap_12
XFILLER_211_385 VGND VGND VPWR VPWR sky130_fd_sc_hd__decap_6
XFILLER_196_587 VGND VGND VPWR VPWR sky130_fd_sc_hd__fill_1
XFILLER_128_109 VPWR VGND VPWR VGND sky130_ef_sc_hd__decap_12
XFILLER_71_1552 VGND VGND VPWR VPWR sky130_fd_sc_hd__fill_1
XPHY_EDGE_ROW_16_2_Left_448 VGND VGND VPWR VPWR sky130_fd_sc_hd__decap_3
XFILLER_184_749 VGND VGND VPWR VPWR sky130_fd_sc_hd__decap_6
XFILLER_183_237 VPWR VGND VPWR VGND sky130_ef_sc_hd__decap_12
XFILLER_168_289 VPWR VGND VPWR VGND sky130_ef_sc_hd__decap_12
XFILLER_128_3 VPWR VGND VPWR VGND sky130_ef_sc_hd__decap_12
XFILLER_7_417 VGND VGND VPWR VPWR sky130_fd_sc_hd__decap_3
XFILLER_23_65 VGND VGND VPWR VPWR sky130_fd_sc_hd__fill_1
XPHY_EDGE_ROW_156_1_Right_742 VGND VGND VPWR VPWR sky130_fd_sc_hd__decap_3
XFILLER_192_793 VPWR VGND VPWR VGND sky130_ef_sc_hd__decap_12
XFILLER_99_69 VPWR VGND VPWR VGND sky130_ef_sc_hd__decap_12
XFILLER_191_281 VPWR VGND VPWR VGND sky130_ef_sc_hd__decap_12
XFILLER_178_1197 VGND VGND VPWR VPWR sky130_fd_sc_hd__decap_6
XFILLER_174_1017 VPWR VGND VPWR VGND sky130_ef_sc_hd__decap_12
XFILLER_30_1282 VPWR VGND VPWR VGND sky130_ef_sc_hd__decap_12
XFILLER_219_1161 VPWR VGND VPWR VGND sky130_ef_sc_hd__decap_12
XFILLER_156_1462 VGND VGND VPWR VPWR sky130_fd_sc_hd__decap_6
XPHY_EDGE_ROW_78_2_Left_510 VGND VGND VPWR VPWR sky130_fd_sc_hd__decap_3
XFILLER_152_1326 VPWR VGND VPWR VGND sky130_ef_sc_hd__decap_12
XPHY_EDGE_ROW_130_2_Left_562 VGND VGND VPWR VPWR sky130_fd_sc_hd__decap_3
XFILLER_65_1378 VGND VGND VPWR VPWR sky130_fd_sc_hd__decap_6
XTAP_TAPCELL_ROW_38_2_3225 VGND VPWR sky130_fd_sc_hd__tapvpwrvgnd_1
XTAP_TAPCELL_ROW_7_984 VGND VPWR sky130_fd_sc_hd__tapvpwrvgnd_1
XTAP_TAPCELL_ROW_7_995 VGND VPWR sky130_fd_sc_hd__tapvpwrvgnd_1
XFILLER_130_1602 VGND VGND VPWR VPWR sky130_fd_sc_hd__decap_3
XFILLER_8_1294 VGND VGND VPWR VPWR sky130_fd_sc_hd__decap_6
XFILLER_4_1147 VGND VGND VPWR VPWR sky130_fd_sc_hd__fill_1
XFILLER_185_1113 VGND VGND VPWR VPWR sky130_fd_sc_hd__decap_6
XFILLER_185_1157 VPWR VGND VPWR VGND sky130_ef_sc_hd__decap_12
XFILLER_64_83 VGND VGND VPWR VPWR sky130_fd_sc_hd__fill_1
XFILLER_203_853 VPWR VGND VPWR VGND sky130_ef_sc_hd__decap_12
XFILLER_124_1406 VGND VGND VPWR VPWR sky130_fd_sc_hd__decap_6
XFILLER_72_1338 VPWR VGND VPWR VGND sky130_ef_sc_hd__decap_12
XANTENNA__623__CLK clknet_3_6_0_clk VGND VGND VPWR VPWR sky130_fd_sc_hd__diode_2
XFILLER_203_897 VPWR VGND VPWR VGND sky130_ef_sc_hd__decap_12
XFILLER_202_363 VGND VGND VPWR VPWR sky130_fd_sc_hd__fill_1
XFILLER_175_727 VGND VGND VPWR VPWR sky130_fd_sc_hd__fill_1
XFILLER_204_1441 VPWR VGND VPWR VGND sky130_ef_sc_hd__decap_12
X_328_ b_addr\[3\] net6 net140 VGND VGND VPWR VPWR s_addr\[3\] sky130_fd_sc_hd__mux2_1
XFILLER_204_1485 VPWR VGND VPWR VGND sky130_ef_sc_hd__decap_12
XTAP_TAPCELL_ROW_155_2_3988 VGND VPWR sky130_fd_sc_hd__tapvpwrvgnd_1
XFILLER_196_1253 VGND VGND VPWR VPWR sky130_fd_sc_hd__decap_6
XFILLER_171_933 VPWR VGND VPWR VGND sky130_ef_sc_hd__decap_12
XFILLER_196_1297 VPWR VGND VPWR VGND sky130_ef_sc_hd__decap_12
XFILLER_192_1117 VPWR VGND VPWR VGND sky130_ef_sc_hd__decap_12
XFILLER_170_421 VPWR VGND VPWR VGND sky130_ef_sc_hd__decap_12
XTAP_TAPCELL_ROW_124_1_1265 VGND VPWR sky130_fd_sc_hd__tapvpwrvgnd_1
XFILLER_100_1450 VPWR VGND VPWR VGND sky130_ef_sc_hd__decap_12
XFILLER_171_977 VPWR VGND VPWR VGND sky130_ef_sc_hd__decap_12
XTAP_TAPCELL_ROW_135_2_3853 VGND VPWR sky130_fd_sc_hd__tapvpwrvgnd_1
XFILLER_100_1494 VPWR VGND VPWR VGND sky130_ef_sc_hd__decap_12
XFILLER_83_1434 VGND VGND VPWR VPWR sky130_fd_sc_hd__decap_6
XFILLER_43_3 VPWR VGND VPWR VGND sky130_ef_sc_hd__decap_12
XPHY_EDGE_ROW_62_2_Left_494 VGND VGND VPWR VPWR sky130_fd_sc_hd__decap_3
XFILLER_174_1595 VGND VGND VPWR VPWR sky130_fd_sc_hd__fill_1
XFILLER_135_1546 VGND VGND VPWR VPWR sky130_fd_sc_hd__decap_6
XFILLER_83_1478 VPWR VGND VPWR VGND sky130_ef_sc_hd__decap_12
XFILLER_211_1401 VPWR VGND VPWR VGND sky130_ef_sc_hd__decap_12
XFILLER_215_1581 VPWR VGND VPWR VGND sky130_ef_sc_hd__decap_12
XFILLER_213_617 VPWR VGND VPWR VGND sky130_ef_sc_hd__decap_12
XFILLER_129_1328 VGND VGND VPWR VPWR sky130_fd_sc_hd__fill_1
XFILLER_111_1590 VPWR VGND VPWR VGND sky130_ef_sc_hd__decap_12
XFILLER_20_1462 VGND VGND VPWR VPWR sky130_fd_sc_hd__decap_6
XFILLER_197_329 VGND VGND VPWR VPWR sky130_fd_sc_hd__decap_6
XFILLER_181_1511 VGND VGND VPWR VPWR sky130_fd_sc_hd__fill_1
XFILLER_94_1574 VGND VGND VPWR VPWR sky130_fd_sc_hd__decap_6
XFILLER_142_1506 VPWR VGND VPWR VGND sky130_ef_sc_hd__decap_12
XFILLER_100_15 VPWR VGND VPWR VGND sky130_ef_sc_hd__decap_12
XFILLER_90_1438 VPWR VGND VPWR VGND sky130_ef_sc_hd__decap_12
XANTENNA__395__B1 net156 VGND VGND VPWR VPWR sky130_fd_sc_hd__diode_2
XFILLER_178_587 VGND VGND VPWR VPWR sky130_fd_sc_hd__fill_1
XFILLER_166_749 VGND VGND VPWR VPWR sky130_fd_sc_hd__decap_6
XFILLER_165_237 VPWR VGND VPWR VGND sky130_ef_sc_hd__decap_12
XPHY_EDGE_ROW_126_1_Left_345 VGND VGND VPWR VPWR sky130_fd_sc_hd__decap_3
XFILLER_14_1244 VGND VGND VPWR VPWR sky130_fd_sc_hd__fill_1
XFILLER_174_793 VPWR VGND VPWR VGND sky130_ef_sc_hd__decap_12
XFILLER_88_1356 VGND VGND VPWR VPWR sky130_fd_sc_hd__fill_1
XFILLER_175_1337 VGND VGND VPWR VPWR sky130_fd_sc_hd__decap_6
XFILLER_173_281 VPWR VGND VPWR VGND sky130_ef_sc_hd__decap_12
XFILLER_109_57 VPWR VGND VPWR VGND sky130_ef_sc_hd__decap_12
XFILLER_69_39 VPWR VGND VPWR VGND sky130_ef_sc_hd__decap_12
XFILLER_192_29 VPWR VGND VPWR VGND sky130_ef_sc_hd__decap_12
XFILLER_153_1602 VGND VGND VPWR VPWR sky130_fd_sc_hd__decap_3
XTAP_TAPCELL_ROW_24_2_3133 VGND VPWR sky130_fd_sc_hd__tapvpwrvgnd_1
XFILLER_62_1518 VGND VGND VPWR VPWR sky130_fd_sc_hd__decap_6
XTAP_TAPCELL_ROW_4_910 VGND VPWR sky130_fd_sc_hd__tapvpwrvgnd_1
XTAP_TAPCELL_ROW_149_1_1316 VGND VPWR sky130_fd_sc_hd__tapvpwrvgnd_1
XFILLER_85_27 VPWR VGND VPWR VGND sky130_ef_sc_hd__decap_12
XFILLER_5_1401 VPWR VGND VPWR VGND sky130_ef_sc_hd__decap_12
XFILLER_60_1220 VPWR VGND VPWR VGND sky130_ef_sc_hd__decap_12
XFILLER_214_1091 VGND VGND VPWR VPWR sky130_fd_sc_hd__fill_1
XTAP_TAPCELL_ROW_184_1983 VGND VPWR sky130_fd_sc_hd__tapvpwrvgnd_1
XTAP_TAPCELL_ROW_184_1972 VGND VPWR sky130_fd_sc_hd__tapvpwrvgnd_1
XFILLER_169_1119 VGND VGND VPWR VPWR sky130_fd_sc_hd__fill_1
XFILLER_25_1384 VGND VGND VPWR VPWR sky130_fd_sc_hd__fill_1
XFILLER_217_945 VGND VGND VPWR VPWR sky130_fd_sc_hd__decap_6
XFILLER_216_433 VPWR VGND VPWR VGND sky130_ef_sc_hd__decap_12
XTAP_TAPCELL_ROW_184_1994 VGND VPWR sky130_fd_sc_hd__tapvpwrvgnd_1
XTAP_TAPCELL_ROW_180_1858 VGND VPWR sky130_fd_sc_hd__tapvpwrvgnd_1
XFILLER_141_55 VGND VGND VPWR VPWR sky130_fd_sc_hd__fill_1
XFILLER_18_65 VGND VGND VPWR VPWR sky130_fd_sc_hd__fill_1
XFILLER_217_989 VPWR VGND VPWR VGND sky130_ef_sc_hd__decap_12
XFILLER_216_477 VPWR VGND VPWR VGND sky130_ef_sc_hd__decap_12
XFILLER_186_1477 VGND VGND VPWR VPWR sky130_fd_sc_hd__decap_6
XTAP_TAPCELL_ROW_180_1869 VGND VPWR sky130_fd_sc_hd__tapvpwrvgnd_1
XFILLER_99_1496 VGND VGND VPWR VPWR sky130_fd_sc_hd__fill_1
XFILLER_203_105 VGND VGND VPWR VPWR sky130_fd_sc_hd__decap_6
XFILLER_188_307 VGND VGND VPWR VPWR sky130_fd_sc_hd__fill_1
XFILLER_70_121 VGND VGND VPWR VPWR sky130_fd_sc_hd__decap_6
XFILLER_203_149 VPWR VGND VPWR VGND sky130_ef_sc_hd__decap_12
XFILLER_197_841 VPWR VGND VPWR VGND sky130_ef_sc_hd__decap_12
XFILLER_34_53 VGND VGND VPWR VPWR sky130_fd_sc_hd__decap_8
XFILLER_34_97 VGND VGND VPWR VPWR sky130_fd_sc_hd__decap_4
XPHY_EDGE_ROW_58_1_Left_277 VGND VGND VPWR VPWR sky130_fd_sc_hd__decap_3
XFILLER_211_193 VPWR VGND VPWR VGND sky130_ef_sc_hd__decap_12
XFILLER_200_867 VGND VGND VPWR VPWR sky130_fd_sc_hd__fill_1
XFILLER_184_513 VPWR VGND VPWR VGND sky130_ef_sc_hd__decap_12
XTAP_TAPCELL_ROW_141_2_3896 VGND VPWR sky130_fd_sc_hd__tapvpwrvgnd_1
XFILLER_32_1300 VGND VGND VPWR VPWR sky130_fd_sc_hd__fill_1
XFILLER_184_557 VPWR VGND VPWR VGND sky130_ef_sc_hd__decap_12
XFILLER_7_225 VPWR VGND VPWR VGND sky130_ef_sc_hd__decap_12
XFILLER_50_41 VPWR VGND VPWR VGND sky130_ef_sc_hd__decap_12
XFILLER_166_41 VPWR VGND VPWR VGND sky130_ef_sc_hd__decap_12
XPHY_EDGE_ROW_157_1_Right_743 VGND VGND VPWR VPWR sky130_fd_sc_hd__decap_3
XFILLER_50_85 VPWR VGND VPWR VGND sky130_ef_sc_hd__decap_12
XFILLER_193_1437 VPWR VGND VPWR VGND sky130_ef_sc_hd__decap_12
XFILLER_166_85 VPWR VGND VPWR VGND sky130_ef_sc_hd__decap_12
XFILLER_158_1524 VGND VGND VPWR VPWR sky130_fd_sc_hd__fill_1
XFILLER_3_431 VGND VGND VPWR VPWR sky130_fd_sc_hd__fill_1
XFILLER_156_1270 VPWR VGND VPWR VGND sky130_ef_sc_hd__decap_12
XFILLER_117_1232 VPWR VGND VPWR VGND sky130_ef_sc_hd__decap_12
XFILLER_117_1298 VPWR VGND VPWR VGND sky130_ef_sc_hd__decap_12
XFILLER_43_1440 VGND VGND VPWR VPWR sky130_fd_sc_hd__fill_1
XFILLER_208_923 VGND VGND VPWR VPWR sky130_fd_sc_hd__fill_1
XTAP_TAPCELL_ROW_68_2_3420 VGND VPWR sky130_fd_sc_hd__tapvpwrvgnd_1
XFILLER_219_293 VPWR VGND VPWR VGND sky130_ef_sc_hd__decap_12
XFILLER_75_93 VPWR VGND VPWR VGND sky130_ef_sc_hd__decap_12
XFILLER_179_329 VGND VGND VPWR VPWR sky130_fd_sc_hd__decap_6
XFILLER_201_69 VPWR VGND VPWR VGND sky130_ef_sc_hd__decap_12
XFILLER_128_1350 VGND VGND VPWR VPWR sky130_fd_sc_hd__decap_6
XFILLER_76_1282 VPWR VGND VPWR VGND sky130_ef_sc_hd__decap_12
XFILLER_37_1244 VPWR VGND VPWR VGND sky130_ef_sc_hd__decap_12
XFILLER_128_1394 VPWR VGND VPWR VGND sky130_ef_sc_hd__decap_12
XFILLER_91_81 VPWR VGND VPWR VGND sky130_ef_sc_hd__decap_12
XFILLER_198_1315 VGND VGND VPWR VPWR sky130_fd_sc_hd__fill_1
XFILLER_187_373 VPWR VGND VPWR VGND sky130_ef_sc_hd__decap_12
XFILLER_163_1285 VGND VGND VPWR VPWR sky130_fd_sc_hd__decap_3
XFILLER_124_1258 VPWR VGND VPWR VGND sky130_ef_sc_hd__decap_12
XFILLER_54_1580 VGND VGND VPWR VPWR sky130_fd_sc_hd__fill_1
XTAP_TAPCELL_ROW_190_2165 VGND VPWR sky130_fd_sc_hd__tapvpwrvgnd_1
XTAP_TAPCELL_ROW_190_2154 VGND VPWR sky130_fd_sc_hd__tapvpwrvgnd_1
XTAP_TAPCELL_ROW_190_2143 VGND VPWR sky130_fd_sc_hd__tapvpwrvgnd_1
XTAP_TAPCELL_ROW_30_2_3176 VGND VPWR sky130_fd_sc_hd__tapvpwrvgnd_1
XTAP_TAPCELL_ROW_215_2872 VGND VPWR sky130_fd_sc_hd__tapvpwrvgnd_1
XTAP_TAPCELL_ROW_215_2861 VGND VPWR sky130_fd_sc_hd__tapvpwrvgnd_1
XFILLER_196_1061 VPWR VGND VPWR VGND sky130_ef_sc_hd__decap_12
XFILLER_171_741 VPWR VGND VPWR VGND sky130_ef_sc_hd__decap_12
XFILLER_7_781 VGND VGND VPWR VPWR sky130_fd_sc_hd__decap_3
XTAP_TAPCELL_ROW_10_2_3041 VGND VPWR sky130_fd_sc_hd__tapvpwrvgnd_1
XTAP_TAPCELL_ROW_211_2758 VGND VPWR sky130_fd_sc_hd__tapvpwrvgnd_1
XTAP_TAPCELL_ROW_211_2747 VGND VPWR sky130_fd_sc_hd__tapvpwrvgnd_1
XFILLER_171_785 VPWR VGND VPWR VGND sky130_ef_sc_hd__decap_12
XFILLER_170_251 VGND VGND VPWR VPWR sky130_fd_sc_hd__fill_1
XFILLER_83_1220 VPWR VGND VPWR VGND sky130_ef_sc_hd__decap_12
XTAP_TAPCELL_ROW_60_1_1137 VGND VPWR sky130_fd_sc_hd__tapvpwrvgnd_1
XFILLER_139_1490 VGND VGND VPWR VPWR sky130_fd_sc_hd__decap_6
XFILLER_135_1310 VPWR VGND VPWR VGND sky130_ef_sc_hd__decap_12
XTAP_TAPCELL_ROW_188_2094 VGND VPWR sky130_fd_sc_hd__tapvpwrvgnd_1
XFILLER_135_1354 VPWR VGND VPWR VGND sky130_ef_sc_hd__decap_12
XFILLER_83_1286 VPWR VGND VPWR VGND sky130_ef_sc_hd__decap_12
XFILLER_211_1231 VGND VGND VPWR VPWR sky130_fd_sc_hd__fill_1
XTAP_TAPCELL_ROW_209_2698 VGND VPWR sky130_fd_sc_hd__tapvpwrvgnd_1
XTAP_TAPCELL_ROW_209_2687 VGND VPWR sky130_fd_sc_hd__tapvpwrvgnd_1
XFILLER_135_1398 VPWR VGND VPWR VGND sky130_ef_sc_hd__decap_12
XFILLER_22_1524 VGND VGND VPWR VPWR sky130_fd_sc_hd__fill_1
XTAP_TAPCELL_ROW_159_2_4013 VGND VPWR sky130_fd_sc_hd__tapvpwrvgnd_1
XFILLER_168_1141 VGND VGND VPWR VPWR sky130_fd_sc_hd__decap_6
XFILLER_52_110 VPWR VGND VPWR VGND sky130_ef_sc_hd__decap_12
XFILLER_214_937 VPWR VGND VPWR VGND sky130_ef_sc_hd__decap_12
XFILLER_168_1185 VPWR VGND VPWR VGND sky130_ef_sc_hd__decap_12
XFILLER_164_1005 VPWR VGND VPWR VGND sky130_ef_sc_hd__decap_12
XFILLER_20_1270 VPWR VGND VPWR VGND sky130_ef_sc_hd__decap_12
XFILLER_213_447 VGND VGND VPWR VPWR sky130_fd_sc_hd__fill_1
XFILLER_201_609 VGND VGND VPWR VPWR sky130_fd_sc_hd__decap_6
XFILLER_197_137 VPWR VGND VPWR VGND sky130_ef_sc_hd__decap_12
XFILLER_179_841 VPWR VGND VPWR VGND sky130_ef_sc_hd__decap_12
XFILLER_164_1049 VPWR VGND VPWR VGND sky130_ef_sc_hd__decap_12
XFILLER_146_1450 VPWR VGND VPWR VGND sky130_ef_sc_hd__decap_12
XFILLER_111_69 VPWR VGND VPWR VGND sky130_ef_sc_hd__decap_12
XFILLER_94_1382 VPWR VGND VPWR VGND sky130_ef_sc_hd__decap_12
XFILLER_0_1397 VGND VGND VPWR VPWR sky130_fd_sc_hd__decap_3
XFILLER_55_1322 VGND VGND VPWR VPWR sky130_fd_sc_hd__decap_6
XFILLER_142_1314 VPWR VGND VPWR VGND sky130_ef_sc_hd__decap_12
XFILLER_107_1434 VGND VGND VPWR VPWR sky130_fd_sc_hd__decap_6
XFILLER_90_1246 VPWR VGND VPWR VGND sky130_ef_sc_hd__decap_12
XANTENNA_fanout140_X net140 VGND VGND VPWR VPWR sky130_fd_sc_hd__diode_2
XFILLER_55_1366 VPWR VGND VPWR VGND sky130_ef_sc_hd__decap_12
XFILLER_205_1057 VGND VGND VPWR VPWR sky130_fd_sc_hd__decap_6
XFILLER_194_811 VGND VGND VPWR VPWR sky130_fd_sc_hd__fill_1
XFILLER_166_513 VPWR VGND VPWR VGND sky130_ef_sc_hd__decap_12
XFILLER_146_1494 VPWR VGND VPWR VGND sky130_ef_sc_hd__decap_12
XFILLER_142_1358 VPWR VGND VPWR VGND sky130_ef_sc_hd__decap_12
XTAP_TAPCELL_ROW_126_2_3798 VGND VPWR sky130_fd_sc_hd__tapvpwrvgnd_1
XFILLER_166_557 VPWR VGND VPWR VGND sky130_ef_sc_hd__decap_12
XFILLER_107_1478 VPWR VGND VPWR VGND sky130_ef_sc_hd__decap_12
XTAP_TAPCELL_ROW_94_2_3587 VGND VPWR sky130_fd_sc_hd__tapvpwrvgnd_1
XFILLER_181_505 VPWR VGND VPWR VGND sky130_ef_sc_hd__decap_12
XTAP_TAPCELL_ROW_173_1662 VGND VPWR sky130_fd_sc_hd__tapvpwrvgnd_1
XFILLER_5_729 VGND VGND VPWR VPWR sky130_fd_sc_hd__fill_2
XFILLER_179_1281 VGND VGND VPWR VPWR sky130_fd_sc_hd__decap_6
XFILLER_175_1101 VPWR VGND VPWR VGND sky130_ef_sc_hd__decap_12
XTAP_TAPCELL_ROW_173_1684 VGND VPWR sky130_fd_sc_hd__tapvpwrvgnd_1
XTAP_TAPCELL_ROW_173_1673 VGND VPWR sky130_fd_sc_hd__tapvpwrvgnd_1
XFILLER_218_1429 VPWR VGND VPWR VGND sky130_ef_sc_hd__decap_12
XFILLER_175_1145 VPWR VGND VPWR VGND sky130_ef_sc_hd__decap_12
XFILLER_20_44 VPWR VGND VPWR VGND sky130_ef_sc_hd__decap_12
XFILLER_175_1189 VPWR VGND VPWR VGND sky130_ef_sc_hd__decap_12
XFILLER_171_1009 VPWR VGND VPWR VGND sky130_ef_sc_hd__decap_12
XFILLER_153_1410 VPWR VGND VPWR VGND sky130_ef_sc_hd__decap_12
XFILLER_136_77 VGND VGND VPWR VPWR sky130_fd_sc_hd__decap_6
XFILLER_96_15 VPWR VGND VPWR VGND sky130_ef_sc_hd__decap_12
XFILLER_66_1462 VGND VGND VPWR VPWR sky130_fd_sc_hd__decap_6
XFILLER_157_1590 VPWR VGND VPWR VGND sky130_ef_sc_hd__decap_12
XFILLER_0_445 VGND VGND VPWR VPWR sky130_fd_sc_hd__decap_3
XFILLER_62_1326 VPWR VGND VPWR VGND sky130_ef_sc_hd__decap_12
XFILLER_216_1197 VGND VGND VPWR VPWR sky130_fd_sc_hd__decap_6
XFILLER_212_1017 VPWR VGND VPWR VGND sky130_ef_sc_hd__decap_12
XFILLER_209_709 VPWR VGND VPWR VGND sky130_ef_sc_hd__decap_12
XFILLER_195_3 VPWR VGND VPWR VGND sky130_ef_sc_hd__decap_12
XFILLER_153_1454 VPWR VGND VPWR VGND sky130_ef_sc_hd__decap_12
XFILLER_118_1574 VGND VGND VPWR VPWR sky130_fd_sc_hd__decap_6
XFILLER_114_1438 VPWR VGND VPWR VGND sky130_ef_sc_hd__decap_12
XTAP_TAPCELL_ROW_167_1488 VGND VPWR sky130_fd_sc_hd__tapvpwrvgnd_1
XFILLER_153_1498 VPWR VGND VPWR VGND sky130_ef_sc_hd__decap_12
XFILLER_5_1231 VGND VGND VPWR VPWR sky130_fd_sc_hd__fill_1
XFILLER_40_1602 VGND VGND VPWR VPWR sky130_fd_sc_hd__decap_3
XFILLER_188_1539 VGND VGND VPWR VPWR sky130_fd_sc_hd__fill_1
XTAP_TAPCELL_ROW_167_1499 VGND VPWR sky130_fd_sc_hd__tapvpwrvgnd_1
XFILLER_152_65 VPWR VGND VPWR VGND sky130_ef_sc_hd__decap_12
XFILLER_217_753 VPWR VGND VPWR VGND sky130_ef_sc_hd__decap_12
XFILLER_186_1241 VPWR VGND VPWR VGND sky130_ef_sc_hd__decap_12
XFILLER_217_797 VPWR VGND VPWR VGND sky130_ef_sc_hd__decap_12
XFILLER_186_1285 VPWR VGND VPWR VGND sky130_ef_sc_hd__decap_12
XFILLER_182_1105 VPWR VGND VPWR VGND sky130_ef_sc_hd__decap_12
X_593_ clknet_3_3_0_clk _027_ VGND VGND VPWR VPWR net68 sky130_fd_sc_hd__dfxtp_1
XFILLER_204_469 VGND VGND VPWR VPWR sky130_fd_sc_hd__decap_6
XFILLER_182_1149 VPWR VGND VPWR VGND sky130_ef_sc_hd__decap_12
XFILLER_73_1422 VPWR VGND VPWR VGND sky130_ef_sc_hd__decap_12
Xclkbuf_3_0_0_clk clknet_0_clk VGND VGND VPWR VPWR clknet_3_0_0_clk sky130_fd_sc_hd__clkbuf_8
XFILLER_160_1414 VPWR VGND VPWR VGND sky130_ef_sc_hd__decap_12
XFILLER_73_1466 VPWR VGND VPWR VGND sky130_ef_sc_hd__decap_12
XFILLER_34_1406 VGND VGND VPWR VPWR sky130_fd_sc_hd__decap_6
XFILLER_197_671 VGND VGND VPWR VPWR sky130_fd_sc_hd__fill_1
XFILLER_185_833 VGND VGND VPWR VPWR sky130_fd_sc_hd__decap_6
XFILLER_169_373 VPWR VGND VPWR VGND sky130_ef_sc_hd__decap_12
XFILLER_125_1534 VPWR VGND VPWR VGND sky130_ef_sc_hd__decap_12
XTAP_TAPCELL_ROW_15_2_3078 VGND VPWR sky130_fd_sc_hd__tapvpwrvgnd_1
XFILLER_61_51 VGND VGND VPWR VPWR sky130_fd_sc_hd__decap_4
XFILLER_185_877 VPWR VGND VPWR VGND sky130_ef_sc_hd__decap_12
XFILLER_184_321 VPWR VGND VPWR VGND sky130_ef_sc_hd__decap_12
XFILLER_177_51 VGND VGND VPWR VPWR sky130_fd_sc_hd__decap_4
XFILLER_125_1578 VPWR VGND VPWR VGND sky130_ef_sc_hd__decap_12
XFILLER_201_1455 VGND VGND VPWR VPWR sky130_fd_sc_hd__fill_1
XFILLER_184_365 VPWR VGND VPWR VGND sky130_ef_sc_hd__decap_12
XFILLER_193_1201 VPWR VGND VPWR VGND sky130_ef_sc_hd__decap_12
XFILLER_197_1381 VPWR VGND VPWR VGND sky130_ef_sc_hd__decap_12
XFILLER_193_1245 VPWR VGND VPWR VGND sky130_ef_sc_hd__decap_12
XPHY_EDGE_ROW_158_1_Right_744 VGND VGND VPWR VPWR sky130_fd_sc_hd__decap_3
XFILLER_10_1450 VPWR VGND VPWR VGND sky130_ef_sc_hd__decap_12
XFILLER_3_261 VGND VGND VPWR VPWR sky130_fd_sc_hd__fill_1
XFILLER_10_1494 VPWR VGND VPWR VGND sky130_ef_sc_hd__decap_12
XFILLER_193_1289 VPWR VGND VPWR VGND sky130_ef_sc_hd__decap_12
XFILLER_84_1562 VPWR VGND VPWR VGND sky130_ef_sc_hd__decap_12
XFILLER_80_1426 VPWR VGND VPWR VGND sky130_ef_sc_hd__decap_12
XFILLER_45_1546 VGND VGND VPWR VPWR sky130_fd_sc_hd__decap_6
XTAP_TAPCELL_ROW_7_1001 VGND VPWR sky130_fd_sc_hd__tapvpwrvgnd_1
XFILLER_6_1017 VPWR VGND VPWR VGND sky130_ef_sc_hd__decap_12
XFILLER_132_1538 VPWR VGND VPWR VGND sky130_ef_sc_hd__decap_12
XTAP_TAPCELL_ROW_7_1012 VGND VPWR sky130_fd_sc_hd__tapvpwrvgnd_1
XTAP_TAPCELL_ROW_7_1023 VGND VPWR sky130_fd_sc_hd__tapvpwrvgnd_1
XTAP_TAPCELL_ROW_7_1034 VGND VPWR sky130_fd_sc_hd__tapvpwrvgnd_1
XFILLER_78_1300 VGND VGND VPWR VPWR sky130_fd_sc_hd__fill_1
XFILLER_212_1595 VGND VGND VPWR VPWR sky130_fd_sc_hd__fill_1
XTAP_TAPCELL_ROW_204_2551 VGND VPWR sky130_fd_sc_hd__tapvpwrvgnd_1
XTAP_TAPCELL_ROW_204_2540 VGND VPWR sky130_fd_sc_hd__tapvpwrvgnd_1
XTAP_TAPCELL_ROW_204_2562 VGND VPWR sky130_fd_sc_hd__tapvpwrvgnd_1
XTAP_TAPCELL_ROW_200_2426 VGND VPWR sky130_fd_sc_hd__tapvpwrvgnd_1
XFILLER_165_1325 VPWR VGND VPWR VGND sky130_ef_sc_hd__decap_12
XFILLER_21_1590 VPWR VGND VPWR VGND sky130_ef_sc_hd__decap_12
XFILLER_39_1328 VGND VGND VPWR VPWR sky130_fd_sc_hd__fill_1
XTAP_TAPCELL_ROW_200_2448 VGND VPWR sky130_fd_sc_hd__tapvpwrvgnd_1
XTAP_TAPCELL_ROW_200_2437 VGND VPWR sky130_fd_sc_hd__tapvpwrvgnd_1
XTAP_TAPCELL_ROW_196_2330 VGND VPWR sky130_fd_sc_hd__tapvpwrvgnd_1
XFILLER_179_137 VPWR VGND VPWR VGND sky130_ef_sc_hd__decap_12
XFILLER_91_1522 VPWR VGND VPWR VGND sky130_ef_sc_hd__decap_12
XFILLER_204_981 VPWR VGND VPWR VGND sky130_ef_sc_hd__decap_12
XTAP_TAPCELL_ROW_192_2216 VGND VPWR sky130_fd_sc_hd__tapvpwrvgnd_1
XTAP_TAPCELL_ROW_192_2205 VGND VPWR sky130_fd_sc_hd__tapvpwrvgnd_1
XFILLER_165_1369 VPWR VGND VPWR VGND sky130_ef_sc_hd__decap_12
XFILLER_52_1506 VPWR VGND VPWR VGND sky130_ef_sc_hd__decap_12
XTAP_TAPCELL_ROW_217_2923 VGND VPWR sky130_fd_sc_hd__tapvpwrvgnd_1
XTAP_TAPCELL_ROW_217_2912 VGND VPWR sky130_fd_sc_hd__tapvpwrvgnd_1
XFILLER_188_693 VGND VGND VPWR VPWR sky130_fd_sc_hd__decap_6
XFILLER_176_811 VGND VGND VPWR VPWR sky130_fd_sc_hd__fill_1
XFILLER_91_1566 VPWR VGND VPWR VGND sky130_ef_sc_hd__decap_12
XTAP_TAPCELL_ROW_79_2_3489 VGND VPWR sky130_fd_sc_hd__tapvpwrvgnd_1
XTAP_TAPCELL_ROW_80_2_3495 VGND VPWR sky130_fd_sc_hd__tapvpwrvgnd_1
XANTENNA__591__Q b_addr\[7\] VGND VGND VPWR VPWR sky130_fd_sc_hd__diode_2
XTAP_TAPCELL_ROW_217_2934 VGND VPWR sky130_fd_sc_hd__tapvpwrvgnd_1
XFILLER_187_181 VPWR VGND VPWR VGND sky130_ef_sc_hd__decap_12
XFILLER_163_1093 VPWR VGND VPWR VGND sky130_ef_sc_hd__decap_12
XTAP_TAPCELL_ROW_213_2809 VGND VPWR sky130_fd_sc_hd__tapvpwrvgnd_1
XFILLER_163_505 VPWR VGND VPWR VGND sky130_ef_sc_hd__decap_12
XFILLER_89_1440 VGND VGND VPWR VPWR sky130_fd_sc_hd__fill_1
XPHY_EDGE_ROW_6_Right_6 VGND VGND VPWR VPWR sky130_fd_sc_hd__decap_3
XFILLER_176_1421 VGND VGND VPWR VPWR sky130_fd_sc_hd__decap_6
XTAP_TAPCELL_ROW_60_2_3371 VGND VPWR sky130_fd_sc_hd__tapvpwrvgnd_1
XFILLER_190_357 VGND VGND VPWR VPWR sky130_fd_sc_hd__decap_6
XFILLER_176_1465 VPWR VGND VPWR VGND sky130_ef_sc_hd__decap_12
XFILLER_172_1329 VPWR VGND VPWR VGND sky130_ef_sc_hd__decap_12
XFILLER_63_1602 VGND VGND VPWR VPWR sky130_fd_sc_hd__decap_3
XFILLER_1_209 VGND VGND VPWR VPWR sky130_fd_sc_hd__fill_2
XTAP_TAPCELL_ROW_39_2_3230 VGND VPWR sky130_fd_sc_hd__tapvpwrvgnd_1
XFILLER_213_1337 VGND VGND VPWR VPWR sky130_fd_sc_hd__decap_6
XFILLER_66_29 VPWR VGND VPWR VGND sky130_ef_sc_hd__decap_12
XPHY_EDGE_ROW_25_2_Left_457 VGND VGND VPWR VPWR sky130_fd_sc_hd__decap_3
XTAP_TAPCELL_ROW_52_2_3319 VGND VPWR sky130_fd_sc_hd__tapvpwrvgnd_1
XFILLER_214_701 VPWR VGND VPWR VGND sky130_ef_sc_hd__decap_12
XFILLER_6_1595 VGND VGND VPWR VPWR sky130_fd_sc_hd__fill_1
XFILLER_187_1561 VGND VGND VPWR VPWR sky130_fd_sc_hd__decap_6
XFILLER_207_1119 VGND VGND VPWR VPWR sky130_fd_sc_hd__fill_1
XFILLER_198_413 VGND VGND VPWR VPWR sky130_fd_sc_hd__decap_6
XFILLER_183_1425 VPWR VGND VPWR VGND sky130_ef_sc_hd__decap_12
XFILLER_0_1161 VPWR VGND VPWR VGND sky130_ef_sc_hd__decap_12
XFILLER_201_417 VPWR VGND VPWR VGND sky130_ef_sc_hd__decap_12
XFILLER_198_457 VPWR VGND VPWR VGND sky130_ef_sc_hd__decap_12
XFILLER_183_1469 VPWR VGND VPWR VGND sky130_ef_sc_hd__decap_12
XFILLER_15_55 VGND VGND VPWR VPWR sky130_fd_sc_hd__fill_1
XFILLER_179_671 VGND VGND VPWR VPWR sky130_fd_sc_hd__fill_1
XFILLER_167_833 VGND VGND VPWR VPWR sky130_fd_sc_hd__decap_6
XFILLER_107_1220 VPWR VGND VPWR VGND sky130_ef_sc_hd__decap_12
XFILLER_15_88 VGND VGND VPWR VPWR sky130_fd_sc_hd__fill_1
XFILLER_210_973 VGND VGND VPWR VPWR sky130_fd_sc_hd__decap_6
XTAP_TAPCELL_ROW_175_1735 VGND VPWR sky130_fd_sc_hd__tapvpwrvgnd_1
XTAP_TAPCELL_ROW_175_1724 VGND VPWR sky130_fd_sc_hd__tapvpwrvgnd_1
XFILLER_166_321 VPWR VGND VPWR VGND sky130_ef_sc_hd__decap_12
XFILLER_107_1286 VPWR VGND VPWR VGND sky130_ef_sc_hd__decap_12
XFILLER_182_825 VPWR VGND VPWR VGND sky130_ef_sc_hd__decap_12
XFILLER_167_877 VPWR VGND VPWR VGND sky130_ef_sc_hd__decap_12
XFILLER_166_365 VPWR VGND VPWR VGND sky130_ef_sc_hd__decap_12
XTAP_TAPCELL_ROW_156_2_3993 VGND VPWR sky130_fd_sc_hd__tapvpwrvgnd_1
XFILLER_182_869 VPWR VGND VPWR VGND sky130_ef_sc_hd__decap_12
XFILLER_181_335 VGND VGND VPWR VPWR sky130_fd_sc_hd__fill_1
XFILLER_110_3 VPWR VGND VPWR VGND sky130_ef_sc_hd__decap_12
XFILLER_208_3 VPWR VGND VPWR VGND sky130_ef_sc_hd__decap_12
XFILLER_194_1521 VPWR VGND VPWR VGND sky130_ef_sc_hd__decap_12
XFILLER_68_1524 VGND VGND VPWR VPWR sky130_fd_sc_hd__fill_1
XFILLER_194_1565 VPWR VGND VPWR VGND sky130_ef_sc_hd__decap_12
XTAP_TAPCELL_ROW_29_1_1075 VGND VPWR sky130_fd_sc_hd__tapvpwrvgnd_1
XFILLER_218_1259 VGND VGND VPWR VPWR sky130_fd_sc_hd__fill_1
XFILLER_190_1429 VPWR VGND VPWR VGND sky130_ef_sc_hd__decap_12
XFILLER_66_1270 VPWR VGND VPWR VGND sky130_ef_sc_hd__decap_12
Xoutput76 net76 VGND VGND VPWR VPWR bist_fail_bits[27] sky130_fd_sc_hd__buf_2
Xoutput65 net65 VGND VGND VPWR VPWR bist_fail_bits[17] sky130_fd_sc_hd__buf_2
Xoutput54 net54 VGND VGND VPWR VPWR bist_fail_addr[5] sky130_fd_sc_hd__buf_2
XFILLER_163_53 VGND VGND VPWR VPWR sky130_fd_sc_hd__decap_3
Xoutput98 net98 VGND VGND VPWR VPWR func_rdata[18] sky130_fd_sc_hd__buf_2
XFILLER_0_242 VGND VGND VPWR VPWR sky130_fd_sc_hd__decap_8
XFILLER_0_253 VGND VGND VPWR VPWR sky130_fd_sc_hd__decap_4
Xoutput87 net87 VGND VGND VPWR VPWR bist_fail_bits[8] sky130_fd_sc_hd__buf_2
XFILLER_27_1232 VPWR VGND VPWR VGND sky130_ef_sc_hd__decap_12
XFILLER_209_517 VPWR VGND VPWR VGND sky130_ef_sc_hd__decap_12
XFILLER_163_97 VPWR VGND VPWR VGND sky130_ef_sc_hd__decap_12
XFILLER_118_1382 VPWR VGND VPWR VGND sky130_ef_sc_hd__decap_12
XFILLER_114_1246 VPWR VGND VPWR VGND sky130_ef_sc_hd__decap_12
XFILLER_1_798 VGND VGND VPWR VPWR sky130_fd_sc_hd__fill_1
XANTENNA_input30_A func_wdata[26] VGND VGND VPWR VPWR sky130_fd_sc_hd__diode_2
XFILLER_27_1298 VPWR VGND VPWR VGND sky130_ef_sc_hd__decap_12
XFILLER_217_561 VPWR VGND VPWR VGND sky130_ef_sc_hd__decap_12
XFILLER_204_233 VPWR VGND VPWR VGND sky130_ef_sc_hd__decap_12
XFILLER_186_1093 VPWR VGND VPWR VGND sky130_ef_sc_hd__decap_12
X_576_ clknet_3_0_0_clk _001_ VGND VGND VPWR VPWR u_ctrl.state\[0\] sky130_fd_sc_hd__dfxtp_1
XFILLER_204_277 VPWR VGND VPWR VGND sky130_ef_sc_hd__decap_12
XTAP_TAPCELL_ROW_84_1_1185 VGND VPWR sky130_fd_sc_hd__tapvpwrvgnd_1
XFILLER_31_113 VGND VGND VPWR VPWR sky130_fd_sc_hd__fill_1
XFILLER_38_1350 VGND VGND VPWR VPWR sky130_fd_sc_hd__decap_6
XFILLER_125_1342 VPWR VGND VPWR VGND sky130_ef_sc_hd__decap_12
XFILLER_73_1274 VPWR VGND VPWR VGND sky130_ef_sc_hd__decap_12
XFILLER_72_83 VGND VGND VPWR VPWR sky130_fd_sc_hd__fill_1
XPHY_EDGE_ROW_4_Left_224 VGND VGND VPWR VPWR sky130_fd_sc_hd__decap_3
XFILLER_38_1394 VPWR VGND VPWR VGND sky130_ef_sc_hd__decap_12
XFILLER_201_951 VGND VGND VPWR VPWR sky130_fd_sc_hd__fill_1
XFILLER_188_83 VGND VGND VPWR VPWR sky130_fd_sc_hd__fill_1
XFILLER_185_641 VPWR VGND VPWR VGND sky130_ef_sc_hd__decap_12
XFILLER_169_181 VPWR VGND VPWR VGND sky130_ef_sc_hd__decap_12
XFILLER_160_1244 VGND VGND VPWR VPWR sky130_fd_sc_hd__fill_1
XFILLER_34_1258 VPWR VGND VPWR VGND sky130_ef_sc_hd__decap_12
XFILLER_185_685 VPWR VGND VPWR VGND sky130_ef_sc_hd__decap_12
XFILLER_125_1386 VPWR VGND VPWR VGND sky130_ef_sc_hd__decap_12
XTAP_TAPCELL_ROW_45_2_3273 VGND VPWR sky130_fd_sc_hd__tapvpwrvgnd_1
XFILLER_184_195 VGND VGND VPWR VPWR sky130_fd_sc_hd__fill_1
XFILLER_86_1602 VGND VGND VPWR VPWR sky130_fd_sc_hd__decap_3
XFILLER_172_357 VGND VGND VPWR VPWR sky130_fd_sc_hd__decap_6
XPHY_EDGE_ROW_159_1_Right_745 VGND VGND VPWR VPWR sky130_fd_sc_hd__decap_3
XFILLER_207_57 VPWR VGND VPWR VGND sky130_ef_sc_hd__decap_12
XTAP_TAPCELL_ROW_185_2020 VGND VPWR sky130_fd_sc_hd__tapvpwrvgnd_1
XFILLER_84_1370 VPWR VGND VPWR VGND sky130_ef_sc_hd__decap_12
XFILLER_45_1310 VPWR VGND VPWR VGND sky130_ef_sc_hd__decap_12
XFILLER_132_1302 VPWR VGND VPWR VGND sky130_ef_sc_hd__decap_12
XFILLER_45_1354 VPWR VGND VPWR VGND sky130_ef_sc_hd__decap_12
XFILLER_49_1490 VGND VGND VPWR VPWR sky130_fd_sc_hd__decap_6
XTAP_TAPCELL_ROW_206_2602 VGND VPWR sky130_fd_sc_hd__tapvpwrvgnd_1
XFILLER_136_1482 VPWR VGND VPWR VGND sky130_ef_sc_hd__decap_12
XPHY_EDGE_ROW_10_1_Left_229 VGND VGND VPWR VPWR sky130_fd_sc_hd__decap_3
XTAP_TAPCELL_ROW_206_2624 VGND VPWR sky130_fd_sc_hd__tapvpwrvgnd_1
XTAP_TAPCELL_ROW_206_2613 VGND VPWR sky130_fd_sc_hd__tapvpwrvgnd_1
XFILLER_45_1398 VPWR VGND VPWR VGND sky130_ef_sc_hd__decap_12
XPHY_EDGE_ROW_135_1_Left_354 VGND VGND VPWR VPWR sky130_fd_sc_hd__decap_3
XANTENNA__586__Q b_addr\[2\] VGND VGND VPWR VPWR sky130_fd_sc_hd__diode_2
XFILLER_165_1133 VPWR VGND VPWR VGND sky130_ef_sc_hd__decap_12
XFILLER_196_917 VGND VGND VPWR VPWR sky130_fd_sc_hd__decap_6
XFILLER_165_1177 VPWR VGND VPWR VGND sky130_ef_sc_hd__decap_12
XTAP_TAPCELL_ROW_131_1_1280 VGND VPWR sky130_fd_sc_hd__tapvpwrvgnd_1
XFILLER_91_1330 VPWR VGND VPWR VGND sky130_ef_sc_hd__decap_12
XFILLER_1_1481 VPWR VGND VPWR VGND sky130_ef_sc_hd__decap_12
XFILLER_56_1450 VPWR VGND VPWR VGND sky130_ef_sc_hd__decap_12
XFILLER_206_1141 VGND VGND VPWR VPWR sky130_fd_sc_hd__decap_6
XFILLER_195_405 VPWR VGND VPWR VGND sky130_ef_sc_hd__decap_12
XANTENNA_fanout148_A u_ctrl.cmp_exp\[0\] VGND VGND VPWR VPWR sky130_fd_sc_hd__diode_2
XFILLER_17_1434 VGND VGND VPWR VPWR sky130_fd_sc_hd__decap_6
XFILLER_52_1314 VPWR VGND VPWR VGND sky130_ef_sc_hd__decap_12
XFILLER_206_1185 VPWR VGND VPWR VGND sky130_ef_sc_hd__decap_12
XFILLER_202_1005 VPWR VGND VPWR VGND sky130_ef_sc_hd__decap_12
XFILLER_195_449 VPWR VGND VPWR VGND sky130_ef_sc_hd__decap_12
XFILLER_143_1442 VPWR VGND VPWR VGND sky130_ef_sc_hd__decap_12
XFILLER_108_1562 VPWR VGND VPWR VGND sky130_ef_sc_hd__decap_12
XFILLER_56_1494 VPWR VGND VPWR VGND sky130_ef_sc_hd__decap_12
XFILLER_202_1049 VPWR VGND VPWR VGND sky130_ef_sc_hd__decap_12
XFILLER_164_825 VPWR VGND VPWR VGND sky130_ef_sc_hd__decap_12
XFILLER_104_1426 VPWR VGND VPWR VGND sky130_ef_sc_hd__decap_12
XFILLER_17_1478 VPWR VGND VPWR VGND sky130_ef_sc_hd__decap_12
XFILLER_52_1358 VPWR VGND VPWR VGND sky130_ef_sc_hd__decap_12
XFILLER_190_121 VPWR VGND VPWR VGND sky130_ef_sc_hd__decap_12
XFILLER_219_1513 VPWR VGND VPWR VGND sky130_ef_sc_hd__decap_12
XFILLER_164_869 VPWR VGND VPWR VGND sky130_ef_sc_hd__decap_12
XFILLER_190_165 VPWR VGND VPWR VGND sky130_ef_sc_hd__decap_12
XFILLER_89_113 VPWR VGND VPWR VGND sky130_ef_sc_hd__decap_12
XFILLER_176_1273 VPWR VGND VPWR VGND sky130_ef_sc_hd__decap_12
XTAP_TAPCELL_ROW_134_2_3849 VGND VPWR sky130_fd_sc_hd__tapvpwrvgnd_1
XFILLER_117_57 VPWR VGND VPWR VGND sky130_ef_sc_hd__decap_12
XFILLER_63_1410 VPWR VGND VPWR VGND sky130_ef_sc_hd__decap_12
XFILLER_213_1101 VPWR VGND VPWR VGND sky130_ef_sc_hd__decap_12
XFILLER_137_1268 VGND VGND VPWR VPWR sky130_fd_sc_hd__decap_4
XFILLER_77_39 VPWR VGND VPWR VGND sky130_ef_sc_hd__decap_12
XFILLER_67_1590 VPWR VGND VPWR VGND sky130_ef_sc_hd__decap_12
XFILLER_8_1602 VGND VGND VPWR VPWR sky130_fd_sc_hd__decap_3
XFILLER_217_1281 VGND VGND VPWR VPWR sky130_fd_sc_hd__decap_6
XFILLER_213_1145 VPWR VGND VPWR VGND sky130_ef_sc_hd__decap_12
XFILLER_154_1582 VPWR VGND VPWR VGND sky130_ef_sc_hd__decap_12
XFILLER_115_1522 VPWR VGND VPWR VGND sky130_ef_sc_hd__decap_12
XFILLER_63_1454 VPWR VGND VPWR VGND sky130_ef_sc_hd__decap_12
XFILLER_24_1438 VPWR VGND VPWR VGND sky130_ef_sc_hd__decap_12
XFILLER_28_1574 VGND VGND VPWR VPWR sky130_fd_sc_hd__decap_6
XFILLER_219_837 VGND VGND VPWR VPWR sky130_fd_sc_hd__decap_3
XTAP_TAPCELL_ROW_164_1425 VGND VPWR sky130_fd_sc_hd__tapvpwrvgnd_1
XTAP_TAPCELL_ROW_164_1414 VGND VPWR sky130_fd_sc_hd__tapvpwrvgnd_1
XTAP_TAPCELL_ROW_164_1403 VGND VPWR sky130_fd_sc_hd__tapvpwrvgnd_1
XFILLER_150_1468 VGND VGND VPWR VPWR sky130_fd_sc_hd__fill_1
XFILLER_115_1566 VPWR VGND VPWR VGND sky130_ef_sc_hd__decap_12
XFILLER_98_1506 VPWR VGND VPWR VGND sky130_ef_sc_hd__decap_12
XPHY_EDGE_ROW_67_1_Left_286 VGND VGND VPWR VPWR sky130_fd_sc_hd__decap_3
XFILLER_63_1498 VPWR VGND VPWR VGND sky130_ef_sc_hd__decap_12
XFILLER_213_1189 VPWR VGND VPWR VGND sky130_ef_sc_hd__decap_12
XFILLER_93_27 VPWR VGND VPWR VGND sky130_ef_sc_hd__decap_12
XTAP_TAPCELL_ROW_82_2_3514 VGND VPWR sky130_fd_sc_hd__tapvpwrvgnd_1
XFILLER_214_531 VGND VGND VPWR VPWR sky130_fd_sc_hd__fill_1
XFILLER_198_221 VPWR VGND VPWR VGND sky130_ef_sc_hd__decap_12
XFILLER_183_1233 VPWR VGND VPWR VGND sky130_ef_sc_hd__decap_12
XFILLER_26_43 VPWR VGND VPWR VGND sky130_ef_sc_hd__decap_12
X_430_ _162_ _163_ net157 VGND VGND VPWR VPWR _024_ sky130_fd_sc_hd__o21a_1
XFILLER_199_777 VGND VGND VPWR VPWR sky130_fd_sc_hd__decap_6
XFILLER_158_3 VPWR VGND VPWR VGND sky130_ef_sc_hd__decap_12
XFILLER_13_113 VPWR VGND VPWR VGND sky130_ef_sc_hd__decap_12
X_361_ _084_ _103_ VGND VGND VPWR VPWR _104_ sky130_fd_sc_hd__and2_4
XFILLER_202_737 VPWR VGND VPWR VGND sky130_ef_sc_hd__decap_12
XFILLER_201_225 VPWR VGND VPWR VGND sky130_ef_sc_hd__decap_12
XFILLER_198_265 VPWR VGND VPWR VGND sky130_ef_sc_hd__decap_12
XFILLER_74_1550 VPWR VGND VPWR VGND sky130_ef_sc_hd__decap_12
XFILLER_167_641 VPWR VGND VPWR VGND sky130_ef_sc_hd__decap_12
XFILLER_74_1594 VGND VGND VPWR VPWR sky130_fd_sc_hd__decap_8
XFILLER_70_1414 VPWR VGND VPWR VGND sky130_ef_sc_hd__decap_12
X_292_ net140 _086_ VGND VGND VPWR VPWR _087_ sky130_fd_sc_hd__nor2_2
XTAP_TAPCELL_ROW_31_2_3181 VGND VPWR sky130_fd_sc_hd__tapvpwrvgnd_1
XFILLER_35_1534 VPWR VGND VPWR VGND sky130_ef_sc_hd__decap_12
XFILLER_42_53 VPWR VGND VPWR VGND sky130_ef_sc_hd__decap_12
XFILLER_210_781 VPWR VGND VPWR VGND sky130_ef_sc_hd__decap_12
XFILLER_167_685 VPWR VGND VPWR VGND sky130_ef_sc_hd__decap_12
XFILLER_158_53 VPWR VGND VPWR VGND sky130_ef_sc_hd__decap_12
XFILLER_122_1526 VPWR VGND VPWR VGND sky130_ef_sc_hd__decap_12
XFILLER_35_1578 VPWR VGND VPWR VGND sky130_ef_sc_hd__decap_12
XFILLER_6_813 VPWR VGND VPWR VGND sky130_ef_sc_hd__decap_12
XFILLER_42_97 VPWR VGND VPWR VGND sky130_ef_sc_hd__decap_12
XFILLER_166_195 VGND VGND VPWR VPWR sky130_fd_sc_hd__fill_1
XFILLER_158_97 VPWR VGND VPWR VGND sky130_ef_sc_hd__decap_12
XFILLER_182_699 VGND VGND VPWR VPWR sky130_fd_sc_hd__fill_1
XFILLER_174_41 VPWR VGND VPWR VGND sky130_ef_sc_hd__decap_12
XFILLER_120_1294 VGND VGND VPWR VPWR sky130_fd_sc_hd__decap_6
XFILLER_194_1373 VPWR VGND VPWR VGND sky130_ef_sc_hd__decap_12
XTAP_TAPCELL_ROW_23_2_3129 VGND VPWR sky130_fd_sc_hd__tapvpwrvgnd_1
XFILLER_190_1259 VGND VGND VPWR VPWR sky130_fd_sc_hd__fill_1
XFILLER_174_85 VPWR VGND VPWR VGND sky130_ef_sc_hd__decap_12
XFILLER_95_105 VGND VGND VPWR VPWR sky130_fd_sc_hd__decap_6
XFILLER_81_1510 VPWR VGND VPWR VGND sky130_ef_sc_hd__decap_12
XFILLER_81_1554 VPWR VGND VPWR VGND sky130_ef_sc_hd__decap_12
XFILLER_3_69 VPWR VGND VPWR VGND sky130_ef_sc_hd__decap_12
XFILLER_1_573 VGND VGND VPWR VPWR sky130_fd_sc_hd__decap_8
XFILLER_3_1009 VPWR VGND VPWR VGND sky130_ef_sc_hd__decap_12
XFILLER_7_1145 VGND VGND VPWR VPWR sky130_fd_sc_hd__decap_3
XFILLER_42_1538 VPWR VGND VPWR VGND sky130_ef_sc_hd__decap_12
XFILLER_7_1189 VPWR VGND VPWR VGND sky130_ef_sc_hd__decap_12
XFILLER_218_881 VPWR VGND VPWR VGND sky130_ef_sc_hd__decap_12
XFILLER_217_391 VGND VGND VPWR VPWR sky130_fd_sc_hd__fill_1
X_628_ clknet_3_1_0_clk _062_ VGND VGND VPWR VPWR net53 sky130_fd_sc_hd__dfxtp_1
XFILLER_205_553 VGND VGND VPWR VPWR sky130_fd_sc_hd__decap_6
XFILLER_178_917 VGND VGND VPWR VPWR sky130_fd_sc_hd__decap_6
XFILLER_166_1453 VPWR VGND VPWR VGND sky130_ef_sc_hd__decap_12
XFILLER_83_93 VPWR VGND VPWR VGND sky130_ef_sc_hd__decap_12
XFILLER_205_597 VPWR VGND VPWR VGND sky130_ef_sc_hd__decap_12
XFILLER_199_93 VPWR VGND VPWR VGND sky130_ef_sc_hd__decap_12
XFILLER_177_405 VPWR VGND VPWR VGND sky130_ef_sc_hd__decap_12
XFILLER_166_1497 VPWR VGND VPWR VGND sky130_ef_sc_hd__decap_12
X_559_ net136 _253_ VGND VGND VPWR VPWR _063_ sky130_fd_sc_hd__and2_1
XFILLER_193_909 VPWR VGND VPWR VGND sky130_ef_sc_hd__decap_12
XFILLER_177_449 VPWR VGND VPWR VGND sky130_ef_sc_hd__decap_12
XFILLER_203_1325 VPWR VGND VPWR VGND sky130_ef_sc_hd__decap_12
XFILLER_192_419 VGND VGND VPWR VPWR sky130_fd_sc_hd__fill_1
XFILLER_186_961 VPWR VGND VPWR VGND sky130_ef_sc_hd__decap_12
XFILLER_203_1369 VPWR VGND VPWR VGND sky130_ef_sc_hd__decap_12
XFILLER_73_3 VPWR VGND VPWR VGND sky130_ef_sc_hd__decap_12
XFILLER_172_121 VPWR VGND VPWR VGND sky130_ef_sc_hd__decap_12
XFILLER_172_165 VPWR VGND VPWR VGND sky130_ef_sc_hd__decap_12
XTAP_TAPCELL_ROW_120_2_3757 VGND VPWR sky130_fd_sc_hd__tapvpwrvgnd_1
XTAP_TAPCELL_ROW_107_1_1231 VGND VPWR sky130_fd_sc_hd__tapvpwrvgnd_1
XFILLER_177_1593 VPWR VGND VPWR VGND sky130_ef_sc_hd__decap_12
XFILLER_173_1413 VPWR VGND VPWR VGND sky130_ef_sc_hd__decap_12
XTAP_TAPCELL_ROW_12_1_1042 VGND VPWR sky130_fd_sc_hd__tapvpwrvgnd_1
XFILLER_173_1457 VPWR VGND VPWR VGND sky130_ef_sc_hd__decap_12
Xfanout129 net130 VGND VGND VPWR VPWR net129 sky130_fd_sc_hd__clkbuf_2
XFILLER_214_1421 VGND VGND VPWR VPWR sky130_fd_sc_hd__decap_6
XFILLER_214_1465 VPWR VGND VPWR VGND sky130_ef_sc_hd__decap_12
XFILLER_210_1329 VPWR VGND VPWR VGND sky130_ef_sc_hd__decap_12
XFILLER_103_15 VPWR VGND VPWR VGND sky130_ef_sc_hd__decap_12
XTAP_TAPCELL_ROW_100_1_1218 VGND VPWR sky130_fd_sc_hd__tapvpwrvgnd_1
XTAP_TAPCELL_ROW_67_2_3416 VGND VPWR sky130_fd_sc_hd__tapvpwrvgnd_1
XFILLER_215_317 VPWR VGND VPWR VGND sky130_ef_sc_hd__decap_12
XFILLER_208_1203 VGND VGND VPWR VPWR sky130_fd_sc_hd__fill_1
XFILLER_184_1553 VPWR VGND VPWR VGND sky130_ef_sc_hd__decap_12
XTAP_TAPCELL_ROW_162_1_1341 VGND VPWR sky130_fd_sc_hd__tapvpwrvgnd_1
XFILLER_196_725 VPWR VGND VPWR VGND sky130_ef_sc_hd__decap_12
XFILLER_184_1597 VGND VGND VPWR VPWR sky130_fd_sc_hd__decap_8
XFILLER_196_769 VPWR VGND VPWR VGND sky130_ef_sc_hd__decap_12
XTAP_TAPCELL_ROW_16_2_3083 VGND VPWR sky130_fd_sc_hd__tapvpwrvgnd_1
XFILLER_17_1220 VPWR VGND VPWR VGND sky130_ef_sc_hd__decap_12
XFILLER_195_279 VGND VGND VPWR VPWR sky130_fd_sc_hd__fill_1
XFILLER_143_1272 VGND VGND VPWR VPWR sky130_fd_sc_hd__fill_1
XFILLER_108_1370 VPWR VGND VPWR VGND sky130_ef_sc_hd__decap_12
XFILLER_17_1286 VPWR VGND VPWR VGND sky130_ef_sc_hd__decap_12
XFILLER_191_441 VGND VGND VPWR VPWR sky130_fd_sc_hd__decap_6
XFILLER_191_485 VPWR VGND VPWR VGND sky130_ef_sc_hd__decap_12
XFILLER_164_699 VGND VGND VPWR VPWR sky130_fd_sc_hd__fill_1
XFILLER_163_165 VGND VGND VPWR VPWR sky130_fd_sc_hd__decap_3
XFILLER_88_27 VGND VGND VPWR VPWR sky130_fd_sc_hd__fill_1
XFILLER_3_827 VGND VGND VPWR VPWR sky130_fd_sc_hd__decap_4
XFILLER_12_89 VGND VGND VPWR VPWR sky130_fd_sc_hd__fill_1
XFILLER_191_1513 VPWR VGND VPWR VGND sky130_ef_sc_hd__decap_12
XFILLER_2_348 VGND VGND VPWR VPWR sky130_fd_sc_hd__decap_6
XFILLER_219_601 VPWR VGND VPWR VGND sky130_ef_sc_hd__decap_12
XFILLER_77_105 VGND VGND VPWR VPWR sky130_fd_sc_hd__decap_6
XFILLER_150_1232 VPWR VGND VPWR VGND sky130_ef_sc_hd__decap_12
XFILLER_144_77 VGND VGND VPWR VPWR sky130_fd_sc_hd__decap_6
XFILLER_115_1330 VPWR VGND VPWR VGND sky130_ef_sc_hd__decap_12
XFILLER_24_1246 VPWR VGND VPWR VGND sky130_ef_sc_hd__decap_12
XFILLER_28_1382 VPWR VGND VPWR VGND sky130_ef_sc_hd__decap_12
XFILLER_219_645 VPWR VGND VPWR VGND sky130_ef_sc_hd__decap_12
XFILLER_218_133 VGND VGND VPWR VPWR sky130_fd_sc_hd__decap_6
XFILLER_98_1314 VPWR VGND VPWR VGND sky130_ef_sc_hd__decap_12
XFILLER_4_1329 VPWR VGND VPWR VGND sky130_ef_sc_hd__decap_12
XANTENNA_clkbuf_3_1_0_clk_X clknet_3_1_0_clk VGND VGND VPWR VPWR sky130_fd_sc_hd__diode_2
XFILLER_218_177 VPWR VGND VPWR VGND sky130_ef_sc_hd__decap_12
XFILLER_98_1358 VPWR VGND VPWR VGND sky130_ef_sc_hd__decap_12
XTAP_TAPCELL_ROW_2_860 VGND VPWR sky130_fd_sc_hd__tapvpwrvgnd_1
XFILLER_160_65 VPWR VGND VPWR VGND sky130_ef_sc_hd__decap_12
XFILLER_202_501 VPWR VGND VPWR VGND sky130_ef_sc_hd__decap_12
XFILLER_199_541 VPWR VGND VPWR VGND sky130_ef_sc_hd__decap_12
X_413_ _147_ _148_ net156 VGND VGND VPWR VPWR _022_ sky130_fd_sc_hd__o21a_1
XFILLER_215_895 VGND VGND VPWR VPWR sky130_fd_sc_hd__fill_1
XFILLER_199_585 VPWR VGND VPWR VGND sky130_ef_sc_hd__decap_12
XFILLER_183_1063 VGND VGND VPWR VPWR sky130_fd_sc_hd__fill_1
XFILLER_202_545 VPWR VGND VPWR VGND sky130_ef_sc_hd__decap_12
XFILLER_175_909 VPWR VGND VPWR VGND sky130_ef_sc_hd__decap_12
X_344_ u_ctrl.cmp_addr\[3\] b_addr\[3\] net152 VGND VGND VPWR VPWR _093_ sky130_fd_sc_hd__mux2_1
XFILLER_202_589 VPWR VGND VPWR VGND sky130_ef_sc_hd__decap_12
XFILLER_174_419 VGND VGND VPWR VPWR sky130_fd_sc_hd__fill_1
XFILLER_168_961 VPWR VGND VPWR VGND sky130_ef_sc_hd__decap_12
XFILLER_126_1470 VPWR VGND VPWR VGND sky130_ef_sc_hd__decap_12
XFILLER_70_1244 VGND VGND VPWR VPWR sky130_fd_sc_hd__fill_1
X_275_ net2 net47 VGND VGND VPWR VPWR _074_ sky130_fd_sc_hd__and2b_1
XFILLER_35_1342 VPWR VGND VPWR VGND sky130_ef_sc_hd__decap_12
XFILLER_200_1509 VPWR VGND VPWR VGND sky130_ef_sc_hd__decap_12
XFILLER_122_1356 VGND VGND VPWR VPWR sky130_fd_sc_hd__fill_1
XFILLER_35_1386 VPWR VGND VPWR VGND sky130_ef_sc_hd__decap_12
XFILLER_183_953 VPWR VGND VPWR VGND sky130_ef_sc_hd__decap_12
XFILLER_154_121 VGND VGND VPWR VPWR sky130_fd_sc_hd__decap_6
XTAP_TAPCELL_ROW_105_2_3659 VGND VPWR sky130_fd_sc_hd__tapvpwrvgnd_1
XFILLER_6_643 VGND VGND VPWR VPWR sky130_fd_sc_hd__fill_1
XPHY_EDGE_ROW_219_Left_438 VGND VGND VPWR VPWR sky130_fd_sc_hd__decap_3
XFILLER_185_51 VGND VGND VPWR VPWR sky130_fd_sc_hd__decap_4
XFILLER_170_625 VPWR VGND VPWR VGND sky130_ef_sc_hd__decap_12
XPHY_EDGE_ROW_102_2_Left_534 VGND VGND VPWR VPWR sky130_fd_sc_hd__decap_3
XFILLER_52_8 VPWR VGND VPWR VGND sky130_ef_sc_hd__decap_12
XFILLER_170_669 VPWR VGND VPWR VGND sky130_ef_sc_hd__decap_12
XFILLER_42_1302 VPWR VGND VPWR VGND sky130_ef_sc_hd__decap_12
XFILLER_209_111 VGND VGND VPWR VPWR sky130_fd_sc_hd__fill_1
XFILLER_81_1384 VGND VGND VPWR VPWR sky130_fd_sc_hd__fill_1
XFILLER_1_381 VGND VGND VPWR VPWR sky130_fd_sc_hd__decap_8
XFILLER_46_1482 VPWR VGND VPWR VGND sky130_ef_sc_hd__decap_12
XTAP_TAPCELL_ROW_53_2_3324 VGND VPWR sky130_fd_sc_hd__tapvpwrvgnd_1
XPHY_EDGE_ROW_84_1_Right_670 VGND VGND VPWR VPWR sky130_fd_sc_hd__decap_3
XFILLER_133_1496 VGND VGND VPWR VPWR sky130_fd_sc_hd__fill_1
XFILLER_212_309 VPWR VGND VPWR VGND sky130_ef_sc_hd__decap_12
XFILLER_209_1567 VGND VGND VPWR VPWR sky130_fd_sc_hd__fill_1
XFILLER_205_361 VPWR VGND VPWR VGND sky130_ef_sc_hd__decap_12
XFILLER_178_725 VPWR VGND VPWR VGND sky130_ef_sc_hd__decap_12
XFILLER_166_1261 VPWR VGND VPWR VGND sky130_ef_sc_hd__decap_12
XFILLER_178_769 VPWR VGND VPWR VGND sky130_ef_sc_hd__decap_12
XFILLER_127_1256 VPWR VGND VPWR VGND sky130_ef_sc_hd__decap_12
XFILLER_177_279 VGND VGND VPWR VPWR sky130_fd_sc_hd__fill_1
XFILLER_140_1412 VGND VGND VPWR VPWR sky130_fd_sc_hd__fill_1
XFILLER_105_1510 VPWR VGND VPWR VGND sky130_ef_sc_hd__decap_12
XFILLER_18_1562 VPWR VGND VPWR VGND sky130_ef_sc_hd__decap_12
XFILLER_53_1442 VPWR VGND VPWR VGND sky130_ef_sc_hd__decap_12
XFILLER_203_1133 VPWR VGND VPWR VGND sky130_ef_sc_hd__decap_12
XFILLER_105_1554 VPWR VGND VPWR VGND sky130_ef_sc_hd__decap_12
XFILLER_14_1426 VPWR VGND VPWR VGND sky130_ef_sc_hd__decap_12
XFILLER_203_1177 VPWR VGND VPWR VGND sky130_ef_sc_hd__decap_12
XFILLER_173_441 VGND VGND VPWR VPWR sky130_fd_sc_hd__decap_6
XFILLER_88_1538 VPWR VGND VPWR VGND sky130_ef_sc_hd__decap_12
XPHY_EDGE_ROW_34_2_Left_466 VGND VGND VPWR VPWR sky130_fd_sc_hd__decap_3
XFILLER_173_485 VPWR VGND VPWR VGND sky130_ef_sc_hd__decap_12
XPHY_EDGE_ROW_159_2_Left_591 VGND VGND VPWR VPWR sky130_fd_sc_hd__decap_3
XTAP_TAPCELL_ROW_43_1_1103 VGND VPWR sky130_fd_sc_hd__tapvpwrvgnd_1
XFILLER_173_1287 VGND VGND VPWR VPWR sky130_fd_sc_hd__fill_1
XTAP_TAPCELL_ROW_149_2_3946 VGND VPWR sky130_fd_sc_hd__tapvpwrvgnd_1
XTAP_TAPCELL_ROW_150_2_3952 VGND VPWR sky130_fd_sc_hd__tapvpwrvgnd_1
XFILLER_47_1268 VGND VGND VPWR VPWR sky130_fd_sc_hd__decap_4
XFILLER_59_105 VGND VGND VPWR VPWR sky130_fd_sc_hd__decap_6
XFILLER_64_1582 VPWR VGND VPWR VGND sky130_ef_sc_hd__decap_12
XFILLER_25_1522 VPWR VGND VPWR VGND sky130_ef_sc_hd__decap_12
XFILLER_214_1273 VPWR VGND VPWR VGND sky130_ef_sc_hd__decap_12
XFILLER_151_1552 VGND VGND VPWR VPWR sky130_fd_sc_hd__fill_1
XFILLER_25_1566 VPWR VGND VPWR VGND sky130_ef_sc_hd__decap_12
XFILLER_60_1468 VGND VGND VPWR VPWR sky130_fd_sc_hd__fill_1
XFILLER_74_29 VPWR VGND VPWR VGND sky130_ef_sc_hd__decap_12
XFILLER_216_637 VGND VGND VPWR VPWR sky130_fd_sc_hd__decap_6
XFILLER_215_125 VPWR VGND VPWR VGND sky130_ef_sc_hd__decap_12
XTAP_TAPCELL_ROW_97_2_3611 VGND VPWR sky130_fd_sc_hd__tapvpwrvgnd_1
XFILLER_215_169 VPWR VGND VPWR VGND sky130_ef_sc_hd__decap_12
XFILLER_110_1282 VPWR VGND VPWR VGND sky130_ef_sc_hd__decap_12
XFILLER_180_1203 VGND VGND VPWR VPWR sky130_fd_sc_hd__fill_1
XFILLER_93_1244 VPWR VGND VPWR VGND sky130_ef_sc_hd__decap_12
XFILLER_196_533 VPWR VGND VPWR VGND sky130_ef_sc_hd__decap_12
XFILLER_145_1378 VGND VGND VPWR VPWR sky130_fd_sc_hd__decap_6
XFILLER_23_55 VGND VGND VPWR VPWR sky130_fd_sc_hd__fill_1
XFILLER_183_205 VPWR VGND VPWR VGND sky130_ef_sc_hd__decap_12
XFILLER_139_55 VGND VGND VPWR VPWR sky130_fd_sc_hd__fill_1
XFILLER_32_1526 VPWR VGND VPWR VGND sky130_ef_sc_hd__decap_12
XFILLER_183_249 VPWR VGND VPWR VGND sky130_ef_sc_hd__decap_12
XFILLER_165_953 VPWR VGND VPWR VGND sky130_ef_sc_hd__decap_12
XFILLER_136_121 VGND VGND VPWR VPWR sky130_fd_sc_hd__decap_6
XFILLER_99_15 VPWR VGND VPWR VGND sky130_ef_sc_hd__decap_12
XFILLER_180_923 VGND VGND VPWR VPWR sky130_fd_sc_hd__fill_1
XFILLER_191_293 VPWR VGND VPWR VGND sky130_ef_sc_hd__decap_12
XFILLER_174_1029 VGND VGND VPWR VPWR sky130_fd_sc_hd__decap_6
XFILLER_151_113 VPWR VGND VPWR VGND sky130_ef_sc_hd__decap_12
XANTENNA__575__CLK clknet_3_0_0_clk VGND VGND VPWR VPWR sky130_fd_sc_hd__diode_2
XFILLER_30_1294 VGND VGND VPWR VPWR sky130_fd_sc_hd__decap_6
XFILLER_219_1173 VGND VGND VPWR VPWR sky130_fd_sc_hd__decap_3
XFILLER_191_1343 VGND VGND VPWR VPWR sky130_fd_sc_hd__fill_1
XFILLER_3_3 VPWR VGND VPWR VGND sky130_ef_sc_hd__decap_12
XTAP_TAPCELL_ROW_38_2_3226 VGND VPWR sky130_fd_sc_hd__tapvpwrvgnd_1
XFILLER_152_1338 VPWR VGND VPWR VGND sky130_ef_sc_hd__decap_12
XTAP_TAPCELL_ROW_7_985 VGND VPWR sky130_fd_sc_hd__tapvpwrvgnd_1
XFILLER_48_41 VPWR VGND VPWR VGND sky130_ef_sc_hd__decap_12
XTAP_TAPCELL_ROW_7_996 VGND VPWR sky130_fd_sc_hd__tapvpwrvgnd_1
XFILLER_48_85 VPWR VGND VPWR VGND sky130_ef_sc_hd__decap_12
XFILLER_207_615 VGND VGND VPWR VPWR sky130_fd_sc_hd__fill_1
XFILLER_0_15 VPWR VGND VPWR VGND sky130_ef_sc_hd__decap_12
XFILLER_0_37 VGND VGND VPWR VPWR sky130_fd_sc_hd__decap_3
XFILLER_185_1169 VGND VGND VPWR VPWR sky130_fd_sc_hd__decap_6
XFILLER_203_821 VPWR VGND VPWR VGND sky130_ef_sc_hd__decap_12
XFILLER_167_1581 VPWR VGND VPWR VGND sky130_ef_sc_hd__decap_12
XFILLER_163_1401 VPWR VGND VPWR VGND sky130_ef_sc_hd__decap_12
XFILLER_203_865 VPWR VGND VPWR VGND sky130_ef_sc_hd__decap_12
XFILLER_199_393 VPWR VGND VPWR VGND sky130_ef_sc_hd__decap_12
XTAP_TAPCELL_ROW_36_1_1090 VGND VPWR sky130_fd_sc_hd__tapvpwrvgnd_1
XFILLER_9_57 VPWR VGND VPWR VGND sky130_ef_sc_hd__decap_12
X_327_ b_addr\[2\] net5 net140 VGND VGND VPWR VPWR s_addr\[2\] sky130_fd_sc_hd__mux2_1
XFILLER_204_1453 VPWR VGND VPWR VGND sky130_ef_sc_hd__decap_12
XFILLER_80_83 VGND VGND VPWR VPWR sky130_fd_sc_hd__fill_1
XFILLER_204_1497 VPWR VGND VPWR VGND sky130_ef_sc_hd__decap_12
XFILLER_200_1317 VPWR VGND VPWR VGND sky130_ef_sc_hd__decap_12
XFILLER_196_83 VGND VGND VPWR VPWR sky130_fd_sc_hd__fill_1
XFILLER_183_783 VGND VGND VPWR VPWR sky130_fd_sc_hd__fill_1
XPHY_EDGE_ROW_144_1_Left_363 VGND VGND VPWR VPWR sky130_fd_sc_hd__decap_3
XFILLER_192_1129 VPWR VGND VPWR VGND sky130_ef_sc_hd__decap_12
XFILLER_171_945 VGND VGND VPWR VPWR sky130_fd_sc_hd__decap_6
XFILLER_170_433 VPWR VGND VPWR VGND sky130_ef_sc_hd__decap_12
XTAP_TAPCELL_ROW_124_1_1266 VGND VPWR sky130_fd_sc_hd__tapvpwrvgnd_1
XFILLER_100_1462 VGND VGND VPWR VPWR sky130_fd_sc_hd__decap_6
XFILLER_174_1541 VPWR VGND VPWR VGND sky130_ef_sc_hd__decap_12
XFILLER_171_989 VPWR VGND VPWR VGND sky130_ef_sc_hd__decap_12
XFILLER_170_477 VPWR VGND VPWR VGND sky130_ef_sc_hd__decap_12
XTAP_TAPCELL_ROW_135_2_3854 VGND VPWR sky130_fd_sc_hd__tapvpwrvgnd_1
XFILLER_89_81 VPWR VGND VPWR VGND sky130_ef_sc_hd__decap_12
XPHY_EDGE_ROW_81_1_Left_300 VGND VGND VPWR VPWR sky130_fd_sc_hd__decap_3
XFILLER_36_3 VPWR VGND VPWR VGND sky130_ef_sc_hd__decap_12
XFILLER_215_57 VPWR VGND VPWR VGND sky130_ef_sc_hd__decap_12
XFILLER_170_1427 VGND VGND VPWR VPWR sky130_fd_sc_hd__fill_1
XFILLER_215_1593 VPWR VGND VPWR VGND sky130_ef_sc_hd__decap_12
XFILLER_211_1413 VPWR VGND VPWR VGND sky130_ef_sc_hd__decap_12
XFILLER_211_1457 VPWR VGND VPWR VGND sky130_ef_sc_hd__decap_12
XPHY_EDGE_ROW_85_1_Right_671 VGND VGND VPWR VPWR sky130_fd_sc_hd__decap_3
XFILLER_0_1513 VPWR VGND VPWR VGND sky130_ef_sc_hd__decap_12
XFILLER_213_629 VPWR VGND VPWR VGND sky130_ef_sc_hd__decap_12
XFILLER_206_681 VPWR VGND VPWR VGND sky130_ef_sc_hd__decap_12
XFILLER_212_139 VGND VGND VPWR VPWR sky130_fd_sc_hd__fill_1
XFILLER_178_533 VPWR VGND VPWR VGND sky130_ef_sc_hd__decap_12
XFILLER_166_1091 VGND VGND VPWR VPWR sky130_fd_sc_hd__fill_1
XFILLER_100_27 VGND VGND VPWR VPWR sky130_fd_sc_hd__fill_1
XFILLER_90_1406 VGND VGND VPWR VPWR sky130_fd_sc_hd__decap_6
XFILLER_193_503 VGND VGND VPWR VPWR sky130_fd_sc_hd__fill_1
XFILLER_181_1567 VGND VGND VPWR VPWR sky130_fd_sc_hd__fill_1
XFILLER_142_1518 VGND VGND VPWR VPWR sky130_fd_sc_hd__decap_6
XFILLER_197_1007 VGND VGND VPWR VPWR sky130_fd_sc_hd__fill_1
XFILLER_165_205 VPWR VGND VPWR VGND sky130_ef_sc_hd__decap_12
XFILLER_140_1220 VPWR VGND VPWR VGND sky130_ef_sc_hd__decap_12
XFILLER_18_1370 VPWR VGND VPWR VGND sky130_ef_sc_hd__decap_12
XFILLER_53_1272 VGND VGND VPWR VPWR sky130_fd_sc_hd__fill_1
XFILLER_181_709 VPWR VGND VPWR VGND sky130_ef_sc_hd__decap_12
XFILLER_165_249 VPWR VGND VPWR VGND sky130_ef_sc_hd__decap_12
XFILLER_118_121 VGND VGND VPWR VPWR sky130_fd_sc_hd__decap_6
XFILLER_88_1302 VPWR VGND VPWR VGND sky130_ef_sc_hd__decap_12
XPHY_EDGE_ROW_76_1_Left_295 VGND VGND VPWR VPWR sky130_fd_sc_hd__decap_3
XFILLER_105_1384 VGND VGND VPWR VPWR sky130_fd_sc_hd__fill_1
XFILLER_173_293 VPWR VGND VPWR VGND sky130_ef_sc_hd__decap_12
XFILLER_133_113 VPWR VGND VPWR VGND sky130_ef_sc_hd__decap_12
XFILLER_109_69 VPWR VGND VPWR VGND sky130_ef_sc_hd__decap_12
XTAP_TAPCELL_ROW_24_2_3134 VGND VPWR sky130_fd_sc_hd__tapvpwrvgnd_1
XFILLER_0_627 VGND VGND VPWR VPWR sky130_fd_sc_hd__fill_1
XFILLER_125_57 VPWR VGND VPWR VGND sky130_ef_sc_hd__decap_12
XTAP_TAPCELL_ROW_4_900 VGND VPWR sky130_fd_sc_hd__tapvpwrvgnd_1
XFILLER_112_1300 VGND VGND VPWR VPWR sky130_fd_sc_hd__fill_1
XFILLER_85_39 VPWR VGND VPWR VGND sky130_ef_sc_hd__decap_12
XTAP_TAPCELL_ROW_4_911 VGND VPWR sky130_fd_sc_hd__tapvpwrvgnd_1
XFILLER_5_1413 VPWR VGND VPWR VGND sky130_ef_sc_hd__decap_12
XFILLER_25_1330 VPWR VGND VPWR VGND sky130_ef_sc_hd__decap_12
XFILLER_60_1232 VPWR VGND VPWR VGND sky130_ef_sc_hd__decap_12
XFILLER_216_401 VPWR VGND VPWR VGND sky130_ef_sc_hd__decap_12
XTAP_TAPCELL_ROW_184_1984 VGND VPWR sky130_fd_sc_hd__tapvpwrvgnd_1
XTAP_TAPCELL_ROW_184_1973 VGND VPWR sky130_fd_sc_hd__tapvpwrvgnd_1
XFILLER_99_1442 VPWR VGND VPWR VGND sky130_ef_sc_hd__decap_12
XFILLER_5_1457 VPWR VGND VPWR VGND sky130_ef_sc_hd__decap_12
XTAP_TAPCELL_ROW_184_1995 VGND VPWR sky130_fd_sc_hd__tapvpwrvgnd_1
XFILLER_216_445 VPWR VGND VPWR VGND sky130_ef_sc_hd__decap_12
XFILLER_189_809 VPWR VGND VPWR VGND sky130_ef_sc_hd__decap_12
XTAP_TAPCELL_ROW_180_1859 VGND VPWR sky130_fd_sc_hd__tapvpwrvgnd_1
XFILLER_95_1328 VGND VGND VPWR VPWR sky130_fd_sc_hd__fill_1
XFILLER_216_489 VPWR VGND VPWR VGND sky130_ef_sc_hd__decap_12
XFILLER_182_1309 VGND VGND VPWR VPWR sky130_fd_sc_hd__decap_6
XFILLER_211_161 VGND VGND VPWR VPWR sky130_fd_sc_hd__decap_6
XFILLER_200_813 VPWR VGND VPWR VGND sky130_ef_sc_hd__decap_12
XFILLER_197_853 VPWR VGND VPWR VGND sky130_ef_sc_hd__decap_12
XFILLER_140_3 VPWR VGND VPWR VGND sky130_ef_sc_hd__decap_12
XFILLER_197_897 VPWR VGND VPWR VGND sky130_ef_sc_hd__decap_12
XFILLER_196_363 VGND VGND VPWR VPWR sky130_fd_sc_hd__fill_1
XFILLER_184_525 VGND VGND VPWR VPWR sky130_fd_sc_hd__decap_6
XTAP_TAPCELL_ROW_178_1799 VGND VPWR sky130_fd_sc_hd__tapvpwrvgnd_1
XTAP_TAPCELL_ROW_141_2_3897 VGND VPWR sky130_fd_sc_hd__tapvpwrvgnd_1
XFILLER_36_1470 VPWR VGND VPWR VGND sky130_ef_sc_hd__decap_12
XFILLER_184_569 VPWR VGND VPWR VGND sky130_ef_sc_hd__decap_12
XFILLER_123_1440 VGND VGND VPWR VPWR sky130_fd_sc_hd__fill_1
XFILLER_7_215 VGND VGND VPWR VPWR sky130_fd_sc_hd__fill_1
XFILLER_7_237 VPWR VGND VPWR VGND sky130_ef_sc_hd__decap_12
XFILLER_32_1356 VGND VGND VPWR VPWR sky130_fd_sc_hd__fill_1
XFILLER_50_20 VGND VGND VPWR VPWR sky130_fd_sc_hd__decap_8
XFILLER_165_783 VGND VGND VPWR VPWR sky130_fd_sc_hd__fill_1
XFILLER_50_53 VPWR VGND VPWR VGND sky130_ef_sc_hd__decap_12
XFILLER_166_53 VPWR VGND VPWR VGND sky130_ef_sc_hd__decap_12
XTAP_TAPCELL_ROW_121_2_3762 VGND VPWR sky130_fd_sc_hd__tapvpwrvgnd_1
XFILLER_50_97 VPWR VGND VPWR VGND sky130_ef_sc_hd__decap_12
XFILLER_193_1449 VGND VGND VPWR VPWR sky130_fd_sc_hd__decap_6
XFILLER_166_97 VPWR VGND VPWR VGND sky130_ef_sc_hd__decap_12
XPHY_EDGE_ROW_8_1_Right_749 VGND VGND VPWR VPWR sky130_fd_sc_hd__decap_3
XFILLER_59_51 VGND VGND VPWR VPWR sky130_fd_sc_hd__decap_4
XFILLER_182_41 VPWR VGND VPWR VGND sky130_ef_sc_hd__decap_12
XFILLER_156_1282 VPWR VGND VPWR VGND sky130_ef_sc_hd__decap_12
XFILLER_117_1244 VPWR VGND VPWR VGND sky130_ef_sc_hd__decap_12
XFILLER_182_85 VPWR VGND VPWR VGND sky130_ef_sc_hd__decap_12
XFILLER_134_1580 VGND VGND VPWR VPWR sky130_fd_sc_hd__fill_1
XTAP_TAPCELL_ROW_68_2_3421 VGND VPWR sky130_fd_sc_hd__tapvpwrvgnd_1
XFILLER_78_1526 VPWR VGND VPWR VGND sky130_ef_sc_hd__decap_12
XFILLER_43_1496 VGND VGND VPWR VPWR sky130_fd_sc_hd__fill_1
XFILLER_208_979 VGND VGND VPWR VPWR sky130_fd_sc_hd__fill_1
XANTENNA_clkload6_A clknet_3_7_0_clk VGND VGND VPWR VPWR sky130_fd_sc_hd__diode_2
XFILLER_201_15 VPWR VGND VPWR VGND sky130_ef_sc_hd__decap_12
XFILLER_61_111 VGND VGND VPWR VPWR sky130_fd_sc_hd__fill_1
XTAP_TAPCELL_ROW_202_2490 VGND VPWR sky130_fd_sc_hd__tapvpwrvgnd_1
XTAP_TAPCELL_ROW_67_1_1151 VGND VPWR sky130_fd_sc_hd__tapvpwrvgnd_1
XFILLER_203_673 VPWR VGND VPWR VGND sky130_ef_sc_hd__decap_12
XFILLER_91_93 VPWR VGND VPWR VGND sky130_ef_sc_hd__decap_12
XFILLER_76_1294 VGND VGND VPWR VPWR sky130_fd_sc_hd__decap_6
XFILLER_37_1256 VPWR VGND VPWR VGND sky130_ef_sc_hd__decap_12
XTAP_TAPCELL_ROW_194_2280 VGND VPWR sky130_fd_sc_hd__tapvpwrvgnd_1
XFILLER_187_385 VGND VGND VPWR VPWR sky130_fd_sc_hd__decap_6
XFILLER_175_503 VGND VGND VPWR VPWR sky130_fd_sc_hd__fill_1
XFILLER_15_1510 VPWR VGND VPWR VGND sky130_ef_sc_hd__decap_12
XFILLER_50_1412 VGND VGND VPWR VPWR sky130_fd_sc_hd__fill_1
XFILLER_204_1261 VPWR VGND VPWR VGND sky130_ef_sc_hd__decap_12
XTAP_TAPCELL_ROW_190_2155 VGND VPWR sky130_fd_sc_hd__tapvpwrvgnd_1
XTAP_TAPCELL_ROW_190_2144 VGND VPWR sky130_fd_sc_hd__tapvpwrvgnd_1
XFILLER_15_1554 VPWR VGND VPWR VGND sky130_ef_sc_hd__decap_12
XTAP_TAPCELL_ROW_215_2862 VGND VPWR sky130_fd_sc_hd__tapvpwrvgnd_1
XFILLER_200_1147 VGND VGND VPWR VPWR sky130_fd_sc_hd__fill_1
XTAP_TAPCELL_ROW_190_2166 VGND VPWR sky130_fd_sc_hd__tapvpwrvgnd_1
XFILLER_102_1524 VGND VGND VPWR VPWR sky130_fd_sc_hd__fill_1
XTAP_TAPCELL_ROW_215_2873 VGND VPWR sky130_fd_sc_hd__tapvpwrvgnd_1
XFILLER_196_1073 VPWR VGND VPWR VGND sky130_ef_sc_hd__decap_12
XTAP_TAPCELL_ROW_155_1_1327 VGND VPWR sky130_fd_sc_hd__tapvpwrvgnd_1
XFILLER_115_113 VPWR VGND VPWR VGND sky130_ef_sc_hd__decap_12
XTAP_TAPCELL_ROW_10_2_3042 VGND VPWR sky130_fd_sc_hd__tapvpwrvgnd_1
XTAP_TAPCELL_ROW_211_2759 VGND VPWR sky130_fd_sc_hd__tapvpwrvgnd_1
XTAP_TAPCELL_ROW_211_2748 VGND VPWR sky130_fd_sc_hd__tapvpwrvgnd_1
XFILLER_171_753 VPWR VGND VPWR VGND sky130_ef_sc_hd__decap_12
XFILLER_100_1270 VPWR VGND VPWR VGND sky130_ef_sc_hd__decap_12
XTAP_TAPCELL_ROW_60_1_1138 VGND VPWR sky130_fd_sc_hd__tapvpwrvgnd_1
XFILLER_171_797 VPWR VGND VPWR VGND sky130_ef_sc_hd__decap_12
XFILLER_83_1232 VPWR VGND VPWR VGND sky130_ef_sc_hd__decap_12
XANTENNA__589__Q b_addr\[5\] VGND VGND VPWR VPWR sky130_fd_sc_hd__diode_2
XTAP_TAPCELL_ROW_188_2095 VGND VPWR sky130_fd_sc_hd__tapvpwrvgnd_1
XTAP_TAPCELL_ROW_188_2084 VGND VPWR sky130_fd_sc_hd__tapvpwrvgnd_1
XFILLER_174_1371 VGND VGND VPWR VPWR sky130_fd_sc_hd__fill_1
XFILLER_135_1322 VGND VGND VPWR VPWR sky130_fd_sc_hd__decap_6
XFILLER_135_1366 VPWR VGND VPWR VGND sky130_ef_sc_hd__decap_12
XFILLER_83_1298 VPWR VGND VPWR VGND sky130_ef_sc_hd__decap_12
XTAP_TAPCELL_ROW_209_2688 VGND VPWR sky130_fd_sc_hd__tapvpwrvgnd_1
XFILLER_61_1552 VGND VGND VPWR VPWR sky130_fd_sc_hd__fill_1
XTAP_TAPCELL_ROW_209_2699 VGND VPWR sky130_fd_sc_hd__tapvpwrvgnd_1
XPHY_EDGE_ROW_179_Left_398 VGND VGND VPWR VPWR sky130_fd_sc_hd__decap_3
XTAP_TAPCELL_ROW_160_2_4020 VGND VPWR sky130_fd_sc_hd__tapvpwrvgnd_1
XTAP_TAPCELL_ROW_159_2_4014 VGND VPWR sky130_fd_sc_hd__tapvpwrvgnd_1
XPHY_EDGE_ROW_86_1_Right_672 VGND VGND VPWR VPWR sky130_fd_sc_hd__decap_3
XFILLER_214_905 VPWR VGND VPWR VGND sky130_ef_sc_hd__decap_12
XFILLER_211_1287 VGND VGND VPWR VPWR sky130_fd_sc_hd__fill_1
XFILLER_214_949 VPWR VGND VPWR VGND sky130_ef_sc_hd__decap_12
XFILLER_197_105 VGND VGND VPWR VPWR sky130_fd_sc_hd__decap_6
XFILLER_164_1017 VPWR VGND VPWR VGND sky130_ef_sc_hd__decap_12
XFILLER_111_15 VPWR VGND VPWR VGND sky130_ef_sc_hd__decap_12
XFILLER_20_1282 VPWR VGND VPWR VGND sky130_ef_sc_hd__decap_12
XFILLER_52_122 VGND VGND VPWR VPWR sky130_fd_sc_hd__decap_4
XFILLER_168_1197 VGND VGND VPWR VPWR sky130_fd_sc_hd__decap_6
XFILLER_94_1350 VGND VGND VPWR VPWR sky130_fd_sc_hd__decap_6
XFILLER_200_109 VPWR VGND VPWR VGND sky130_ef_sc_hd__decap_12
XFILLER_197_149 VPWR VGND VPWR VGND sky130_ef_sc_hd__decap_12
XFILLER_179_853 VPWR VGND VPWR VGND sky130_ef_sc_hd__decap_12
XFILLER_146_1462 VGND VGND VPWR VPWR sky130_fd_sc_hd__decap_6
XFILLER_94_1394 VPWR VGND VPWR VGND sky130_ef_sc_hd__decap_12
XFILLER_179_897 VPWR VGND VPWR VGND sky130_ef_sc_hd__decap_12
XFILLER_178_363 VGND VGND VPWR VPWR sky130_fd_sc_hd__fill_1
XFILLER_166_525 VGND VGND VPWR VPWR sky130_fd_sc_hd__decap_6
XFILLER_142_1326 VPWR VGND VPWR VGND sky130_ef_sc_hd__decap_12
XTAP_TAPCELL_ROW_126_2_3799 VGND VPWR sky130_fd_sc_hd__tapvpwrvgnd_1
XFILLER_90_1258 VPWR VGND VPWR VGND sky130_ef_sc_hd__decap_12
XFILLER_55_1378 VGND VGND VPWR VPWR sky130_fd_sc_hd__decap_6
XFILLER_194_867 VGND VGND VPWR VPWR sky130_fd_sc_hd__fill_1
XFILLER_166_569 VPWR VGND VPWR VGND sky130_ef_sc_hd__decap_12
XFILLER_120_1602 VGND VGND VPWR VPWR sky130_fd_sc_hd__decap_3
XTAP_TAPCELL_ROW_94_2_3588 VGND VPWR sky130_fd_sc_hd__tapvpwrvgnd_1
XFILLER_181_517 VPWR VGND VPWR VGND sky130_ef_sc_hd__decap_12
XTAP_TAPCELL_ROW_173_1663 VGND VPWR sky130_fd_sc_hd__tapvpwrvgnd_1
XTAP_TAPCELL_ROW_106_2_3664 VGND VPWR sky130_fd_sc_hd__tapvpwrvgnd_1
XFILLER_175_1113 VGND VGND VPWR VPWR sky130_fd_sc_hd__decap_6
XTAP_TAPCELL_ROW_173_1674 VGND VPWR sky130_fd_sc_hd__tapvpwrvgnd_1
XANTENNA__540__A1 _174_ VGND VGND VPWR VPWR sky130_fd_sc_hd__diode_2
XFILLER_20_56 VPWR VGND VPWR VGND sky130_ef_sc_hd__decap_12
XFILLER_175_1157 VPWR VGND VPWR VGND sky130_ef_sc_hd__decap_12
XFILLER_121_105 VGND VGND VPWR VPWR sky130_fd_sc_hd__decap_6
XFILLER_1_925 VPWR VGND VPWR VGND sky130_ef_sc_hd__decap_12
XFILLER_0_402 VGND VGND VPWR VPWR sky130_fd_sc_hd__fill_2
XFILLER_153_1422 VPWR VGND VPWR VGND sky130_ef_sc_hd__decap_12
XFILLER_96_27 VGND VGND VPWR VPWR sky130_fd_sc_hd__fill_1
XFILLER_212_1029 VGND VGND VPWR VPWR sky130_fd_sc_hd__decap_6
XFILLER_153_1466 VPWR VGND VPWR VGND sky130_ef_sc_hd__decap_12
XFILLER_114_1406 VGND VGND VPWR VPWR sky130_fd_sc_hd__decap_6
XFILLER_62_1338 VPWR VGND VPWR VGND sky130_ef_sc_hd__decap_12
XFILLER_208_209 VPWR VGND VPWR VGND sky130_ef_sc_hd__decap_12
XFILLER_217_721 VGND VGND VPWR VPWR sky130_fd_sc_hd__decap_6
XFILLER_188_3 VPWR VGND VPWR VGND sky130_ef_sc_hd__decap_12
XTAP_TAPCELL_ROW_167_1489 VGND VPWR sky130_fd_sc_hd__tapvpwrvgnd_1
XFILLER_152_77 VGND VGND VPWR VPWR sky130_fd_sc_hd__decap_6
XFILLER_217_765 VPWR VGND VPWR VGND sky130_ef_sc_hd__decap_12
XFILLER_216_253 VPWR VGND VPWR VGND sky130_ef_sc_hd__decap_12
XFILLER_99_1272 VGND VGND VPWR VPWR sky130_fd_sc_hd__fill_1
X_592_ clknet_3_3_0_clk _026_ VGND VGND VPWR VPWR net57 sky130_fd_sc_hd__dfxtp_1
XFILLER_5_1287 VGND VGND VPWR VPWR sky130_fd_sc_hd__fill_1
XFILLER_189_617 VPWR VGND VPWR VGND sky130_ef_sc_hd__decap_12
XFILLER_186_1253 VGND VGND VPWR VPWR sky130_fd_sc_hd__decap_6
XPHY_EDGE_ROW_111_2_Left_543 VGND VGND VPWR VPWR sky130_fd_sc_hd__decap_3
XFILLER_43_111 VGND VGND VPWR VPWR sky130_fd_sc_hd__fill_1
XFILLER_186_1297 VPWR VGND VPWR VGND sky130_ef_sc_hd__decap_12
XFILLER_182_1117 VPWR VGND VPWR VGND sky130_ef_sc_hd__decap_12
XPHY_EDGE_ROW_160_2_Right_217 VGND VGND VPWR VPWR sky130_fd_sc_hd__decap_3
XFILLER_73_1434 VGND VGND VPWR VPWR sky130_fd_sc_hd__decap_6
XFILLER_169_385 VGND VGND VPWR VPWR sky130_fd_sc_hd__decap_6
XFILLER_164_1595 VGND VGND VPWR VPWR sky130_fd_sc_hd__fill_1
XFILLER_160_1426 VPWR VGND VPWR VGND sky130_ef_sc_hd__decap_12
XFILLER_125_1546 VGND VGND VPWR VPWR sky130_fd_sc_hd__decap_6
XFILLER_101_81 VPWR VGND VPWR VGND sky130_ef_sc_hd__decap_12
XFILLER_73_1478 VPWR VGND VPWR VGND sky130_ef_sc_hd__decap_12
XFILLER_205_1581 VPWR VGND VPWR VGND sky130_ef_sc_hd__decap_12
XFILLER_201_1401 VPWR VGND VPWR VGND sky130_ef_sc_hd__decap_12
XFILLER_200_643 VGND VGND VPWR VPWR sky130_fd_sc_hd__fill_1
XFILLER_184_333 VPWR VGND VPWR VGND sky130_ef_sc_hd__decap_12
XFILLER_185_889 VGND VGND VPWR VPWR sky130_fd_sc_hd__decap_6
XFILLER_184_377 VPWR VGND VPWR VGND sky130_ef_sc_hd__decap_12
XFILLER_158_1300 VGND VGND VPWR VPWR sky130_fd_sc_hd__fill_1
XFILLER_197_1393 VGND VGND VPWR VPWR sky130_fd_sc_hd__decap_6
XFILLER_193_1213 VPWR VGND VPWR VGND sky130_ef_sc_hd__decap_12
XFILLER_10_1462 VGND VGND VPWR VPWR sky130_fd_sc_hd__decap_6
XFILLER_193_1257 VPWR VGND VPWR VGND sky130_ef_sc_hd__decap_12
XFILLER_193_51 VGND VGND VPWR VPWR sky130_fd_sc_hd__decap_4
XFILLER_119_1328 VGND VGND VPWR VPWR sky130_fd_sc_hd__fill_1
XFILLER_101_1590 VPWR VGND VPWR VGND sky130_ef_sc_hd__decap_12
XFILLER_171_1511 VGND VGND VPWR VPWR sky130_fd_sc_hd__fill_1
XFILLER_84_1574 VGND VGND VPWR VPWR sky130_fd_sc_hd__decap_6
XFILLER_3_273 VGND VGND VPWR VPWR sky130_fd_sc_hd__decap_6
XFILLER_132_1506 VPWR VGND VPWR VGND sky130_ef_sc_hd__decap_12
XFILLER_80_1438 VPWR VGND VPWR VGND sky130_ef_sc_hd__decap_12
XFILLER_212_1541 VPWR VGND VPWR VGND sky130_ef_sc_hd__decap_12
XTAP_TAPCELL_ROW_7_1002 VGND VPWR sky130_fd_sc_hd__tapvpwrvgnd_1
XTAP_TAPCELL_ROW_7_1013 VGND VPWR sky130_fd_sc_hd__tapvpwrvgnd_1
XFILLER_6_1029 VGND VGND VPWR VPWR sky130_fd_sc_hd__decap_6
XTAP_TAPCELL_ROW_7_1024 VGND VPWR sky130_fd_sc_hd__tapvpwrvgnd_1
XFILLER_43_1271 VGND VGND VPWR VPWR sky130_fd_sc_hd__fill_2
XTAP_TAPCELL_ROW_204_2552 VGND VPWR sky130_fd_sc_hd__tapvpwrvgnd_1
XTAP_TAPCELL_ROW_204_2541 VGND VPWR sky130_fd_sc_hd__tapvpwrvgnd_1
XTAP_TAPCELL_ROW_143_2_3905 VGND VPWR sky130_fd_sc_hd__tapvpwrvgnd_1
XPHY_EDGE_ROW_43_2_Left_475 VGND VGND VPWR VPWR sky130_fd_sc_hd__decap_3
XTAP_TAPCELL_ROW_204_2563 VGND VPWR sky130_fd_sc_hd__tapvpwrvgnd_1
XFILLER_78_1356 VGND VGND VPWR VPWR sky130_fd_sc_hd__fill_1
XTAP_TAPCELL_ROW_200_2449 VGND VPWR sky130_fd_sc_hd__tapvpwrvgnd_1
XTAP_TAPCELL_ROW_200_2438 VGND VPWR sky130_fd_sc_hd__tapvpwrvgnd_1
XTAP_TAPCELL_ROW_200_2427 VGND VPWR sky130_fd_sc_hd__tapvpwrvgnd_1
XTAP_TAPCELL_ROW_196_2331 VGND VPWR sky130_fd_sc_hd__tapvpwrvgnd_1
XTAP_TAPCELL_ROW_196_2320 VGND VPWR sky130_fd_sc_hd__tapvpwrvgnd_1
XFILLER_179_105 VGND VGND VPWR VPWR sky130_fd_sc_hd__decap_6
XFILLER_165_1337 VGND VGND VPWR VPWR sky130_fd_sc_hd__decap_6
XFILLER_195_609 VGND VGND VPWR VPWR sky130_fd_sc_hd__decap_6
XTAP_TAPCELL_ROW_192_2206 VGND VPWR sky130_fd_sc_hd__tapvpwrvgnd_1
XFILLER_179_149 VPWR VGND VPWR VGND sky130_ef_sc_hd__decap_12
XFILLER_143_1602 VGND VGND VPWR VPWR sky130_fd_sc_hd__decap_3
XFILLER_91_1534 VPWR VGND VPWR VGND sky130_ef_sc_hd__decap_12
XTAP_TAPCELL_ROW_217_2924 VGND VPWR sky130_fd_sc_hd__tapvpwrvgnd_1
XTAP_TAPCELL_ROW_217_2913 VGND VPWR sky130_fd_sc_hd__tapvpwrvgnd_1
XFILLER_204_993 VPWR VGND VPWR VGND sky130_ef_sc_hd__decap_12
XTAP_TAPCELL_ROW_192_2217 VGND VPWR sky130_fd_sc_hd__tapvpwrvgnd_1
XFILLER_163_1061 VGND VGND VPWR VPWR sky130_fd_sc_hd__decap_3
XFILLER_91_1578 VPWR VGND VPWR VGND sky130_ef_sc_hd__decap_12
XTAP_TAPCELL_ROW_80_2_3496 VGND VPWR sky130_fd_sc_hd__tapvpwrvgnd_1
XFILLER_52_1518 VGND VGND VPWR VPWR sky130_fd_sc_hd__decap_6
XTAP_TAPCELL_ROW_217_2935 VGND VPWR sky130_fd_sc_hd__tapvpwrvgnd_1
XFILLER_187_193 VPWR VGND VPWR VGND sky130_ef_sc_hd__decap_12
XFILLER_176_867 VGND VGND VPWR VPWR sky130_fd_sc_hd__fill_1
XFILLER_50_1220 VPWR VGND VPWR VGND sky130_ef_sc_hd__decap_12
XFILLER_204_1091 VGND VGND VPWR VPWR sky130_fd_sc_hd__fill_1
XFILLER_163_517 VPWR VGND VPWR VGND sky130_ef_sc_hd__decap_12
XFILLER_15_1384 VGND VGND VPWR VPWR sky130_fd_sc_hd__fill_1
XFILLER_89_1496 VGND VGND VPWR VPWR sky130_fd_sc_hd__fill_1
XFILLER_176_1477 VGND VGND VPWR VPWR sky130_fd_sc_hd__decap_6
XFILLER_171_561 VPWR VGND VPWR VGND sky130_ef_sc_hd__decap_12
XFILLER_103_105 VGND VGND VPWR VPWR sky130_fd_sc_hd__decap_6
XPHY_EDGE_ROW_107_1_Left_326 VGND VGND VPWR VPWR sky130_fd_sc_hd__decap_3
XFILLER_106_15 VPWR VGND VPWR VGND sky130_ef_sc_hd__decap_12
XTAP_TAPCELL_ROW_39_2_3231 VGND VPWR sky130_fd_sc_hd__tapvpwrvgnd_1
XPHY_EDGE_ROW_187_Left_406 VGND VGND VPWR VPWR sky130_fd_sc_hd__decap_3
XFILLER_6_1541 VPWR VGND VPWR VGND sky130_ef_sc_hd__decap_12
XFILLER_22_1300 VGND VGND VPWR VPWR sky130_fd_sc_hd__fill_1
XTAP_TAPCELL_ROW_181_1910 VGND VPWR sky130_fd_sc_hd__tapvpwrvgnd_1
XFILLER_96_1412 VGND VGND VPWR VPWR sky130_fd_sc_hd__fill_1
XFILLER_2_1427 VGND VGND VPWR VPWR sky130_fd_sc_hd__fill_1
XFILLER_214_713 VPWR VGND VPWR VGND sky130_ef_sc_hd__decap_12
XFILLER_148_1524 VGND VGND VPWR VPWR sky130_fd_sc_hd__fill_1
XPHY_EDGE_ROW_87_1_Right_673 VGND VGND VPWR VPWR sky130_fd_sc_hd__decap_3
XFILLER_82_29 VPWR VGND VPWR VGND sky130_ef_sc_hd__decap_12
XFILLER_214_757 VPWR VGND VPWR VGND sky130_ef_sc_hd__decap_12
XFILLER_213_223 VGND VGND VPWR VPWR sky130_fd_sc_hd__fill_1
XFILLER_198_29 VPWR VGND VPWR VGND sky130_ef_sc_hd__decap_12
XFILLER_183_1437 VPWR VGND VPWR VGND sky130_ef_sc_hd__decap_12
XFILLER_198_469 VGND VGND VPWR VPWR sky130_fd_sc_hd__decap_6
XFILLER_0_1173 VGND VGND VPWR VPWR sky130_fd_sc_hd__decap_3
XFILLER_201_429 VPWR VGND VPWR VGND sky130_ef_sc_hd__decap_12
XPHY_EDGE_ROW_196_Left_415 VGND VGND VPWR VPWR sky130_fd_sc_hd__decap_3
XTAP_TAPCELL_ROW_179_1850 VGND VPWR sky130_fd_sc_hd__tapvpwrvgnd_1
XTAP_TAPCELL_ROW_175_1714 VGND VPWR sky130_fd_sc_hd__tapvpwrvgnd_1
XFILLER_146_1270 VPWR VGND VPWR VGND sky130_ef_sc_hd__decap_12
XFILLER_107_1232 VPWR VGND VPWR VGND sky130_ef_sc_hd__decap_12
XTAP_TAPCELL_ROW_175_1736 VGND VPWR sky130_fd_sc_hd__tapvpwrvgnd_1
XTAP_TAPCELL_ROW_175_1725 VGND VPWR sky130_fd_sc_hd__tapvpwrvgnd_1
XFILLER_166_333 VPWR VGND VPWR VGND sky130_ef_sc_hd__decap_12
XFILLER_167_889 VGND VGND VPWR VPWR sky130_fd_sc_hd__decap_6
XFILLER_166_377 VPWR VGND VPWR VGND sky130_ef_sc_hd__decap_12
XTAP_TAPCELL_ROW_156_2_3994 VGND VPWR sky130_fd_sc_hd__tapvpwrvgnd_1
XFILLER_107_1298 VPWR VGND VPWR VGND sky130_ef_sc_hd__decap_12
XFILLER_33_1440 VGND VGND VPWR VPWR sky130_fd_sc_hd__fill_1
XFILLER_182_837 VPWR VGND VPWR VGND sky130_ef_sc_hd__decap_12
XFILLER_31_77 VPWR VGND VPWR VGND sky130_ef_sc_hd__decap_12
XFILLER_218_1205 VPWR VGND VPWR VGND sky130_ef_sc_hd__decap_12
XFILLER_194_1533 VGND VGND VPWR VPWR sky130_fd_sc_hd__decap_6
XFILLER_147_55 VGND VGND VPWR VPWR sky130_fd_sc_hd__fill_1
XFILLER_194_1577 VPWR VGND VPWR VGND sky130_ef_sc_hd__decap_12
XFILLER_190_881 VPWR VGND VPWR VGND sky130_ef_sc_hd__decap_12
XFILLER_103_3 VPWR VGND VPWR VGND sky130_ef_sc_hd__decap_12
XTAP_TAPCELL_ROW_29_1_1076 VGND VPWR sky130_fd_sc_hd__tapvpwrvgnd_1
XPHY_EDGE_ROW_39_1_Left_258 VGND VGND VPWR VPWR sky130_fd_sc_hd__decap_3
Xoutput66 net66 VGND VGND VPWR VPWR bist_fail_bits[18] sky130_fd_sc_hd__buf_2
XFILLER_0_221 VGND VGND VPWR VPWR sky130_fd_sc_hd__decap_3
Xoutput55 net55 VGND VGND VPWR VPWR bist_fail_addr[6] sky130_fd_sc_hd__buf_2
XFILLER_118_1350 VGND VGND VPWR VPWR sky130_fd_sc_hd__decap_6
XFILLER_66_1282 VPWR VGND VPWR VGND sky130_ef_sc_hd__decap_12
Xoutput99 net99 VGND VGND VPWR VPWR func_rdata[19] sky130_fd_sc_hd__buf_2
XFILLER_1_755 VGND VGND VPWR VPWR sky130_fd_sc_hd__decap_6
Xoutput77 net77 VGND VGND VPWR VPWR bist_fail_bits[28] sky130_fd_sc_hd__buf_2
Xoutput88 net88 VGND VGND VPWR VPWR bist_fail_bits[9] sky130_fd_sc_hd__buf_2
XFILLER_27_1244 VPWR VGND VPWR VGND sky130_ef_sc_hd__decap_12
XFILLER_153_1274 VPWR VGND VPWR VGND sky130_ef_sc_hd__decap_12
XFILLER_118_1394 VPWR VGND VPWR VGND sky130_ef_sc_hd__decap_12
XFILLER_209_529 VPWR VGND VPWR VGND sky130_ef_sc_hd__decap_12
XFILLER_188_1315 VGND VGND VPWR VPWR sky130_fd_sc_hd__fill_1
XFILLER_114_1258 VPWR VGND VPWR VGND sky130_ef_sc_hd__decap_12
XFILLER_0_298 VGND VGND VPWR VPWR sky130_fd_sc_hd__decap_3
XANTENNA_input23_A func_wdata[1] VGND VGND VPWR VPWR sky130_fd_sc_hd__diode_2
XFILLER_44_1580 VGND VGND VPWR VPWR sky130_fd_sc_hd__fill_1
XFILLER_56_41 VPWR VGND VPWR VGND sky130_ef_sc_hd__decap_12
XTAP_TAPCELL_ROW_128_2_3807 VGND VPWR sky130_fd_sc_hd__tapvpwrvgnd_1
XFILLER_217_573 VPWR VGND VPWR VGND sky130_ef_sc_hd__decap_12
XFILLER_186_1061 VPWR VGND VPWR VGND sky130_ef_sc_hd__decap_12
XPHY_EDGE_ROW_153_1_Left_372 VGND VGND VPWR VPWR sky130_fd_sc_hd__decap_3
X_575_ clknet_3_0_0_clk _013_ VGND VGND VPWR VPWR u_ctrl.cmp_addr\[7\] sky130_fd_sc_hd__dfxtp_1
XFILLER_204_245 VGND VGND VPWR VPWR sky130_fd_sc_hd__decap_6
XFILLER_189_447 VGND VGND VPWR VPWR sky130_fd_sc_hd__fill_1
XFILLER_177_609 VGND VGND VPWR VPWR sky130_fd_sc_hd__decap_6
XFILLER_73_1220 VPWR VGND VPWR VGND sky130_ef_sc_hd__decap_12
XFILLER_204_289 VPWR VGND VPWR VGND sky130_ef_sc_hd__decap_12
XFILLER_198_981 VPWR VGND VPWR VGND sky130_ef_sc_hd__decap_12
XFILLER_129_1490 VGND VGND VPWR VPWR sky130_fd_sc_hd__decap_6
XFILLER_125_1310 VPWR VGND VPWR VGND sky130_ef_sc_hd__decap_12
XTAP_TAPCELL_ROW_84_1_1186 VGND VPWR sky130_fd_sc_hd__tapvpwrvgnd_1
XTAP_TAPCELL_ROW_65_2_3398 VGND VPWR sky130_fd_sc_hd__tapvpwrvgnd_1
XFILLER_169_193 VPWR VGND VPWR VGND sky130_ef_sc_hd__decap_12
XPHY_EDGE_ROW_161_2_Right_218 VGND VGND VPWR VPWR sky130_fd_sc_hd__decap_3
XFILLER_125_1354 VPWR VGND VPWR VGND sky130_ef_sc_hd__decap_12
XFILLER_73_1286 VPWR VGND VPWR VGND sky130_ef_sc_hd__decap_12
XFILLER_199_1455 VGND VGND VPWR VPWR sky130_fd_sc_hd__fill_1
XFILLER_185_653 VPWR VGND VPWR VGND sky130_ef_sc_hd__decap_12
XFILLER_184_141 VPWR VGND VPWR VGND sky130_ef_sc_hd__decap_12
XFILLER_125_1398 VPWR VGND VPWR VGND sky130_ef_sc_hd__decap_12
XANTENNA__424__A b_addr\[6\] VGND VGND VPWR VPWR sky130_fd_sc_hd__diode_2
XFILLER_201_1231 VGND VGND VPWR VPWR sky130_fd_sc_hd__fill_1
XPHY_EDGE_ROW_200_Left_419 VGND VGND VPWR VPWR sky130_fd_sc_hd__decap_3
XFILLER_185_697 VPWR VGND VPWR VGND sky130_ef_sc_hd__decap_12
XFILLER_12_1524 VGND VGND VPWR VPWR sky130_fd_sc_hd__fill_1
XANTENNA_output91_A net91 VGND VGND VPWR VPWR sky130_fd_sc_hd__diode_2
XFILLER_193_1021 VPWR VGND VPWR VGND sky130_ef_sc_hd__decap_12
XFILLER_10_1270 VPWR VGND VPWR VGND sky130_ef_sc_hd__decap_12
XFILLER_207_69 VPWR VGND VPWR VGND sky130_ef_sc_hd__decap_12
XFILLER_193_1065 VPWR VGND VPWR VGND sky130_ef_sc_hd__decap_12
XTAP_TAPCELL_ROW_185_2021 VGND VPWR sky130_fd_sc_hd__tapvpwrvgnd_1
XTAP_TAPCELL_ROW_185_2010 VGND VPWR sky130_fd_sc_hd__tapvpwrvgnd_1
XFILLER_136_1450 VPWR VGND VPWR VGND sky130_ef_sc_hd__decap_12
XFILLER_97_81 VPWR VGND VPWR VGND sky130_ef_sc_hd__decap_12
XFILLER_84_1382 VPWR VGND VPWR VGND sky130_ef_sc_hd__decap_12
XFILLER_45_1322 VGND VGND VPWR VPWR sky130_fd_sc_hd__decap_6
XTAP_TAPCELL_ROW_206_2603 VGND VPWR sky130_fd_sc_hd__tapvpwrvgnd_1
XFILLER_136_1494 VPWR VGND VPWR VGND sky130_ef_sc_hd__decap_12
XFILLER_132_1314 VPWR VGND VPWR VGND sky130_ef_sc_hd__decap_12
XFILLER_80_1246 VPWR VGND VPWR VGND sky130_ef_sc_hd__decap_12
XFILLER_45_1366 VPWR VGND VPWR VGND sky130_ef_sc_hd__decap_12
XTAP_TAPCELL_ROW_206_2625 VGND VPWR sky130_fd_sc_hd__tapvpwrvgnd_1
XTAP_TAPCELL_ROW_206_2614 VGND VPWR sky130_fd_sc_hd__tapvpwrvgnd_1
XFILLER_132_1358 VPWR VGND VPWR VGND sky130_ef_sc_hd__decap_12
XFILLER_212_1371 VGND VGND VPWR VPWR sky130_fd_sc_hd__fill_1
XFILLER_169_1281 VGND VGND VPWR VPWR sky130_fd_sc_hd__decap_6
XFILLER_165_1101 VPWR VGND VPWR VGND sky130_ef_sc_hd__decap_12
XFILLER_208_1429 VPWR VGND VPWR VGND sky130_ef_sc_hd__decap_12
XFILLER_165_1145 VPWR VGND VPWR VGND sky130_ef_sc_hd__decap_12
XFILLER_1_1493 VPWR VGND VPWR VGND sky130_ef_sc_hd__decap_12
XFILLER_211_727 VGND VGND VPWR VPWR sky130_fd_sc_hd__fill_1
XFILLER_195_417 VPWR VGND VPWR VGND sky130_ef_sc_hd__decap_12
XFILLER_165_1189 VPWR VGND VPWR VGND sky130_ef_sc_hd__decap_12
XFILLER_147_1590 VPWR VGND VPWR VGND sky130_ef_sc_hd__decap_12
XFILLER_143_1410 VPWR VGND VPWR VGND sky130_ef_sc_hd__decap_12
XFILLER_91_1342 VPWR VGND VPWR VGND sky130_ef_sc_hd__decap_12
XFILLER_56_1462 VGND VGND VPWR VPWR sky130_fd_sc_hd__decap_6
XFILLER_143_1454 VPWR VGND VPWR VGND sky130_ef_sc_hd__decap_12
XFILLER_108_1574 VGND VGND VPWR VPWR sky130_fd_sc_hd__decap_6
XFILLER_91_1386 VPWR VGND VPWR VGND sky130_ef_sc_hd__decap_12
XFILLER_52_1326 VPWR VGND VPWR VGND sky130_ef_sc_hd__decap_12
XFILLER_206_1197 VGND VGND VPWR VPWR sky130_fd_sc_hd__decap_6
XFILLER_202_1017 VPWR VGND VPWR VGND sky130_ef_sc_hd__decap_12
XFILLER_143_1498 VPWR VGND VPWR VGND sky130_ef_sc_hd__decap_12
XFILLER_104_1438 VPWR VGND VPWR VGND sky130_ef_sc_hd__decap_12
XFILLER_30_1602 VGND VGND VPWR VPWR sky130_fd_sc_hd__decap_3
XFILLER_178_1539 VGND VGND VPWR VPWR sky130_fd_sc_hd__fill_1
XFILLER_164_837 VPWR VGND VPWR VGND sky130_ef_sc_hd__decap_12
XFILLER_190_133 VGND VGND VPWR VPWR sky130_fd_sc_hd__decap_6
XFILLER_219_1525 VPWR VGND VPWR VGND sky130_ef_sc_hd__decap_12
XFILLER_190_177 VPWR VGND VPWR VGND sky130_ef_sc_hd__decap_12
XFILLER_176_1241 VPWR VGND VPWR VGND sky130_ef_sc_hd__decap_12
XFILLER_172_881 VPWR VGND VPWR VGND sky130_ef_sc_hd__decap_12
XFILLER_219_1569 VPWR VGND VPWR VGND sky130_ef_sc_hd__decap_12
XFILLER_176_1285 VPWR VGND VPWR VGND sky130_ef_sc_hd__decap_12
XFILLER_172_1105 VPWR VGND VPWR VGND sky130_ef_sc_hd__decap_12
XFILLER_171_391 VGND VGND VPWR VPWR sky130_fd_sc_hd__fill_1
XFILLER_117_69 VPWR VGND VPWR VGND sky130_ef_sc_hd__decap_12
XFILLER_89_125 VGND VGND VPWR VPWR sky130_fd_sc_hd__fill_2
XFILLER_172_1149 VPWR VGND VPWR VGND sky130_ef_sc_hd__decap_12
XFILLER_154_1550 VPWR VGND VPWR VGND sky130_ef_sc_hd__decap_12
XFILLER_63_1422 VPWR VGND VPWR VGND sky130_ef_sc_hd__decap_12
XFILLER_213_1113 VGND VGND VPWR VPWR sky130_fd_sc_hd__decap_6
XTAP_TAPCELL_ROW_168_1540 VGND VPWR sky130_fd_sc_hd__tapvpwrvgnd_1
XFILLER_154_1594 VGND VGND VPWR VPWR sky130_fd_sc_hd__decap_8
XFILLER_150_1414 VPWR VGND VPWR VGND sky130_ef_sc_hd__decap_12
XFILLER_115_1534 VPWR VGND VPWR VGND sky130_ef_sc_hd__decap_12
XFILLER_63_1466 VPWR VGND VPWR VGND sky130_ef_sc_hd__decap_12
XFILLER_24_1406 VGND VGND VPWR VPWR sky130_fd_sc_hd__decap_6
XFILLER_213_1157 VPWR VGND VPWR VGND sky130_ef_sc_hd__decap_12
XTAP_TAPCELL_ROW_164_1426 VGND VPWR sky130_fd_sc_hd__tapvpwrvgnd_1
XTAP_TAPCELL_ROW_164_1415 VGND VPWR sky130_fd_sc_hd__tapvpwrvgnd_1
XTAP_TAPCELL_ROW_164_1404 VGND VPWR sky130_fd_sc_hd__tapvpwrvgnd_1
XFILLER_133_57 VPWR VGND VPWR VGND sky130_ef_sc_hd__decap_12
XFILLER_115_1578 VPWR VGND VPWR VGND sky130_ef_sc_hd__decap_12
XFILLER_98_1518 VGND VGND VPWR VPWR sky130_fd_sc_hd__decap_6
XFILLER_93_39 VPWR VGND VPWR VGND sky130_ef_sc_hd__decap_12
XFILLER_6_1371 VGND VGND VPWR VPWR sky130_fd_sc_hd__fill_1
XFILLER_96_1220 VPWR VGND VPWR VGND sky130_ef_sc_hd__decap_12
XFILLER_187_1381 VPWR VGND VPWR VGND sky130_ef_sc_hd__decap_12
XFILLER_183_1201 VPWR VGND VPWR VGND sky130_ef_sc_hd__decap_12
XPHY_EDGE_ROW_88_1_Right_674 VGND VGND VPWR VPWR sky130_fd_sc_hd__decap_3
XFILLER_26_55 VGND VGND VPWR VPWR sky130_fd_sc_hd__decap_8
XFILLER_198_233 VPWR VGND VPWR VGND sky130_ef_sc_hd__decap_12
XFILLER_183_1245 VPWR VGND VPWR VGND sky130_ef_sc_hd__decap_12
X_360_ u_ctrl.elem_idx\[1\] u_ctrl.elem_idx\[0\] u_ctrl.elem_idx\[2\] VGND VGND VPWR
+ VPWR _103_ sky130_fd_sc_hd__a21o_1
XFILLER_214_587 VGND VGND VPWR VPWR sky130_fd_sc_hd__fill_1
XFILLER_202_749 VGND VGND VPWR VPWR sky130_fd_sc_hd__decap_6
XFILLER_198_277 VPWR VGND VPWR VGND sky130_ef_sc_hd__decap_12
XFILLER_183_1289 VPWR VGND VPWR VGND sky130_ef_sc_hd__decap_12
XFILLER_161_1510 VPWR VGND VPWR VGND sky130_ef_sc_hd__decap_12
XFILLER_74_1562 VPWR VGND VPWR VGND sky130_ef_sc_hd__decap_12
XFILLER_13_125 VGND VGND VPWR VPWR sky130_fd_sc_hd__fill_2
XFILLER_201_237 VPWR VGND VPWR VGND sky130_ef_sc_hd__decap_12
XFILLER_195_951 VGND VGND VPWR VPWR sky130_fd_sc_hd__fill_1
XFILLER_161_1554 VPWR VGND VPWR VGND sky130_ef_sc_hd__decap_12
XFILLER_70_1426 VPWR VGND VPWR VGND sky130_ef_sc_hd__decap_12
X_291_ u_ctrl.elem_idx\[0\] _072_ _084_ _085_ VGND VGND VPWR VPWR _086_ sky130_fd_sc_hd__o211ai_4
XFILLER_35_1546 VGND VGND VPWR VPWR sky130_fd_sc_hd__decap_6
XFILLER_182_601 VPWR VGND VPWR VGND sky130_ef_sc_hd__decap_12
XFILLER_167_653 VPWR VGND VPWR VGND sky130_ef_sc_hd__decap_12
XFILLER_166_141 VPWR VGND VPWR VGND sky130_ef_sc_hd__decap_12
XFILLER_122_1538 VPWR VGND VPWR VGND sky130_ef_sc_hd__decap_12
XTAP_TAPCELL_ROW_31_2_3182 VGND VPWR sky130_fd_sc_hd__tapvpwrvgnd_1
XFILLER_42_65 VPWR VGND VPWR VGND sky130_ef_sc_hd__decap_12
XFILLER_210_793 VPWR VGND VPWR VGND sky130_ef_sc_hd__decap_12
XFILLER_181_111 VGND VGND VPWR VPWR sky130_fd_sc_hd__fill_1
XFILLER_167_697 VPWR VGND VPWR VGND sky130_ef_sc_hd__decap_12
XFILLER_158_65 VPWR VGND VPWR VGND sky130_ef_sc_hd__decap_12
XFILLER_6_825 VPWR VGND VPWR VGND sky130_ef_sc_hd__decap_12
XFILLER_202_1595 VGND VGND VPWR VPWR sky130_fd_sc_hd__fill_1
XFILLER_182_645 VPWR VGND VPWR VGND sky130_ef_sc_hd__decap_12
XFILLER_68_1300 VGND VGND VPWR VPWR sky130_fd_sc_hd__fill_1
XFILLER_6_869 VPWR VGND VPWR VGND sky130_ef_sc_hd__decap_12
XFILLER_194_1341 VPWR VGND VPWR VGND sky130_ef_sc_hd__decap_12
XFILLER_163_881 VPWR VGND VPWR VGND sky130_ef_sc_hd__decap_12
XFILLER_218_1035 VGND VGND VPWR VPWR sky130_fd_sc_hd__fill_1
XFILLER_194_1385 VPWR VGND VPWR VGND sky130_ef_sc_hd__decap_12
XFILLER_190_1205 VPWR VGND VPWR VGND sky130_ef_sc_hd__decap_12
XFILLER_174_53 VPWR VGND VPWR VGND sky130_ef_sc_hd__decap_12
XFILLER_11_1590 VPWR VGND VPWR VGND sky130_ef_sc_hd__decap_12
XFILLER_29_1328 VGND VGND VPWR VPWR sky130_fd_sc_hd__fill_1
XFILLER_174_97 VPWR VGND VPWR VGND sky130_ef_sc_hd__decap_12
XFILLER_81_1522 VPWR VGND VPWR VGND sky130_ef_sc_hd__decap_12
XFILLER_3_15 VPWR VGND VPWR VGND sky130_ef_sc_hd__decap_12
XFILLER_81_1566 VPWR VGND VPWR VGND sky130_ef_sc_hd__decap_12
XFILLER_67_51 VGND VGND VPWR VPWR sky130_fd_sc_hd__decap_4
XFILLER_42_1506 VPWR VGND VPWR VGND sky130_ef_sc_hd__decap_12
XFILLER_190_41 VPWR VGND VPWR VGND sky130_ef_sc_hd__decap_12
XFILLER_209_337 VPWR VGND VPWR VGND sky130_ef_sc_hd__decap_12
XFILLER_190_85 VPWR VGND VPWR VGND sky130_ef_sc_hd__decap_12
XFILLER_79_1440 VGND VGND VPWR VPWR sky130_fd_sc_hd__fill_1
XFILLER_218_893 VPWR VGND VPWR VGND sky130_ef_sc_hd__decap_12
XFILLER_166_1421 VGND VGND VPWR VPWR sky130_fd_sc_hd__decap_6
X_627_ clknet_3_2_0_clk _061_ VGND VGND VPWR VPWR net52 sky130_fd_sc_hd__dfxtp_1
XFILLER_166_1465 VPWR VGND VPWR VGND sky130_ef_sc_hd__decap_12
X_558_ net54 u_ctrl.cmp_addr\[5\] net122 VGND VGND VPWR VPWR _253_ sky130_fd_sc_hd__mux2_1
XFILLER_177_417 VPWR VGND VPWR VGND sky130_ef_sc_hd__decap_12
XFILLER_53_1602 VGND VGND VPWR VPWR sky130_fd_sc_hd__decap_3
XPHY_EDGE_ROW_164_Right_9 VGND VGND VPWR VPWR sky130_fd_sc_hd__decap_3
X_489_ net149 _189_ net127 net135 _218_ VGND VGND VPWR VPWR _028_ sky130_fd_sc_hd__o311a_1
XFILLER_203_1337 VGND VGND VPWR VPWR sky130_fd_sc_hd__decap_6
XFILLER_186_973 VGND VGND VPWR VPWR sky130_fd_sc_hd__decap_6
XPHY_EDGE_ROW_162_2_Right_219 VGND VGND VPWR VPWR sky130_fd_sc_hd__decap_3
XTAP_TAPCELL_ROW_95_2_3593 VGND VPWR sky130_fd_sc_hd__tapvpwrvgnd_1
XFILLER_185_461 VPWR VGND VPWR VGND sky130_ef_sc_hd__decap_12
XFILLER_172_133 VGND VGND VPWR VPWR sky130_fd_sc_hd__decap_6
XFILLER_66_3 VPWR VGND VPWR VGND sky130_ef_sc_hd__decap_12
XFILLER_177_1561 VGND VGND VPWR VPWR sky130_fd_sc_hd__decap_6
XFILLER_172_177 VPWR VGND VPWR VGND sky130_ef_sc_hd__decap_12
XTAP_TAPCELL_ROW_120_2_3758 VGND VPWR sky130_fd_sc_hd__tapvpwrvgnd_1
XTAP_TAPCELL_ROW_107_1_1232 VGND VPWR sky130_fd_sc_hd__tapvpwrvgnd_1
XANTENNA__489__B1 net135 VGND VGND VPWR VPWR sky130_fd_sc_hd__diode_2
XFILLER_173_1425 VPWR VGND VPWR VGND sky130_ef_sc_hd__decap_12
XFILLER_173_1469 VPWR VGND VPWR VGND sky130_ef_sc_hd__decap_12
XFILLER_214_1477 VGND VGND VPWR VPWR sky130_fd_sc_hd__decap_6
XFILLER_3_1511 VGND VGND VPWR VPWR sky130_fd_sc_hd__fill_1
XFILLER_103_27 VPWR VGND VPWR VGND sky130_ef_sc_hd__decap_12
XFILLER_215_329 VGND VGND VPWR VPWR sky130_fd_sc_hd__decap_6
XFILLER_184_1521 VPWR VGND VPWR VGND sky130_ef_sc_hd__decap_12
XANTENNA__413__B1 net156 VGND VGND VPWR VPWR sky130_fd_sc_hd__diode_2
XFILLER_58_1524 VGND VGND VPWR VPWR sky130_fd_sc_hd__fill_1
XFILLER_184_1565 VPWR VGND VPWR VGND sky130_ef_sc_hd__decap_12
XTAP_TAPCELL_ROW_162_1_1342 VGND VPWR sky130_fd_sc_hd__tapvpwrvgnd_1
XFILLER_208_1259 VGND VGND VPWR VPWR sky130_fd_sc_hd__fill_1
XFILLER_180_1429 VPWR VGND VPWR VGND sky130_ef_sc_hd__decap_12
XFILLER_196_737 VPWR VGND VPWR VGND sky130_ef_sc_hd__decap_12
XFILLER_195_225 VPWR VGND VPWR VGND sky130_ef_sc_hd__decap_12
XTAP_TAPCELL_ROW_16_2_3084 VGND VPWR sky130_fd_sc_hd__tapvpwrvgnd_1
XFILLER_17_1232 VPWR VGND VPWR VGND sky130_ef_sc_hd__decap_12
XFILLER_56_1270 VPWR VGND VPWR VGND sky130_ef_sc_hd__decap_12
XFILLER_177_951 VGND VGND VPWR VPWR sky130_fd_sc_hd__fill_1
XFILLER_108_1382 VPWR VGND VPWR VGND sky130_ef_sc_hd__decap_12
XFILLER_164_601 VPWR VGND VPWR VGND sky130_ef_sc_hd__decap_12
XFILLER_104_1246 VPWR VGND VPWR VGND sky130_ef_sc_hd__decap_12
XFILLER_17_1298 VPWR VGND VPWR VGND sky130_ef_sc_hd__decap_12
XFILLER_164_645 VPWR VGND VPWR VGND sky130_ef_sc_hd__decap_12
XPHY_EDGE_ROW_68_2_Left_500 VGND VGND VPWR VPWR sky130_fd_sc_hd__decap_3
XFILLER_2_305 VGND VGND VPWR VPWR sky130_fd_sc_hd__fill_1
XFILLER_191_1525 VPWR VGND VPWR VGND sky130_ef_sc_hd__decap_12
XFILLER_191_497 VGND VGND VPWR VPWR sky130_fd_sc_hd__decap_6
XFILLER_3_839 VGND VGND VPWR VPWR sky130_fd_sc_hd__fill_1
XFILLER_176_1093 VPWR VGND VPWR VGND sky130_ef_sc_hd__decap_12
XPHY_EDGE_ROW_120_2_Left_552 VGND VGND VPWR VPWR sky130_fd_sc_hd__decap_3
XFILLER_191_1569 VPWR VGND VPWR VGND sky130_ef_sc_hd__decap_12
XFILLER_28_1350 VGND VGND VPWR VPWR sky130_fd_sc_hd__decap_6
XFILLER_219_613 VGND VGND VPWR VPWR sky130_fd_sc_hd__decap_3
XFILLER_115_1342 VPWR VGND VPWR VGND sky130_ef_sc_hd__decap_12
XFILLER_63_1274 VPWR VGND VPWR VGND sky130_ef_sc_hd__decap_12
XFILLER_28_1394 VPWR VGND VPWR VGND sky130_ef_sc_hd__decap_12
XFILLER_219_657 VPWR VGND VPWR VGND sky130_ef_sc_hd__decap_12
XFILLER_150_1244 VGND VGND VPWR VPWR sky130_fd_sc_hd__fill_1
XFILLER_115_1386 VPWR VGND VPWR VGND sky130_ef_sc_hd__decap_12
XFILLER_98_1326 VPWR VGND VPWR VGND sky130_ef_sc_hd__decap_12
XFILLER_92_109 VPWR VGND VPWR VGND sky130_ef_sc_hd__decap_12
XFILLER_24_1258 VPWR VGND VPWR VGND sky130_ef_sc_hd__decap_12
XFILLER_206_307 VGND VGND VPWR VPWR sky130_fd_sc_hd__fill_1
XFILLER_170_3 VPWR VGND VPWR VGND sky130_ef_sc_hd__decap_12
XTAP_TAPCELL_ROW_2_850 VGND VPWR sky130_fd_sc_hd__tapvpwrvgnd_1
XFILLER_218_189 VGND VGND VPWR VPWR sky130_fd_sc_hd__decap_6
XFILLER_215_841 VPWR VGND VPWR VGND sky130_ef_sc_hd__decap_12
XFILLER_160_77 VGND VGND VPWR VPWR sky130_fd_sc_hd__decap_6
XFILLER_76_1602 VGND VGND VPWR VPWR sky130_fd_sc_hd__decap_3
XTAP_TAPCELL_ROW_2_861 VGND VPWR sky130_fd_sc_hd__tapvpwrvgnd_1
XFILLER_199_553 VGND VGND VPWR VPWR sky130_fd_sc_hd__decap_6
X_412_ b_addr\[4\] _102_ VGND VGND VPWR VPWR _148_ sky130_fd_sc_hd__and2_1
XFILLER_202_513 VPWR VGND VPWR VGND sky130_ef_sc_hd__decap_12
XPHY_EDGE_ROW_89_1_Right_675 VGND VGND VPWR VPWR sky130_fd_sc_hd__decap_3
XFILLER_202_557 VPWR VGND VPWR VGND sky130_ef_sc_hd__decap_12
XFILLER_199_597 VPWR VGND VPWR VGND sky130_ef_sc_hd__decap_12
XFILLER_74_1370 VPWR VGND VPWR VGND sky130_ef_sc_hd__decap_12
X_343_ net155 _092_ VGND VGND VPWR VPWR _008_ sky130_fd_sc_hd__and2_1
XFILLER_35_1310 VPWR VGND VPWR VGND sky130_ef_sc_hd__decap_12
XFILLER_39_1490 VGND VGND VPWR VPWR sky130_fd_sc_hd__decap_6
XFILLER_168_973 VGND VGND VPWR VPWR sky130_fd_sc_hd__decap_6
XFILLER_126_1482 VPWR VGND VPWR VGND sky130_ef_sc_hd__decap_12
XFILLER_122_1302 VPWR VGND VPWR VGND sky130_ef_sc_hd__decap_12
X_274_ net174 VGND VGND VPWR VPWR _073_ sky130_fd_sc_hd__inv_2
XFILLER_35_1354 VPWR VGND VPWR VGND sky130_ef_sc_hd__decap_12
XFILLER_183_921 VPWR VGND VPWR VGND sky130_ef_sc_hd__decap_12
XFILLER_167_461 VPWR VGND VPWR VGND sky130_ef_sc_hd__decap_12
XFILLER_161_1384 VGND VGND VPWR VPWR sky130_fd_sc_hd__fill_1
XFILLER_35_1398 VPWR VGND VPWR VGND sky130_ef_sc_hd__decap_12
XFILLER_183_965 VPWR VGND VPWR VGND sky130_ef_sc_hd__decap_12
XFILLER_182_475 VGND VGND VPWR VPWR sky130_fd_sc_hd__fill_1
XFILLER_170_637 VGND VGND VPWR VPWR sky130_fd_sc_hd__decap_6
XFILLER_6_699 VGND VGND VPWR VPWR sky130_fd_sc_hd__fill_1
XPHY_EDGE_ROW_52_2_Left_484 VGND VGND VPWR VPWR sky130_fd_sc_hd__decap_3
XFILLER_190_1035 VGND VGND VPWR VPWR sky130_fd_sc_hd__fill_1
XFILLER_2_861 VGND VGND VPWR VPWR sky130_fd_sc_hd__fill_2
XFILLER_81_1330 VPWR VGND VPWR VGND sky130_ef_sc_hd__decap_12
XFILLER_78_83 VGND VGND VPWR VPWR sky130_fd_sc_hd__fill_1
XFILLER_46_1450 VPWR VGND VPWR VGND sky130_ef_sc_hd__decap_12
XFILLER_204_15 VPWR VGND VPWR VGND sky130_ef_sc_hd__decap_12
XFILLER_133_1442 VPWR VGND VPWR VGND sky130_ef_sc_hd__decap_12
XFILLER_1_393 VGND VGND VPWR VPWR sky130_fd_sc_hd__decap_3
XFILLER_42_1314 VPWR VGND VPWR VGND sky130_ef_sc_hd__decap_12
XFILLER_46_1494 VPWR VGND VPWR VGND sky130_ef_sc_hd__decap_12
XTAP_TAPCELL_ROW_53_2_3325 VGND VPWR sky130_fd_sc_hd__tapvpwrvgnd_1
XFILLER_42_1358 VPWR VGND VPWR VGND sky130_ef_sc_hd__decap_12
XFILLER_209_167 VGND VGND VPWR VPWR sky130_fd_sc_hd__fill_1
XFILLER_209_1513 VPWR VGND VPWR VGND sky130_ef_sc_hd__decap_12
XFILLER_205_373 VPWR VGND VPWR VGND sky130_ef_sc_hd__decap_12
XFILLER_166_1273 VPWR VGND VPWR VGND sky130_ef_sc_hd__decap_12
XFILLER_178_737 VPWR VGND VPWR VGND sky130_ef_sc_hd__decap_12
XFILLER_177_225 VPWR VGND VPWR VGND sky130_ef_sc_hd__decap_12
XFILLER_127_1268 VGND VGND VPWR VPWR sky130_fd_sc_hd__decap_4
XFILLER_92_1470 VPWR VGND VPWR VGND sky130_ef_sc_hd__decap_12
XFILLER_53_1410 VPWR VGND VPWR VGND sky130_ef_sc_hd__decap_12
XFILLER_57_1590 VPWR VGND VPWR VGND sky130_ef_sc_hd__decap_12
XFILLER_207_1281 VGND VGND VPWR VPWR sky130_fd_sc_hd__decap_6
XFILLER_203_1101 VPWR VGND VPWR VGND sky130_ef_sc_hd__decap_12
XPHY_EDGE_ROW_116_1_Left_335 VGND VGND VPWR VPWR sky130_fd_sc_hd__decap_3
XFILLER_105_1522 VPWR VGND VPWR VGND sky130_ef_sc_hd__decap_12
XFILLER_18_1574 VGND VGND VPWR VPWR sky130_fd_sc_hd__decap_6
XFILLER_53_1454 VPWR VGND VPWR VGND sky130_ef_sc_hd__decap_12
XFILLER_203_1145 VPWR VGND VPWR VGND sky130_ef_sc_hd__decap_12
XFILLER_193_729 VPWR VGND VPWR VGND sky130_ef_sc_hd__decap_12
XFILLER_186_781 VPWR VGND VPWR VGND sky130_ef_sc_hd__decap_12
XFILLER_144_1582 VPWR VGND VPWR VGND sky130_ef_sc_hd__decap_12
XFILLER_105_1566 VPWR VGND VPWR VGND sky130_ef_sc_hd__decap_12
XFILLER_88_1506 VPWR VGND VPWR VGND sky130_ef_sc_hd__decap_12
XFILLER_14_1438 VPWR VGND VPWR VGND sky130_ef_sc_hd__decap_12
XFILLER_53_1498 VPWR VGND VPWR VGND sky130_ef_sc_hd__decap_12
XFILLER_203_1189 VPWR VGND VPWR VGND sky130_ef_sc_hd__decap_12
XFILLER_145_111 VGND VGND VPWR VPWR sky130_fd_sc_hd__fill_1
XFILLER_140_1468 VGND VGND VPWR VPWR sky130_fd_sc_hd__fill_1
XFILLER_173_497 VGND VGND VPWR VPWR sky130_fd_sc_hd__decap_6
XTAP_TAPCELL_ROW_43_1_1104 VGND VPWR sky130_fd_sc_hd__tapvpwrvgnd_1
XFILLER_173_1233 VPWR VGND VPWR VGND sky130_ef_sc_hd__decap_12
XFILLER_0_809 VGND VGND VPWR VPWR sky130_fd_sc_hd__decap_3
XFILLER_216_1539 VGND VGND VPWR VPWR sky130_fd_sc_hd__fill_1
XTAP_TAPCELL_ROW_149_2_3947 VGND VPWR sky130_fd_sc_hd__tapvpwrvgnd_1
XTAP_TAPCELL_ROW_150_2_3953 VGND VPWR sky130_fd_sc_hd__tapvpwrvgnd_1
XFILLER_64_1550 VPWR VGND VPWR VGND sky130_ef_sc_hd__decap_12
XFILLER_214_1241 VPWR VGND VPWR VGND sky130_ef_sc_hd__decap_12
XFILLER_114_15 VPWR VGND VPWR VGND sky130_ef_sc_hd__decap_12
XFILLER_64_1594 VGND VGND VPWR VPWR sky130_fd_sc_hd__decap_8
XFILLER_25_1534 VPWR VGND VPWR VGND sky130_ef_sc_hd__decap_12
XFILLER_60_1414 VPWR VGND VPWR VGND sky130_ef_sc_hd__decap_12
XFILLER_214_1285 VPWR VGND VPWR VGND sky130_ef_sc_hd__decap_12
XFILLER_210_1105 VPWR VGND VPWR VGND sky130_ef_sc_hd__decap_12
XFILLER_112_1526 VPWR VGND VPWR VGND sky130_ef_sc_hd__decap_12
XFILLER_99_1602 VGND VGND VPWR VPWR sky130_fd_sc_hd__decap_3
XFILLER_74_109 VPWR VGND VPWR VGND sky130_ef_sc_hd__decap_12
XFILLER_25_1578 VPWR VGND VPWR VGND sky130_ef_sc_hd__decap_12
XFILLER_210_1149 VPWR VGND VPWR VGND sky130_ef_sc_hd__decap_12
XFILLER_215_137 VPWR VGND VPWR VGND sky130_ef_sc_hd__decap_12
XFILLER_212_811 VGND VGND VPWR VPWR sky130_fd_sc_hd__fill_1
XFILLER_196_501 VPWR VGND VPWR VGND sky130_ef_sc_hd__decap_12
XFILLER_184_1373 VPWR VGND VPWR VGND sky130_ef_sc_hd__decap_12
XFILLER_110_1294 VGND VGND VPWR VPWR sky130_fd_sc_hd__decap_6
XFILLER_93_1256 VPWR VGND VPWR VGND sky130_ef_sc_hd__decap_12
XFILLER_196_545 VPWR VGND VPWR VGND sky130_ef_sc_hd__decap_12
XFILLER_90_29 VPWR VGND VPWR VGND sky130_ef_sc_hd__decap_12
XFILLER_71_1510 VPWR VGND VPWR VGND sky130_ef_sc_hd__decap_12
XPHY_EDGE_ROW_48_1_Left_267 VGND VGND VPWR VPWR sky130_fd_sc_hd__decap_3
XFILLER_180_1259 VGND VGND VPWR VPWR sky130_fd_sc_hd__fill_1
XFILLER_71_1554 VPWR VGND VPWR VGND sky130_ef_sc_hd__decap_12
XFILLER_196_589 VPWR VGND VPWR VGND sky130_ef_sc_hd__decap_12
XFILLER_183_217 VGND VGND VPWR VPWR sky130_fd_sc_hd__decap_6
XFILLER_165_921 VPWR VGND VPWR VGND sky130_ef_sc_hd__decap_12
XFILLER_32_1538 VPWR VGND VPWR VGND sky130_ef_sc_hd__decap_12
XFILLER_165_965 VPWR VGND VPWR VGND sky130_ef_sc_hd__decap_12
XFILLER_99_27 VPWR VGND VPWR VGND sky130_ef_sc_hd__decap_12
XFILLER_191_261 VPWR VGND VPWR VGND sky130_ef_sc_hd__decap_12
XFILLER_164_475 VGND VGND VPWR VPWR sky130_fd_sc_hd__fill_1
XFILLER_151_125 VGND VGND VPWR VPWR sky130_fd_sc_hd__fill_2
XFILLER_180_979 VGND VGND VPWR VPWR sky130_fd_sc_hd__fill_1
XPHY_EDGE_ROW_162_1_Left_381 VGND VGND VPWR VPWR sky130_fd_sc_hd__decap_3
XFILLER_155_55 VGND VGND VPWR VPWR sky130_fd_sc_hd__fill_1
XFILLER_3_658 VPWR VGND VPWR VGND sky130_ef_sc_hd__decap_12
XTAP_TAPCELL_ROW_38_2_3227 VGND VPWR sky130_fd_sc_hd__tapvpwrvgnd_1
XFILLER_191_1399 VGND VGND VPWR VPWR sky130_fd_sc_hd__fill_1
XTAP_TAPCELL_ROW_7_986 VGND VPWR sky130_fd_sc_hd__tapvpwrvgnd_1
XFILLER_219_421 VPWR VGND VPWR VGND sky130_ef_sc_hd__decap_12
XFILLER_4_1105 VPWR VGND VPWR VGND sky130_ef_sc_hd__decap_12
XTAP_TAPCELL_ROW_7_997 VGND VPWR sky130_fd_sc_hd__tapvpwrvgnd_1
XFILLER_48_53 VPWR VGND VPWR VGND sky130_ef_sc_hd__decap_12
XFILLER_4_1149 VPWR VGND VPWR VGND sky130_ef_sc_hd__decap_12
XFILLER_48_97 VPWR VGND VPWR VGND sky130_ef_sc_hd__decap_12
XFILLER_0_27 VGND VGND VPWR VPWR sky130_fd_sc_hd__fill_1
XFILLER_64_41 VPWR VGND VPWR VGND sky130_ef_sc_hd__decap_12
XFILLER_215_671 VGND VGND VPWR VPWR sky130_fd_sc_hd__fill_1
XFILLER_203_833 VGND VGND VPWR VPWR sky130_fd_sc_hd__decap_6
XFILLER_199_361 VPWR VGND VPWR VGND sky130_ef_sc_hd__decap_12
XFILLER_163_1413 VPWR VGND VPWR VGND sky130_ef_sc_hd__decap_12
XFILLER_64_85 VPWR VGND VPWR VGND sky130_ef_sc_hd__decap_12
XFILLER_202_321 VPWR VGND VPWR VGND sky130_ef_sc_hd__decap_12
XFILLER_167_1593 VPWR VGND VPWR VGND sky130_ef_sc_hd__decap_12
XFILLER_163_1457 VPWR VGND VPWR VGND sky130_ef_sc_hd__decap_12
XFILLER_204_1421 VGND VGND VPWR VPWR sky130_fd_sc_hd__decap_6
XFILLER_203_877 VPWR VGND VPWR VGND sky130_ef_sc_hd__decap_12
XFILLER_202_365 VPWR VGND VPWR VGND sky130_ef_sc_hd__decap_12
XFILLER_9_69 VGND VGND VPWR VPWR sky130_fd_sc_hd__decap_4
X_326_ b_addr\[1\] net4 net140 VGND VGND VPWR VPWR s_addr\[1\] sky130_fd_sc_hd__mux2_1
XFILLER_204_1465 VPWR VGND VPWR VGND sky130_ef_sc_hd__decap_12
XFILLER_198_1509 VPWR VGND VPWR VGND sky130_ef_sc_hd__decap_12
XFILLER_175_729 VPWR VGND VPWR VGND sky130_ef_sc_hd__decap_12
XFILLER_168_781 VPWR VGND VPWR VGND sky130_ef_sc_hd__decap_12
XFILLER_200_1329 VPWR VGND VPWR VGND sky130_ef_sc_hd__decap_12
XFILLER_127_111 VGND VGND VPWR VPWR sky130_fd_sc_hd__fill_1
XFILLER_7_953 VPWR VGND VPWR VGND sky130_ef_sc_hd__decap_12
XFILLER_170_401 VPWR VGND VPWR VGND sky130_ef_sc_hd__decap_12
XFILLER_170_445 VPWR VGND VPWR VGND sky130_ef_sc_hd__decap_12
XTAP_TAPCELL_ROW_135_2_3855 VGND VPWR sky130_fd_sc_hd__tapvpwrvgnd_1
XFILLER_89_93 VPWR VGND VPWR VGND sky130_ef_sc_hd__decap_12
XFILLER_174_1553 VPWR VGND VPWR VGND sky130_ef_sc_hd__decap_12
XFILLER_170_489 VPWR VGND VPWR VGND sky130_ef_sc_hd__decap_12
XFILLER_174_1597 VGND VGND VPWR VPWR sky130_fd_sc_hd__decap_8
XFILLER_215_1561 VGND VGND VPWR VPWR sky130_fd_sc_hd__decap_6
XFILLER_215_69 VPWR VGND VPWR VGND sky130_ef_sc_hd__decap_12
XFILLER_211_1425 VPWR VGND VPWR VGND sky130_ef_sc_hd__decap_12
XFILLER_29_3 VPWR VGND VPWR VGND sky130_ef_sc_hd__decap_12
XFILLER_133_1272 VGND VGND VPWR VPWR sky130_fd_sc_hd__fill_1
XTAP_TAPCELL_ROW_83_2_3520 VGND VPWR sky130_fd_sc_hd__tapvpwrvgnd_1
XFILLER_211_1469 VPWR VGND VPWR VGND sky130_ef_sc_hd__decap_12
XFILLER_0_1525 VPWR VGND VPWR VGND sky130_ef_sc_hd__decap_12
XFILLER_209_1343 VGND VGND VPWR VPWR sky130_fd_sc_hd__fill_1
XFILLER_181_1513 VPWR VGND VPWR VGND sky130_ef_sc_hd__decap_12
XFILLER_178_501 VPWR VGND VPWR VGND sky130_ef_sc_hd__decap_12
XFILLER_0_1569 VPWR VGND VPWR VGND sky130_ef_sc_hd__decap_12
XFILLER_206_693 VGND VGND VPWR VPWR sky130_fd_sc_hd__decap_6
XFILLER_205_181 VPWR VGND VPWR VGND sky130_ef_sc_hd__decap_12
XFILLER_178_545 VPWR VGND VPWR VGND sky130_ef_sc_hd__decap_12
XFILLER_178_589 VPWR VGND VPWR VGND sky130_ef_sc_hd__decap_12
XFILLER_165_217 VGND VGND VPWR VPWR sky130_fd_sc_hd__decap_6
XFILLER_105_1330 VPWR VGND VPWR VGND sky130_ef_sc_hd__decap_12
XFILLER_18_1382 VPWR VGND VPWR VGND sky130_ef_sc_hd__decap_12
XFILLER_193_559 VGND VGND VPWR VPWR sky130_fd_sc_hd__fill_1
XFILLER_140_1232 VPWR VGND VPWR VGND sky130_ef_sc_hd__decap_12
XFILLER_88_1314 VPWR VGND VPWR VGND sky130_ef_sc_hd__decap_12
XFILLER_14_1246 VPWR VGND VPWR VGND sky130_ef_sc_hd__decap_12
XFILLER_180_209 VPWR VGND VPWR VGND sky130_ef_sc_hd__decap_12
XFILLER_109_15 VPWR VGND VPWR VGND sky130_ef_sc_hd__decap_12
XFILLER_173_261 VPWR VGND VPWR VGND sky130_ef_sc_hd__decap_12
XFILLER_133_125 VGND VGND VPWR VPWR sky130_fd_sc_hd__fill_2
XFILLER_88_1358 VPWR VGND VPWR VGND sky130_ef_sc_hd__decap_12
XTAP_TAPCELL_ROW_24_2_3135 VGND VPWR sky130_fd_sc_hd__tapvpwrvgnd_1
XFILLER_0_606 VGND VGND VPWR VPWR sky130_fd_sc_hd__fill_1
XFILLER_173_1063 VGND VGND VPWR VPWR sky130_fd_sc_hd__fill_1
XTAP_TAPCELL_ROW_4_901 VGND VPWR sky130_fd_sc_hd__tapvpwrvgnd_1
XFILLER_125_69 VPWR VGND VPWR VGND sky130_ef_sc_hd__decap_12
XFILLER_116_1470 VPWR VGND VPWR VGND sky130_ef_sc_hd__decap_12
XFILLER_99_1410 VPWR VGND VPWR VGND sky130_ef_sc_hd__decap_12
XTAP_TAPCELL_ROW_4_912 VGND VPWR sky130_fd_sc_hd__tapvpwrvgnd_1
XFILLER_5_1425 VPWR VGND VPWR VGND sky130_ef_sc_hd__decap_12
XFILLER_25_1342 VPWR VGND VPWR VGND sky130_ef_sc_hd__decap_12
XFILLER_214_1093 VPWR VGND VPWR VGND sky130_ef_sc_hd__decap_12
XTAP_TAPCELL_ROW_184_1974 VGND VPWR sky130_fd_sc_hd__tapvpwrvgnd_1
XFILLER_25_1386 VPWR VGND VPWR VGND sky130_ef_sc_hd__decap_12
XFILLER_60_1244 VGND VGND VPWR VPWR sky130_fd_sc_hd__fill_1
XFILLER_216_413 VGND VGND VPWR VPWR sky130_fd_sc_hd__decap_6
XTAP_TAPCELL_ROW_184_1996 VGND VPWR sky130_fd_sc_hd__tapvpwrvgnd_1
XTAP_TAPCELL_ROW_184_1985 VGND VPWR sky130_fd_sc_hd__tapvpwrvgnd_1
XFILLER_112_1356 VGND VGND VPWR VPWR sky130_fd_sc_hd__fill_1
XFILLER_99_1454 VPWR VGND VPWR VGND sky130_ef_sc_hd__decap_12
XFILLER_5_1469 VPWR VGND VPWR VGND sky130_ef_sc_hd__decap_12
XFILLER_216_457 VPWR VGND VPWR VGND sky130_ef_sc_hd__decap_12
XFILLER_141_57 VPWR VGND VPWR VGND sky130_ef_sc_hd__decap_12
XFILLER_99_1498 VPWR VGND VPWR VGND sky130_ef_sc_hd__decap_12
XFILLER_188_309 VPWR VGND VPWR VGND sky130_ef_sc_hd__decap_12
XFILLER_197_821 VPWR VGND VPWR VGND sky130_ef_sc_hd__decap_12
XTAP_TAPCELL_ROW_130_1_1277 VGND VPWR sky130_fd_sc_hd__tapvpwrvgnd_1
XFILLER_200_825 VPWR VGND VPWR VGND sky130_ef_sc_hd__decap_12
XFILLER_197_865 VPWR VGND VPWR VGND sky130_ef_sc_hd__decap_12
XFILLER_133_3 VPWR VGND VPWR VGND sky130_ef_sc_hd__decap_12
XFILLER_32_1302 VPWR VGND VPWR VGND sky130_ef_sc_hd__decap_12
XFILLER_36_1482 VPWR VGND VPWR VGND sky130_ef_sc_hd__decap_12
XFILLER_200_869 VPWR VGND VPWR VGND sky130_ef_sc_hd__decap_12
XFILLER_109_111 VGND VGND VPWR VPWR sky130_fd_sc_hd__fill_1
XFILLER_71_1384 VGND VGND VPWR VPWR sky130_fd_sc_hd__fill_1
XFILLER_123_1496 VGND VGND VPWR VPWR sky130_fd_sc_hd__fill_1
XFILLER_7_249 VGND VGND VPWR VPWR sky130_fd_sc_hd__fill_1
XFILLER_50_65 VPWR VGND VPWR VGND sky130_ef_sc_hd__decap_12
XFILLER_192_581 VGND VGND VPWR VPWR sky130_fd_sc_hd__decap_6
XFILLER_166_65 VPWR VGND VPWR VGND sky130_ef_sc_hd__decap_12
XFILLER_158_1526 VPWR VGND VPWR VGND sky130_ef_sc_hd__decap_12
XTAP_TAPCELL_ROW_121_2_3763 VGND VPWR sky130_fd_sc_hd__tapvpwrvgnd_1
XTAP_TAPCELL_ROW_9_1_1035 VGND VPWR sky130_fd_sc_hd__tapvpwrvgnd_1
XFILLER_182_53 VPWR VGND VPWR VGND sky130_ef_sc_hd__decap_12
XFILLER_156_1294 VGND VGND VPWR VPWR sky130_fd_sc_hd__decap_6
XFILLER_117_1256 VPWR VGND VPWR VGND sky130_ef_sc_hd__decap_12
XFILLER_3_499 VGND VGND VPWR VPWR sky130_fd_sc_hd__fill_1
XANTENNA__310__A2 net144 VGND VGND VPWR VPWR sky130_fd_sc_hd__diode_2
XFILLER_182_97 VPWR VGND VPWR VGND sky130_ef_sc_hd__decap_12
XFILLER_38_109 VPWR VGND VPWR VGND sky130_ef_sc_hd__decap_12
XFILLER_43_1442 VPWR VGND VPWR VGND sky130_ef_sc_hd__decap_12
XFILLER_208_925 VPWR VGND VPWR VGND sky130_ef_sc_hd__decap_12
XFILLER_130_1412 VGND VGND VPWR VPWR sky130_fd_sc_hd__fill_1
XTAP_TAPCELL_ROW_68_2_3422 VGND VPWR sky130_fd_sc_hd__tapvpwrvgnd_1
XFILLER_75_51 VGND VGND VPWR VPWR sky130_fd_sc_hd__decap_4
XFILLER_78_1538 VPWR VGND VPWR VGND sky130_ef_sc_hd__decap_12
XFILLER_201_27 VPWR VGND VPWR VGND sky130_ef_sc_hd__decap_12
XFILLER_203_641 VPWR VGND VPWR VGND sky130_ef_sc_hd__decap_12
XTAP_TAPCELL_ROW_202_2491 VGND VPWR sky130_fd_sc_hd__tapvpwrvgnd_1
XTAP_TAPCELL_ROW_67_1_1152 VGND VPWR sky130_fd_sc_hd__tapvpwrvgnd_1
XFILLER_37_1268 VGND VGND VPWR VPWR sky130_fd_sc_hd__decap_4
XFILLER_203_685 VPWR VGND VPWR VGND sky130_ef_sc_hd__decap_12
XTAP_TAPCELL_ROW_194_2281 VGND VPWR sky130_fd_sc_hd__tapvpwrvgnd_1
XTAP_TAPCELL_ROW_194_2270 VGND VPWR sky130_fd_sc_hd__tapvpwrvgnd_1
XFILLER_15_1522 VPWR VGND VPWR VGND sky130_ef_sc_hd__decap_12
XFILLER_204_1273 VPWR VGND VPWR VGND sky130_ef_sc_hd__decap_12
XFILLER_202_195 VGND VGND VPWR VPWR sky130_fd_sc_hd__fill_1
XFILLER_198_1317 VPWR VGND VPWR VGND sky130_ef_sc_hd__decap_12
XTAP_TAPCELL_ROW_190_2156 VGND VPWR sky130_fd_sc_hd__tapvpwrvgnd_1
XTAP_TAPCELL_ROW_190_2145 VGND VPWR sky130_fd_sc_hd__tapvpwrvgnd_1
XFILLER_175_559 VGND VGND VPWR VPWR sky130_fd_sc_hd__fill_1
XFILLER_141_1552 VGND VGND VPWR VPWR sky130_fd_sc_hd__fill_1
X_309_ net19 net142 net132 VGND VGND VPWR VPWR s_wdata\[16\] sky130_fd_sc_hd__a21o_1
XFILLER_15_1566 VPWR VGND VPWR VGND sky130_ef_sc_hd__decap_12
XFILLER_54_1582 VPWR VGND VPWR VGND sky130_ef_sc_hd__decap_12
XTAP_TAPCELL_ROW_215_2863 VGND VPWR sky130_fd_sc_hd__tapvpwrvgnd_1
XTAP_TAPCELL_ROW_190_2167 VGND VPWR sky130_fd_sc_hd__tapvpwrvgnd_1
XFILLER_50_1468 VGND VGND VPWR VPWR sky130_fd_sc_hd__fill_1
XTAP_TAPCELL_ROW_215_2874 VGND VPWR sky130_fd_sc_hd__tapvpwrvgnd_1
XFILLER_171_721 VGND VGND VPWR VPWR sky130_fd_sc_hd__decap_6
XTAP_TAPCELL_ROW_155_1_1328 VGND VPWR sky130_fd_sc_hd__tapvpwrvgnd_1
XTAP_TAPCELL_ROW_10_2_3043 VGND VPWR sky130_fd_sc_hd__tapvpwrvgnd_1
XTAP_TAPCELL_ROW_211_2749 VGND VPWR sky130_fd_sc_hd__tapvpwrvgnd_1
XFILLER_196_1085 VGND VGND VPWR VPWR sky130_fd_sc_hd__decap_6
XFILLER_171_765 VPWR VGND VPWR VGND sky130_ef_sc_hd__decap_12
XFILLER_115_125 VGND VGND VPWR VPWR sky130_fd_sc_hd__fill_2
XFILLER_170_253 VPWR VGND VPWR VGND sky130_ef_sc_hd__decap_12
XFILLER_100_1282 VPWR VGND VPWR VGND sky130_ef_sc_hd__decap_12
XFILLER_83_1244 VPWR VGND VPWR VGND sky130_ef_sc_hd__decap_12
XTAP_TAPCELL_ROW_188_2096 VGND VPWR sky130_fd_sc_hd__tapvpwrvgnd_1
XTAP_TAPCELL_ROW_188_2085 VGND VPWR sky130_fd_sc_hd__tapvpwrvgnd_1
XFILLER_170_1203 VGND VGND VPWR VPWR sky130_fd_sc_hd__fill_1
XFILLER_135_1378 VGND VGND VPWR VPWR sky130_fd_sc_hd__decap_6
XPHY_EDGE_ROW_15_2_Left_447 VGND VGND VPWR VPWR sky130_fd_sc_hd__decap_3
XFILLER_211_1233 VPWR VGND VPWR VGND sky130_ef_sc_hd__decap_12
XTAP_TAPCELL_ROW_209_2689 VGND VPWR sky130_fd_sc_hd__tapvpwrvgnd_1
XFILLER_22_1526 VPWR VGND VPWR VGND sky130_ef_sc_hd__decap_12
XTAP_TAPCELL_ROW_160_2_4021 VGND VPWR sky130_fd_sc_hd__tapvpwrvgnd_1
XFILLER_214_917 VGND VGND VPWR VPWR sky130_fd_sc_hd__decap_6
XFILLER_1_81 VPWR VGND VPWR VGND sky130_ef_sc_hd__decap_12
XFILLER_213_405 VPWR VGND VPWR VGND sky130_ef_sc_hd__decap_12
XFILLER_111_27 VPWR VGND VPWR VGND sky130_ef_sc_hd__decap_12
XFILLER_213_449 VPWR VGND VPWR VGND sky130_ef_sc_hd__decap_12
XFILLER_179_821 VPWR VGND VPWR VGND sky130_ef_sc_hd__decap_12
XFILLER_164_1029 VGND VGND VPWR VPWR sky130_fd_sc_hd__decap_6
XFILLER_20_1294 VGND VGND VPWR VPWR sky130_fd_sc_hd__decap_6
XFILLER_181_1343 VGND VGND VPWR VPWR sky130_fd_sc_hd__fill_1
XFILLER_179_865 VPWR VGND VPWR VGND sky130_ef_sc_hd__decap_12
XFILLER_194_813 VPWR VGND VPWR VGND sky130_ef_sc_hd__decap_12
XFILLER_142_1338 VPWR VGND VPWR VGND sky130_ef_sc_hd__decap_12
XTAP_TAPCELL_ROW_94_2_3589 VGND VPWR sky130_fd_sc_hd__tapvpwrvgnd_1
XTAP_TAPCELL_ROW_106_2_3665 VGND VPWR sky130_fd_sc_hd__tapvpwrvgnd_1
XFILLER_181_529 VPWR VGND VPWR VGND sky130_ef_sc_hd__decap_12
XFILLER_174_581 VGND VGND VPWR VPWR sky130_fd_sc_hd__decap_6
XTAP_TAPCELL_ROW_173_1675 VGND VPWR sky130_fd_sc_hd__tapvpwrvgnd_1
XTAP_TAPCELL_ROW_173_1664 VGND VPWR sky130_fd_sc_hd__tapvpwrvgnd_1
XFILLER_218_1409 VPWR VGND VPWR VGND sky130_ef_sc_hd__decap_12
XPHY_EDGE_ROW_199_Right_44 VGND VGND VPWR VPWR sky130_fd_sc_hd__decap_3
XFILLER_20_68 VGND VGND VPWR VPWR sky130_fd_sc_hd__decap_8
XFILLER_175_1169 VGND VGND VPWR VPWR sky130_fd_sc_hd__decap_6
XTAP_TAPCELL_ROW_11_1_1039 VGND VPWR sky130_fd_sc_hd__tapvpwrvgnd_1
XFILLER_192_1483 VGND VGND VPWR VPWR sky130_fd_sc_hd__fill_1
XFILLER_153_1434 VGND VGND VPWR VPWR sky130_fd_sc_hd__decap_6
XFILLER_1_937 VGND VGND VPWR VPWR sky130_fd_sc_hd__fill_2
XFILLER_7_1509 VGND VGND VPWR VPWR sky130_fd_sc_hd__decap_3
XFILLER_153_1478 VPWR VGND VPWR VGND sky130_ef_sc_hd__decap_12
XTAP_TAPCELL_ROW_54_2_3330 VGND VPWR sky130_fd_sc_hd__tapvpwrvgnd_1
XFILLER_5_1233 VPWR VGND VPWR VGND sky130_ef_sc_hd__decap_12
XFILLER_216_221 VPWR VGND VPWR VGND sky130_ef_sc_hd__decap_12
XFILLER_1_1119 VGND VGND VPWR VPWR sky130_fd_sc_hd__fill_1
X_591_ clknet_3_0_0_clk _025_ VGND VGND VPWR VPWR b_addr\[7\] sky130_fd_sc_hd__dfxtp_1
XFILLER_217_777 VGND VGND VPWR VPWR sky130_fd_sc_hd__decap_6
XFILLER_216_265 VPWR VGND VPWR VGND sky130_ef_sc_hd__decap_12
XFILLER_189_629 VPWR VGND VPWR VGND sky130_ef_sc_hd__decap_12
XFILLER_182_1129 VPWR VGND VPWR VGND sky130_ef_sc_hd__decap_12
XPHY_EDGE_ROW_61_2_Left_493 VGND VGND VPWR VPWR sky130_fd_sc_hd__decap_3
XFILLER_188_139 VGND VGND VPWR VPWR sky130_fd_sc_hd__fill_1
XFILLER_164_1541 VPWR VGND VPWR VGND sky130_ef_sc_hd__decap_12
XFILLER_197_673 VPWR VGND VPWR VGND sky130_ef_sc_hd__decap_12
XFILLER_184_301 VGND VGND VPWR VPWR sky130_fd_sc_hd__decap_6
XFILLER_160_1438 VPWR VGND VPWR VGND sky130_ef_sc_hd__decap_12
XFILLER_101_93 VPWR VGND VPWR VGND sky130_ef_sc_hd__decap_12
XFILLER_201_1413 VPWR VGND VPWR VGND sky130_ef_sc_hd__decap_12
XFILLER_205_1593 VPWR VGND VPWR VGND sky130_ef_sc_hd__decap_12
XFILLER_200_699 VGND VGND VPWR VPWR sky130_fd_sc_hd__fill_1
XFILLER_184_345 VPWR VGND VPWR VGND sky130_ef_sc_hd__decap_12
XFILLER_6_15 VPWR VGND VPWR VGND sky130_ef_sc_hd__decap_12
XFILLER_201_1457 VPWR VGND VPWR VGND sky130_ef_sc_hd__decap_12
XFILLER_184_389 VPWR VGND VPWR VGND sky130_ef_sc_hd__decap_12
XFILLER_193_1225 VGND VGND VPWR VPWR sky130_fd_sc_hd__decap_6
XFILLER_158_1356 VGND VGND VPWR VPWR sky130_fd_sc_hd__fill_1
XFILLER_4_753 VGND VGND VPWR VPWR sky130_fd_sc_hd__decap_3
XFILLER_193_1269 VPWR VGND VPWR VGND sky130_ef_sc_hd__decap_12
XFILLER_80_1406 VGND VGND VPWR VPWR sky130_fd_sc_hd__decap_6
XFILLER_171_1567 VGND VGND VPWR VPWR sky130_fd_sc_hd__fill_1
XFILLER_132_1518 VGND VGND VPWR VPWR sky130_fd_sc_hd__decap_6
XPHY_EDGE_ROW_203_Right_48 VGND VGND VPWR VPWR sky130_fd_sc_hd__decap_3
XPHY_EDGE_ROW_125_1_Left_344 VGND VGND VPWR VPWR sky130_fd_sc_hd__decap_3
XFILLER_86_83 VGND VGND VPWR VPWR sky130_fd_sc_hd__fill_1
XFILLER_0_981 VPWR VGND VPWR VGND sky130_ef_sc_hd__decap_12
XTAP_TAPCELL_ROW_7_1003 VGND VPWR sky130_fd_sc_hd__tapvpwrvgnd_1
XTAP_TAPCELL_ROW_7_1014 VGND VPWR sky130_fd_sc_hd__tapvpwrvgnd_1
XTAP_TAPCELL_ROW_7_1025 VGND VPWR sky130_fd_sc_hd__tapvpwrvgnd_1
XFILLER_212_1553 VPWR VGND VPWR VGND sky130_ef_sc_hd__decap_12
XFILLER_187_1007 VGND VGND VPWR VPWR sky130_fd_sc_hd__fill_1
XFILLER_130_1220 VPWR VGND VPWR VGND sky130_ef_sc_hd__decap_12
XANTENNA__588__CLK clknet_3_2_0_clk VGND VGND VPWR VPWR sky130_fd_sc_hd__diode_2
XFILLER_212_1597 VGND VGND VPWR VPWR sky130_fd_sc_hd__decap_8
XFILLER_212_15 VPWR VGND VPWR VGND sky130_ef_sc_hd__decap_12
XFILLER_208_755 VGND VGND VPWR VPWR sky130_fd_sc_hd__fill_1
XTAP_TAPCELL_ROW_204_2542 VGND VPWR sky130_fd_sc_hd__tapvpwrvgnd_1
XFILLER_78_1302 VPWR VGND VPWR VGND sky130_ef_sc_hd__decap_12
XTAP_TAPCELL_ROW_204_2564 VGND VPWR sky130_fd_sc_hd__tapvpwrvgnd_1
XTAP_TAPCELL_ROW_204_2553 VGND VPWR sky130_fd_sc_hd__tapvpwrvgnd_1
XTAP_TAPCELL_ROW_143_2_3906 VGND VPWR sky130_fd_sc_hd__tapvpwrvgnd_1
XFILLER_34_101 VGND VGND VPWR VPWR sky130_fd_sc_hd__fill_1
XFILLER_211_909 VPWR VGND VPWR VGND sky130_ef_sc_hd__decap_12
XTAP_TAPCELL_ROW_200_2439 VGND VPWR sky130_fd_sc_hd__tapvpwrvgnd_1
XTAP_TAPCELL_ROW_200_2428 VGND VPWR sky130_fd_sc_hd__tapvpwrvgnd_1
XTAP_TAPCELL_ROW_196_2332 VGND VPWR sky130_fd_sc_hd__tapvpwrvgnd_1
XTAP_TAPCELL_ROW_196_2321 VGND VPWR sky130_fd_sc_hd__tapvpwrvgnd_1
XFILLER_210_419 VGND VGND VPWR VPWR sky130_fd_sc_hd__fill_1
XFILLER_204_961 VPWR VGND VPWR VGND sky130_ef_sc_hd__decap_12
XTAP_TAPCELL_ROW_192_2207 VGND VPWR sky130_fd_sc_hd__tapvpwrvgnd_1
XTAP_TAPCELL_ROW_98_1_1213 VGND VPWR sky130_fd_sc_hd__tapvpwrvgnd_1
XFILLER_96_3 VPWR VGND VPWR VGND sky130_ef_sc_hd__decap_12
XFILLER_91_1546 VGND VGND VPWR VPWR sky130_fd_sc_hd__decap_6
XTAP_TAPCELL_ROW_217_2914 VGND VPWR sky130_fd_sc_hd__tapvpwrvgnd_1
XPHY_EDGE_ROW_212_Right_57 VGND VGND VPWR VPWR sky130_fd_sc_hd__decap_3
XFILLER_194_109 VPWR VGND VPWR VGND sky130_ef_sc_hd__decap_12
XTAP_TAPCELL_ROW_192_2218 VGND VPWR sky130_fd_sc_hd__tapvpwrvgnd_1
XFILLER_187_161 VGND VGND VPWR VPWR sky130_fd_sc_hd__decap_6
XFILLER_176_813 VPWR VGND VPWR VGND sky130_ef_sc_hd__decap_12
XTAP_TAPCELL_ROW_80_2_3497 VGND VPWR sky130_fd_sc_hd__tapvpwrvgnd_1
XTAP_TAPCELL_ROW_217_2936 VGND VPWR sky130_fd_sc_hd__tapvpwrvgnd_1
XTAP_TAPCELL_ROW_217_2925 VGND VPWR sky130_fd_sc_hd__tapvpwrvgnd_1
XFILLER_15_1330 VPWR VGND VPWR VGND sky130_ef_sc_hd__decap_12
XFILLER_198_1147 VGND VGND VPWR VPWR sky130_fd_sc_hd__fill_1
XFILLER_102_1300 VGND VGND VPWR VPWR sky130_fd_sc_hd__fill_1
XFILLER_50_1232 VPWR VGND VPWR VGND sky130_ef_sc_hd__decap_12
XFILLER_163_529 VGND VGND VPWR VPWR sky130_fd_sc_hd__decap_3
XFILLER_89_1442 VPWR VGND VPWR VGND sky130_ef_sc_hd__decap_12
XFILLER_85_1328 VGND VGND VPWR VPWR sky130_fd_sc_hd__fill_1
XFILLER_172_1309 VGND VGND VPWR VPWR sky130_fd_sc_hd__decap_6
XFILLER_171_573 VPWR VGND VPWR VGND sky130_ef_sc_hd__decap_12
XFILLER_106_27 VGND VGND VPWR VPWR sky130_fd_sc_hd__fill_1
XTAP_TAPCELL_ROW_39_2_3232 VGND VPWR sky130_fd_sc_hd__tapvpwrvgnd_1
XPHY_EDGE_ROW_57_1_Left_276 VGND VGND VPWR VPWR sky130_fd_sc_hd__decap_3
XFILLER_26_1470 VPWR VGND VPWR VGND sky130_ef_sc_hd__decap_12
XTAP_TAPCELL_ROW_181_1911 VGND VPWR sky130_fd_sc_hd__tapvpwrvgnd_1
XTAP_TAPCELL_ROW_181_1900 VGND VPWR sky130_fd_sc_hd__tapvpwrvgnd_1
XFILLER_113_1440 VGND VGND VPWR VPWR sky130_fd_sc_hd__fill_1
XFILLER_6_1553 VPWR VGND VPWR VGND sky130_ef_sc_hd__decap_12
XFILLER_211_1063 VGND VGND VPWR VPWR sky130_fd_sc_hd__fill_1
XFILLER_122_15 VPWR VGND VPWR VGND sky130_ef_sc_hd__decap_12
XFILLER_6_1597 VGND VGND VPWR VPWR sky130_fd_sc_hd__decap_8
XFILLER_22_1356 VGND VGND VPWR VPWR sky130_fd_sc_hd__fill_1
XFILLER_214_725 VPWR VGND VPWR VGND sky130_ef_sc_hd__decap_12
XFILLER_183_1449 VGND VGND VPWR VPWR sky130_fd_sc_hd__decap_6
XFILLER_96_1468 VGND VGND VPWR VPWR sky130_fd_sc_hd__fill_1
XFILLER_214_769 VPWR VGND VPWR VGND sky130_ef_sc_hd__decap_12
XTAP_TAPCELL_ROW_179_1840 VGND VPWR sky130_fd_sc_hd__tapvpwrvgnd_1
XFILLER_15_57 VGND VGND VPWR VPWR sky130_fd_sc_hd__decap_8
XFILLER_213_279 VGND VGND VPWR VPWR sky130_fd_sc_hd__fill_1
XTAP_TAPCELL_ROW_179_1851 VGND VPWR sky130_fd_sc_hd__tapvpwrvgnd_1
XFILLER_179_673 VPWR VGND VPWR VGND sky130_ef_sc_hd__decap_12
XFILLER_166_301 VGND VGND VPWR VPWR sky130_fd_sc_hd__decap_6
XFILLER_146_1282 VPWR VGND VPWR VGND sky130_ef_sc_hd__decap_12
XFILLER_194_643 VGND VGND VPWR VPWR sky130_fd_sc_hd__fill_1
XTAP_TAPCELL_ROW_175_1737 VGND VPWR sky130_fd_sc_hd__tapvpwrvgnd_1
XTAP_TAPCELL_ROW_175_1726 VGND VPWR sky130_fd_sc_hd__tapvpwrvgnd_1
XTAP_TAPCELL_ROW_175_1715 VGND VPWR sky130_fd_sc_hd__tapvpwrvgnd_1
XFILLER_107_1244 VPWR VGND VPWR VGND sky130_ef_sc_hd__decap_12
XFILLER_182_805 VGND VGND VPWR VPWR sky130_fd_sc_hd__decap_6
XFILLER_166_345 VPWR VGND VPWR VGND sky130_ef_sc_hd__decap_12
XTAP_TAPCELL_ROW_156_2_3995 VGND VPWR sky130_fd_sc_hd__tapvpwrvgnd_1
XFILLER_124_1580 VGND VGND VPWR VPWR sky130_fd_sc_hd__fill_1
XFILLER_182_849 VPWR VGND VPWR VGND sky130_ef_sc_hd__decap_12
XFILLER_166_389 VPWR VGND VPWR VGND sky130_ef_sc_hd__decap_12
XFILLER_33_1496 VGND VGND VPWR VPWR sky130_fd_sc_hd__fill_1
XFILLER_181_337 VPWR VGND VPWR VGND sky130_ef_sc_hd__decap_12
XFILLER_68_1526 VPWR VGND VPWR VGND sky130_ef_sc_hd__decap_12
XFILLER_31_89 VPWR VGND VPWR VGND sky130_ef_sc_hd__decap_12
XFILLER_218_1217 VPWR VGND VPWR VGND sky130_ef_sc_hd__decap_12
XFILLER_190_1409 VPWR VGND VPWR VGND sky130_ef_sc_hd__decap_12
XFILLER_190_893 VPWR VGND VPWR VGND sky130_ef_sc_hd__decap_12
XTAP_TAPCELL_ROW_136_2_3860 VGND VPWR sky130_fd_sc_hd__tapvpwrvgnd_1
XFILLER_194_1589 VGND VGND VPWR VPWR sky130_fd_sc_hd__decap_6
Xoutput67 net67 VGND VGND VPWR VPWR bist_fail_bits[19] sky130_fd_sc_hd__buf_2
Xoutput56 net56 VGND VGND VPWR VPWR bist_fail_addr[7] sky130_fd_sc_hd__buf_2
XFILLER_66_1294 VGND VGND VPWR VPWR sky130_fd_sc_hd__decap_6
Xoutput78 net78 VGND VGND VPWR VPWR bist_fail_bits[29] sky130_fd_sc_hd__buf_2
XFILLER_1_767 VPWR VGND VPWR VGND sky130_ef_sc_hd__decap_12
Xoutput89 net89 VGND VGND VPWR VPWR func_rdata[0] sky130_fd_sc_hd__buf_2
XFILLER_7_1317 VPWR VGND VPWR VGND sky130_ef_sc_hd__decap_12
XFILLER_27_1256 VPWR VGND VPWR VGND sky130_ef_sc_hd__decap_12
XFILLER_153_1286 VPWR VGND VPWR VGND sky130_ef_sc_hd__decap_12
XFILLER_0_277 VGND VGND VPWR VPWR sky130_fd_sc_hd__decap_3
XFILLER_40_1412 VGND VGND VPWR VPWR sky130_fd_sc_hd__fill_1
XFILLER_217_541 VPWR VGND VPWR VGND sky130_ef_sc_hd__decap_12
XTAP_TAPCELL_ROW_128_2_3808 VGND VPWR sky130_fd_sc_hd__tapvpwrvgnd_1
XANTENNA_input16_A func_wdata[13] VGND VGND VPWR VPWR sky130_fd_sc_hd__diode_2
XFILLER_5_1063 VGND VGND VPWR VPWR sky130_fd_sc_hd__fill_1
XFILLER_56_53 VPWR VGND VPWR VGND sky130_ef_sc_hd__decap_12
XFILLER_217_585 VPWR VGND VPWR VGND sky130_ef_sc_hd__decap_12
XFILLER_186_1073 VPWR VGND VPWR VGND sky130_ef_sc_hd__decap_12
X_574_ clknet_3_3_0_clk _012_ VGND VGND VPWR VPWR u_ctrl.cmp_addr\[6\] sky130_fd_sc_hd__dfxtp_1
XFILLER_72_41 VPWR VGND VPWR VGND sky130_ef_sc_hd__decap_12
XFILLER_198_993 VPWR VGND VPWR VGND sky130_ef_sc_hd__decap_12
XFILLER_188_41 VPWR VGND VPWR VGND sky130_ef_sc_hd__decap_12
XFILLER_176_109 VPWR VGND VPWR VGND sky130_ef_sc_hd__decap_12
XFILLER_164_1371 VGND VGND VPWR VPWR sky130_fd_sc_hd__fill_1
XFILLER_125_1322 VGND VGND VPWR VPWR sky130_fd_sc_hd__decap_6
XFILLER_73_1232 VPWR VGND VPWR VGND sky130_ef_sc_hd__decap_12
XFILLER_72_85 VPWR VGND VPWR VGND sky130_ef_sc_hd__decap_12
XTAP_TAPCELL_ROW_65_2_3399 VGND VPWR sky130_fd_sc_hd__tapvpwrvgnd_1
XFILLER_201_953 VPWR VGND VPWR VGND sky130_ef_sc_hd__decap_12
XFILLER_199_1401 VPWR VGND VPWR VGND sky130_ef_sc_hd__decap_12
XFILLER_188_85 VPWR VGND VPWR VGND sky130_ef_sc_hd__decap_12
XFILLER_169_161 VGND VGND VPWR VPWR sky130_fd_sc_hd__decap_6
XFILLER_160_1246 VPWR VGND VPWR VGND sky130_ef_sc_hd__decap_12
XFILLER_125_1366 VPWR VGND VPWR VGND sky130_ef_sc_hd__decap_12
XFILLER_73_1298 VPWR VGND VPWR VGND sky130_ef_sc_hd__decap_12
XFILLER_185_665 VGND VGND VPWR VPWR sky130_fd_sc_hd__decap_6
XFILLER_184_153 VPWR VGND VPWR VGND sky130_ef_sc_hd__decap_12
XFILLER_51_1552 VGND VGND VPWR VPWR sky130_fd_sc_hd__fill_1
XFILLER_201_1287 VGND VGND VPWR VPWR sky130_fd_sc_hd__fill_1
XFILLER_184_197 VPWR VGND VPWR VGND sky130_ef_sc_hd__decap_12
XFILLER_207_15 VPWR VGND VPWR VGND sky130_ef_sc_hd__decap_12
XFILLER_193_1033 VPWR VGND VPWR VGND sky130_ef_sc_hd__decap_12
XTAP_TAPCELL_ROW_25_2_3140 VGND VPWR sky130_fd_sc_hd__tapvpwrvgnd_1
XFILLER_193_1077 VPWR VGND VPWR VGND sky130_ef_sc_hd__decap_12
XTAP_TAPCELL_ROW_185_2011 VGND VPWR sky130_fd_sc_hd__tapvpwrvgnd_1
XTAP_TAPCELL_ROW_185_2000 VGND VPWR sky130_fd_sc_hd__tapvpwrvgnd_1
XFILLER_84_1350 VGND VGND VPWR VPWR sky130_fd_sc_hd__decap_6
XANTENNA__440__A net147 VGND VGND VPWR VPWR sky130_fd_sc_hd__diode_2
XFILLER_10_1282 VPWR VGND VPWR VGND sky130_ef_sc_hd__decap_12
XTAP_TAPCELL_ROW_185_2022 VGND VPWR sky130_fd_sc_hd__tapvpwrvgnd_1
XFILLER_136_1462 VGND VGND VPWR VPWR sky130_fd_sc_hd__decap_6
XFILLER_84_1394 VPWR VGND VPWR VGND sky130_ef_sc_hd__decap_12
XFILLER_132_1326 VPWR VGND VPWR VGND sky130_ef_sc_hd__decap_12
XFILLER_100_109 VPWR VGND VPWR VGND sky130_ef_sc_hd__decap_12
XFILLER_97_93 VPWR VGND VPWR VGND sky130_ef_sc_hd__decap_12
XFILLER_80_1258 VPWR VGND VPWR VGND sky130_ef_sc_hd__decap_12
XFILLER_45_1378 VGND VGND VPWR VPWR sky130_fd_sc_hd__decap_6
XTAP_TAPCELL_ROW_206_2615 VGND VPWR sky130_fd_sc_hd__tapvpwrvgnd_1
XTAP_TAPCELL_ROW_206_2604 VGND VPWR sky130_fd_sc_hd__tapvpwrvgnd_1
XFILLER_11_3 VPWR VGND VPWR VGND sky130_ef_sc_hd__decap_12
XFILLER_110_1602 VGND VGND VPWR VPWR sky130_fd_sc_hd__decap_3
XFILLER_165_1113 VGND VGND VPWR VPWR sky130_fd_sc_hd__decap_6
XFILLER_165_1157 VPWR VGND VPWR VGND sky130_ef_sc_hd__decap_12
XFILLER_95_1490 VGND VGND VPWR VPWR sky130_fd_sc_hd__decap_6
XFILLER_91_1310 VPWR VGND VPWR VGND sky130_ef_sc_hd__decap_12
XFILLER_195_429 VPWR VGND VPWR VGND sky130_ef_sc_hd__decap_12
XFILLER_143_1422 VPWR VGND VPWR VGND sky130_ef_sc_hd__decap_12
XFILLER_91_1354 VPWR VGND VPWR VGND sky130_ef_sc_hd__decap_12
XFILLER_22_126 VGND VGND VPWR VPWR sky130_fd_sc_hd__fill_1
XFILLER_104_1406 VGND VGND VPWR VPWR sky130_fd_sc_hd__decap_6
XTAP_TAPCELL_ROW_35_1_1087 VGND VPWR sky130_fd_sc_hd__tapvpwrvgnd_1
XFILLER_52_1338 VPWR VGND VPWR VGND sky130_ef_sc_hd__decap_12
XFILLER_202_1029 VGND VGND VPWR VPWR sky130_fd_sc_hd__decap_6
XFILLER_176_643 VGND VGND VPWR VPWR sky130_fd_sc_hd__fill_1
XFILLER_164_805 VGND VGND VPWR VPWR sky130_fd_sc_hd__decap_6
XFILLER_143_1466 VPWR VGND VPWR VGND sky130_ef_sc_hd__decap_12
XFILLER_91_1398 VPWR VGND VPWR VGND sky130_ef_sc_hd__decap_12
XANTENNA__603__CLK clknet_3_3_0_clk VGND VGND VPWR VPWR sky130_fd_sc_hd__diode_2
XFILLER_164_849 VPWR VGND VPWR VGND sky130_ef_sc_hd__decap_12
XFILLER_163_337 VPWR VGND VPWR VGND sky130_ef_sc_hd__decap_12
XFILLER_89_1272 VGND VGND VPWR VPWR sky130_fd_sc_hd__fill_1
XFILLER_219_1537 VGND VGND VPWR VPWR sky130_fd_sc_hd__decap_3
XFILLER_176_1253 VGND VGND VPWR VPWR sky130_fd_sc_hd__decap_6
XFILLER_117_15 VPWR VGND VPWR VGND sky130_ef_sc_hd__decap_12
XFILLER_2_509 VGND VGND VPWR VPWR sky130_fd_sc_hd__fill_1
XFILLER_190_189 VGND VGND VPWR VPWR sky130_fd_sc_hd__decap_6
XFILLER_176_1297 VPWR VGND VPWR VGND sky130_ef_sc_hd__decap_12
XFILLER_172_1117 VPWR VGND VPWR VGND sky130_ef_sc_hd__decap_12
XFILLER_172_893 VPWR VGND VPWR VGND sky130_ef_sc_hd__decap_12
XFILLER_63_1434 VGND VGND VPWR VPWR sky130_fd_sc_hd__decap_6
XTAP_TAPCELL_ROW_168_1541 VGND VPWR sky130_fd_sc_hd__tapvpwrvgnd_1
XTAP_TAPCELL_ROW_168_1530 VGND VPWR sky130_fd_sc_hd__tapvpwrvgnd_1
XFILLER_154_1562 VPWR VGND VPWR VGND sky130_ef_sc_hd__decap_12
XPHY_EDGE_ROW_90_2_Right_147 VGND VGND VPWR VPWR sky130_fd_sc_hd__decap_3
XANTENNA_input8_A func_addr[5] VGND VGND VPWR VPWR sky130_fd_sc_hd__diode_2
XFILLER_213_1169 VGND VGND VPWR VPWR sky130_fd_sc_hd__decap_6
XTAP_TAPCELL_ROW_164_1427 VGND VPWR sky130_fd_sc_hd__tapvpwrvgnd_1
XTAP_TAPCELL_ROW_164_1416 VGND VPWR sky130_fd_sc_hd__tapvpwrvgnd_1
XTAP_TAPCELL_ROW_164_1405 VGND VPWR sky130_fd_sc_hd__tapvpwrvgnd_1
XFILLER_150_1426 VPWR VGND VPWR VGND sky130_ef_sc_hd__decap_12
XFILLER_115_1546 VGND VGND VPWR VPWR sky130_fd_sc_hd__decap_6
XTAP_TAPCELL_ROW_114_2_3716 VGND VPWR sky130_fd_sc_hd__tapvpwrvgnd_1
XTAP_TAPCELL_ROW_90_1_1197 VGND VPWR sky130_fd_sc_hd__tapvpwrvgnd_1
XFILLER_63_1478 VPWR VGND VPWR VGND sky130_ef_sc_hd__decap_12
XFILLER_133_69 VPWR VGND VPWR VGND sky130_ef_sc_hd__decap_12
XFILLER_2_1203 VGND VGND VPWR VPWR sky130_fd_sc_hd__fill_1
XFILLER_148_1300 VGND VGND VPWR VPWR sky130_fd_sc_hd__fill_1
XFILLER_96_1232 VPWR VGND VPWR VGND sky130_ef_sc_hd__decap_12
XFILLER_214_533 VPWR VGND VPWR VGND sky130_ef_sc_hd__decap_12
XFILLER_183_1213 VPWR VGND VPWR VGND sky130_ef_sc_hd__decap_12
XFILLER_198_245 VGND VGND VPWR VPWR sky130_fd_sc_hd__decap_6
XFILLER_187_1393 VGND VGND VPWR VPWR sky130_fd_sc_hd__decap_6
XFILLER_183_1257 VPWR VGND VPWR VGND sky130_ef_sc_hd__decap_12
XFILLER_109_1328 VGND VGND VPWR VPWR sky130_fd_sc_hd__fill_1
XFILLER_201_205 VPWR VGND VPWR VGND sky130_ef_sc_hd__decap_12
XFILLER_158_109 VPWR VGND VPWR VGND sky130_ef_sc_hd__decap_12
X_290_ u_ctrl.elem_idx\[1\] _071_ u_ctrl.op_idx u_ctrl.elem_idx\[2\] VGND VGND VPWR
+ VPWR _085_ sky130_fd_sc_hd__a211o_1
XFILLER_201_249 VPWR VGND VPWR VGND sky130_ef_sc_hd__decap_12
XFILLER_198_289 VPWR VGND VPWR VGND sky130_ef_sc_hd__decap_12
XFILLER_161_1522 VPWR VGND VPWR VGND sky130_ef_sc_hd__decap_12
XFILLER_122_1506 VPWR VGND VPWR VGND sky130_ef_sc_hd__decap_12
XFILLER_74_1574 VGND VGND VPWR VPWR sky130_fd_sc_hd__decap_6
XFILLER_70_1438 VPWR VGND VPWR VGND sky130_ef_sc_hd__decap_12
XFILLER_167_665 VGND VGND VPWR VPWR sky130_fd_sc_hd__decap_6
XFILLER_161_1566 VPWR VGND VPWR VGND sky130_ef_sc_hd__decap_12
XFILLER_42_77 VGND VGND VPWR VPWR sky130_fd_sc_hd__decap_6
XFILLER_213_3 VPWR VGND VPWR VGND sky130_ef_sc_hd__decap_12
XFILLER_202_1541 VPWR VGND VPWR VGND sky130_ef_sc_hd__decap_12
XFILLER_182_613 VPWR VGND VPWR VGND sky130_ef_sc_hd__decap_12
XFILLER_166_153 VPWR VGND VPWR VGND sky130_ef_sc_hd__decap_12
XFILLER_158_77 VGND VGND VPWR VPWR sky130_fd_sc_hd__decap_6
XFILLER_6_837 VPWR VGND VPWR VGND sky130_ef_sc_hd__decap_12
XFILLER_182_657 VPWR VGND VPWR VGND sky130_ef_sc_hd__decap_12
XFILLER_166_197 VPWR VGND VPWR VGND sky130_ef_sc_hd__decap_12
XFILLER_5_325 VGND VGND VPWR VPWR sky130_fd_sc_hd__fill_1
XFILLER_194_1353 VPWR VGND VPWR VGND sky130_ef_sc_hd__decap_12
XFILLER_181_167 VGND VGND VPWR VPWR sky130_fd_sc_hd__fill_1
XFILLER_159_1440 VGND VGND VPWR VPWR sky130_fd_sc_hd__fill_1
XFILLER_68_1356 VGND VGND VPWR VPWR sky130_fd_sc_hd__fill_1
XFILLER_5_369 VGND VGND VPWR VPWR sky130_fd_sc_hd__fill_1
XFILLER_190_1217 VPWR VGND VPWR VGND sky130_ef_sc_hd__decap_12
XFILLER_174_65 VPWR VGND VPWR VGND sky130_ef_sc_hd__decap_12
XFILLER_163_893 VGND VGND VPWR VPWR sky130_fd_sc_hd__decap_3
XFILLER_194_1397 VPWR VGND VPWR VGND sky130_ef_sc_hd__decap_12
XFILLER_3_27 VPWR VGND VPWR VGND sky130_ef_sc_hd__decap_12
XFILLER_1_531 VGND VGND VPWR VPWR sky130_fd_sc_hd__fill_1
XFILLER_133_1602 VGND VGND VPWR VPWR sky130_fd_sc_hd__decap_3
XFILLER_107_81 VPWR VGND VPWR VGND sky130_ef_sc_hd__decap_12
XFILLER_81_1534 VPWR VGND VPWR VGND sky130_ef_sc_hd__decap_12
XFILLER_42_1518 VGND VGND VPWR VPWR sky130_fd_sc_hd__decap_6
XFILLER_209_305 VPWR VGND VPWR VGND sky130_ef_sc_hd__decap_12
XFILLER_81_1578 VPWR VGND VPWR VGND sky130_ef_sc_hd__decap_12
XFILLER_209_349 VPWR VGND VPWR VGND sky130_ef_sc_hd__decap_12
XFILLER_190_53 VPWR VGND VPWR VGND sky130_ef_sc_hd__decap_12
XFILLER_218_861 VGND VGND VPWR VPWR sky130_fd_sc_hd__decap_6
XFILLER_190_97 VPWR VGND VPWR VGND sky130_ef_sc_hd__decap_12
XFILLER_217_393 VPWR VGND VPWR VGND sky130_ef_sc_hd__decap_12
XFILLER_83_51 VGND VGND VPWR VPWR sky130_fd_sc_hd__decap_4
X_626_ clknet_3_3_0_clk _060_ VGND VGND VPWR VPWR net51 sky130_fd_sc_hd__dfxtp_1
XFILLER_199_51 VGND VGND VPWR VPWR sky130_fd_sc_hd__decap_4
XFILLER_189_223 VGND VGND VPWR VPWR sky130_fd_sc_hd__fill_1
XFILLER_79_1496 VGND VGND VPWR VPWR sky130_fd_sc_hd__fill_1
X_557_ net136 _252_ VGND VGND VPWR VPWR _062_ sky130_fd_sc_hd__and2_1
XANTENNA__626__CLK clknet_3_3_0_clk VGND VGND VPWR VPWR sky130_fd_sc_hd__diode_2
XFILLER_166_1477 VGND VGND VPWR VPWR sky130_fd_sc_hd__decap_6
XFILLER_177_429 VPWR VGND VPWR VGND sky130_ef_sc_hd__decap_12
X_488_ net79 net121 VGND VGND VPWR VPWR _218_ sky130_fd_sc_hd__or2_1
XANTENNA__435__A b_addr\[7\] VGND VGND VPWR VPWR sky130_fd_sc_hd__diode_2
XFILLER_201_783 VGND VGND VPWR VPWR sky130_fd_sc_hd__fill_1
XFILLER_199_1231 VGND VGND VPWR VPWR sky130_fd_sc_hd__fill_1
XTAP_TAPCELL_ROW_95_2_3594 VGND VPWR sky130_fd_sc_hd__tapvpwrvgnd_1
XPHY_EDGE_ROW_24_2_Left_456 VGND VGND VPWR VPWR sky130_fd_sc_hd__decap_3
XFILLER_185_473 VPWR VGND VPWR VGND sky130_ef_sc_hd__decap_12
XFILLER_12_1300 VGND VGND VPWR VPWR sky130_fd_sc_hd__fill_1
XPHY_EDGE_ROW_149_2_Left_581 VGND VGND VPWR VPWR sky130_fd_sc_hd__decap_3
XFILLER_86_1412 VGND VGND VPWR VPWR sky130_fd_sc_hd__fill_1
XANTENNA__489__A1 net149 VGND VGND VPWR VPWR sky130_fd_sc_hd__diode_2
XTAP_TAPCELL_ROW_120_2_3759 VGND VPWR sky130_fd_sc_hd__tapvpwrvgnd_1
XFILLER_59_3 VPWR VGND VPWR VGND sky130_ef_sc_hd__decap_12
XFILLER_172_189 VGND VGND VPWR VPWR sky130_fd_sc_hd__decap_6
XFILLER_138_1524 VGND VGND VPWR VPWR sky130_fd_sc_hd__fill_1
XFILLER_5_881 VPWR VGND VPWR VGND sky130_ef_sc_hd__decap_12
XFILLER_173_1437 VPWR VGND VPWR VGND sky130_ef_sc_hd__decap_12
XFILLER_136_1270 VPWR VGND VPWR VGND sky130_ef_sc_hd__decap_12
XFILLER_210_1309 VGND VGND VPWR VPWR sky130_fd_sc_hd__decap_6
XFILLER_23_1440 VGND VGND VPWR VPWR sky130_fd_sc_hd__fill_1
XFILLER_103_39 VPWR VGND VPWR VGND sky130_ef_sc_hd__decap_12
XFILLER_97_1552 VGND VGND VPWR VPWR sky130_fd_sc_hd__fill_1
XFILLER_3_1567 VGND VGND VPWR VPWR sky130_fd_sc_hd__fill_1
XFILLER_208_1205 VPWR VGND VPWR VGND sky130_ef_sc_hd__decap_12
XFILLER_184_1533 VGND VGND VPWR VPWR sky130_fd_sc_hd__decap_6
XFILLER_211_503 VGND VGND VPWR VPWR sky130_fd_sc_hd__fill_1
XFILLER_184_1577 VPWR VGND VPWR VGND sky130_ef_sc_hd__decap_12
XFILLER_196_749 VGND VGND VPWR VPWR sky130_fd_sc_hd__decap_6
XFILLER_195_237 VPWR VGND VPWR VGND sky130_ef_sc_hd__decap_12
XFILLER_108_1350 VGND VGND VPWR VPWR sky130_fd_sc_hd__decap_6
XTAP_TAPCELL_ROW_16_2_3085 VGND VPWR sky130_fd_sc_hd__tapvpwrvgnd_1
XFILLER_56_1282 VPWR VGND VPWR VGND sky130_ef_sc_hd__decap_12
XFILLER_17_1244 VPWR VGND VPWR VGND sky130_ef_sc_hd__decap_12
XFILLER_164_613 VPWR VGND VPWR VGND sky130_ef_sc_hd__decap_12
XFILLER_143_1274 VPWR VGND VPWR VGND sky130_ef_sc_hd__decap_12
XFILLER_108_1394 VPWR VGND VPWR VGND sky130_ef_sc_hd__decap_12
XFILLER_104_1258 VPWR VGND VPWR VGND sky130_ef_sc_hd__decap_12
XFILLER_34_1580 VGND VGND VPWR VPWR sky130_fd_sc_hd__fill_1
XFILLER_178_1315 VGND VGND VPWR VPWR sky130_fd_sc_hd__fill_1
XFILLER_164_657 VPWR VGND VPWR VGND sky130_ef_sc_hd__decap_12
XFILLER_219_1301 VPWR VGND VPWR VGND sky130_ef_sc_hd__decap_12
XFILLER_156_1602 VGND VGND VPWR VPWR sky130_fd_sc_hd__decap_3
XFILLER_219_1345 VPWR VGND VPWR VGND sky130_ef_sc_hd__decap_12
XFILLER_176_1061 VPWR VGND VPWR VGND sky130_ef_sc_hd__decap_12
XFILLER_88_29 VPWR VGND VPWR VGND sky130_ef_sc_hd__decap_12
XFILLER_191_1537 VPWR VGND VPWR VGND sky130_ef_sc_hd__decap_12
XFILLER_115_1310 VPWR VGND VPWR VGND sky130_ef_sc_hd__decap_12
XFILLER_63_1220 VPWR VGND VPWR VGND sky130_ef_sc_hd__decap_12
XFILLER_8_1412 VGND VGND VPWR VPWR sky130_fd_sc_hd__fill_1
XFILLER_154_1370 VPWR VGND VPWR VGND sky130_ef_sc_hd__decap_12
XFILLER_119_1490 VGND VGND VPWR VPWR sky130_fd_sc_hd__decap_6
XFILLER_115_1354 VPWR VGND VPWR VGND sky130_ef_sc_hd__decap_12
XPHY_EDGE_ROW_91_2_Right_148 VGND VGND VPWR VPWR sky130_fd_sc_hd__decap_3
XFILLER_63_1286 VPWR VGND VPWR VGND sky130_ef_sc_hd__decap_12
XFILLER_219_669 VGND VGND VPWR VPWR sky130_fd_sc_hd__decap_3
XFILLER_207_809 VPWR VGND VPWR VGND sky130_ef_sc_hd__decap_12
XFILLER_4_1309 VGND VGND VPWR VPWR sky130_fd_sc_hd__decap_6
XFILLER_189_1455 VGND VGND VPWR VPWR sky130_fd_sc_hd__fill_1
XTAP_TAPCELL_ROW_144_2_3911 VGND VPWR sky130_fd_sc_hd__tapvpwrvgnd_1
XFILLER_115_1398 VPWR VGND VPWR VGND sky130_ef_sc_hd__decap_12
XFILLER_98_1338 VPWR VGND VPWR VGND sky130_ef_sc_hd__decap_12
XTAP_TAPCELL_ROW_2_851 VGND VPWR sky130_fd_sc_hd__tapvpwrvgnd_1
XTAP_TAPCELL_ROW_2_840 VGND VPWR sky130_fd_sc_hd__tapvpwrvgnd_1
XFILLER_37_55 VGND VGND VPWR VPWR sky130_fd_sc_hd__fill_1
XTAP_TAPCELL_ROW_2_862 VGND VPWR sky130_fd_sc_hd__tapvpwrvgnd_1
XFILLER_215_853 VPWR VGND VPWR VGND sky130_ef_sc_hd__decap_12
XFILLER_183_1021 VPWR VGND VPWR VGND sky130_ef_sc_hd__decap_12
XFILLER_163_3 VPWR VGND VPWR VGND sky130_ef_sc_hd__decap_12
X_411_ _108_ _146_ _117_ VGND VGND VPWR VPWR _147_ sky130_fd_sc_hd__a21oi_1
XFILLER_215_897 VPWR VGND VPWR VGND sky130_ef_sc_hd__decap_12
XFILLER_214_363 VGND VGND VPWR VPWR sky130_fd_sc_hd__fill_1
XFILLER_202_525 VGND VGND VPWR VPWR sky130_fd_sc_hd__decap_6
XFILLER_187_727 VGND VGND VPWR VPWR sky130_fd_sc_hd__fill_1
XFILLER_183_1065 VPWR VGND VPWR VGND sky130_ef_sc_hd__decap_12
XTAP_TAPCELL_ROW_113_1_1243 VGND VPWR sky130_fd_sc_hd__tapvpwrvgnd_1
X_342_ u_ctrl.cmp_addr\[2\] b_addr\[2\] net152 VGND VGND VPWR VPWR _092_ sky130_fd_sc_hd__mux2_1
XFILLER_35_1322 VGND VGND VPWR VPWR sky130_fd_sc_hd__decap_6
XFILLER_202_569 VPWR VGND VPWR VGND sky130_ef_sc_hd__decap_12
XFILLER_161_1330 VPWR VGND VPWR VGND sky130_ef_sc_hd__decap_12
XFILLER_126_1450 VPWR VGND VPWR VGND sky130_ef_sc_hd__decap_12
XFILLER_122_1314 VPWR VGND VPWR VGND sky130_ef_sc_hd__decap_12
XFILLER_74_1382 VPWR VGND VPWR VGND sky130_ef_sc_hd__decap_12
XFILLER_70_1246 VPWR VGND VPWR VGND sky130_ef_sc_hd__decap_12
X_273_ u_ctrl.op_idx VGND VGND VPWR VPWR _072_ sky130_fd_sc_hd__inv_2
XFILLER_35_1366 VPWR VGND VPWR VGND sky130_ef_sc_hd__decap_12
XFILLER_183_933 VPWR VGND VPWR VGND sky130_ef_sc_hd__decap_12
XFILLER_167_473 VPWR VGND VPWR VGND sky130_ef_sc_hd__decap_12
XFILLER_126_1494 VPWR VGND VPWR VGND sky130_ef_sc_hd__decap_12
XFILLER_202_1371 VGND VGND VPWR VPWR sky130_fd_sc_hd__fill_1
XFILLER_182_421 VPWR VGND VPWR VGND sky130_ef_sc_hd__decap_12
XPHY_EDGE_ROW_134_1_Left_353 VGND VGND VPWR VPWR sky130_fd_sc_hd__decap_3
XFILLER_122_1358 VPWR VGND VPWR VGND sky130_ef_sc_hd__decap_12
XFILLER_6_645 VPWR VGND VPWR VGND sky130_ef_sc_hd__decap_12
XFILLER_183_977 VPWR VGND VPWR VGND sky130_ef_sc_hd__decap_12
XFILLER_194_1161 VPWR VGND VPWR VGND sky130_ef_sc_hd__decap_12
XFILLER_133_1410 VPWR VGND VPWR VGND sky130_ef_sc_hd__decap_12
XFILLER_81_1342 VPWR VGND VPWR VGND sky130_ef_sc_hd__decap_12
XFILLER_46_1462 VGND VGND VPWR VPWR sky130_fd_sc_hd__decap_6
XFILLER_137_1590 VPWR VGND VPWR VGND sky130_ef_sc_hd__decap_12
XFILLER_42_1326 VPWR VGND VPWR VGND sky130_ef_sc_hd__decap_12
XFILLER_209_113 VPWR VGND VPWR VGND sky130_ef_sc_hd__decap_12
XFILLER_204_27 VGND VGND VPWR VPWR sky130_fd_sc_hd__fill_1
XFILLER_133_1454 VPWR VGND VPWR VGND sky130_ef_sc_hd__decap_12
XFILLER_81_1386 VPWR VGND VPWR VGND sky130_ef_sc_hd__decap_12
XFILLER_133_1498 VPWR VGND VPWR VGND sky130_ef_sc_hd__decap_12
XFILLER_20_1602 VGND VGND VPWR VPWR sky130_fd_sc_hd__decap_3
XFILLER_168_1539 VGND VGND VPWR VPWR sky130_fd_sc_hd__fill_1
XFILLER_94_83 VGND VGND VPWR VPWR sky130_fd_sc_hd__fill_1
XFILLER_209_1525 VPWR VGND VPWR VGND sky130_ef_sc_hd__decap_12
XFILLER_166_1241 VPWR VGND VPWR VGND sky130_ef_sc_hd__decap_12
X_609_ clknet_3_7_0_clk _043_ VGND VGND VPWR VPWR net65 sky130_fd_sc_hd__dfxtp_1
XFILLER_209_1569 VPWR VGND VPWR VGND sky130_ef_sc_hd__decap_12
XFILLER_205_385 VGND VGND VPWR VPWR sky130_fd_sc_hd__decap_6
XFILLER_178_749 VGND VGND VPWR VPWR sky130_fd_sc_hd__decap_6
XFILLER_166_1285 VPWR VGND VPWR VGND sky130_ef_sc_hd__decap_12
XFILLER_53_1422 VPWR VGND VPWR VGND sky130_ef_sc_hd__decap_12
XPHY_EDGE_ROW_53_2_Right_110 VGND VGND VPWR VPWR sky130_fd_sc_hd__decap_3
XFILLER_203_1113 VGND VGND VPWR VPWR sky130_fd_sc_hd__decap_6
XFILLER_177_237 VPWR VGND VPWR VGND sky130_ef_sc_hd__decap_12
XFILLER_144_1550 VPWR VGND VPWR VGND sky130_ef_sc_hd__decap_12
XFILLER_92_1482 VPWR VGND VPWR VGND sky130_ef_sc_hd__decap_12
XFILLER_14_1406 VGND VGND VPWR VPWR sky130_fd_sc_hd__decap_6
XFILLER_203_1157 VPWR VGND VPWR VGND sky130_ef_sc_hd__decap_12
XFILLER_144_1594 VGND VGND VPWR VPWR sky130_fd_sc_hd__decap_8
XFILLER_140_1414 VPWR VGND VPWR VGND sky130_ef_sc_hd__decap_12
XFILLER_105_1534 VPWR VGND VPWR VGND sky130_ef_sc_hd__decap_12
XPHY_EDGE_ROW_66_1_Left_285 VGND VGND VPWR VPWR sky130_fd_sc_hd__decap_3
XFILLER_53_1466 VPWR VGND VPWR VGND sky130_ef_sc_hd__decap_12
XFILLER_186_793 VPWR VGND VPWR VGND sky130_ef_sc_hd__decap_12
XFILLER_185_281 VPWR VGND VPWR VGND sky130_ef_sc_hd__decap_12
XFILLER_105_1578 VPWR VGND VPWR VGND sky130_ef_sc_hd__decap_12
XFILLER_88_1518 VGND VGND VPWR VPWR sky130_fd_sc_hd__decap_6
XFILLER_86_1220 VPWR VGND VPWR VGND sky130_ef_sc_hd__decap_12
XFILLER_173_1201 VPWR VGND VPWR VGND sky130_ef_sc_hd__decap_12
XANTENNA__331__A0 b_addr\[6\] VGND VGND VPWR VPWR sky130_fd_sc_hd__diode_2
XFILLER_177_1381 VPWR VGND VPWR VGND sky130_ef_sc_hd__decap_12
XFILLER_173_1245 VPWR VGND VPWR VGND sky130_ef_sc_hd__decap_12
XTAP_TAPCELL_ROW_149_2_3948 VGND VPWR sky130_fd_sc_hd__tapvpwrvgnd_1
XTAP_TAPCELL_ROW_150_2_3954 VGND VPWR sky130_fd_sc_hd__tapvpwrvgnd_1
XFILLER_173_1289 VPWR VGND VPWR VGND sky130_ef_sc_hd__decap_12
XFILLER_151_1510 VPWR VGND VPWR VGND sky130_ef_sc_hd__decap_12
XFILLER_64_1562 VPWR VGND VPWR VGND sky130_ef_sc_hd__decap_12
XFILLER_214_1253 VGND VGND VPWR VPWR sky130_fd_sc_hd__decap_6
XFILLER_210_1117 VPWR VGND VPWR VGND sky130_ef_sc_hd__decap_12
XFILLER_151_1554 VPWR VGND VPWR VGND sky130_ef_sc_hd__decap_12
XFILLER_114_27 VGND VGND VPWR VPWR sky130_fd_sc_hd__fill_1
XFILLER_25_1546 VGND VGND VPWR VPWR sky130_fd_sc_hd__decap_6
XFILLER_60_1426 VPWR VGND VPWR VGND sky130_ef_sc_hd__decap_12
XFILLER_214_1297 VPWR VGND VPWR VGND sky130_ef_sc_hd__decap_12
XFILLER_112_1538 VPWR VGND VPWR VGND sky130_ef_sc_hd__decap_12
XFILLER_215_105 VGND VGND VPWR VPWR sky130_fd_sc_hd__decap_6
XFILLER_82_121 VGND VGND VPWR VPWR sky130_fd_sc_hd__decap_6
XFILLER_58_1300 VGND VGND VPWR VPWR sky130_fd_sc_hd__fill_1
XFILLER_215_149 VPWR VGND VPWR VGND sky130_ef_sc_hd__decap_12
XPHY_EDGE_ROW_171_Right_16 VGND VGND VPWR VPWR sky130_fd_sc_hd__decap_3
XFILLER_130_15 VPWR VGND VPWR VGND sky130_ef_sc_hd__decap_12
XFILLER_208_1035 VGND VGND VPWR VPWR sky130_fd_sc_hd__fill_1
XFILLER_184_1341 VPWR VGND VPWR VGND sky130_ef_sc_hd__decap_12
XFILLER_180_1205 VPWR VGND VPWR VGND sky130_ef_sc_hd__decap_12
XANTENNA_fanout156_X net156 VGND VGND VPWR VPWR sky130_fd_sc_hd__diode_2
XPHY_EDGE_ROW_9_2_Left_441 VGND VGND VPWR VPWR sky130_fd_sc_hd__decap_3
XFILLER_19_1328 VGND VGND VPWR VPWR sky130_fd_sc_hd__fill_1
XFILLER_212_867 VGND VGND VPWR VPWR sky130_fd_sc_hd__fill_1
XFILLER_196_513 VPWR VGND VPWR VGND sky130_ef_sc_hd__decap_12
XFILLER_184_1385 VPWR VGND VPWR VGND sky130_ef_sc_hd__decap_12
XFILLER_169_727 VGND VGND VPWR VPWR sky130_fd_sc_hd__fill_1
XFILLER_93_1268 VGND VGND VPWR VPWR sky130_fd_sc_hd__decap_4
XFILLER_196_557 VPWR VGND VPWR VGND sky130_ef_sc_hd__decap_12
XFILLER_71_1522 VPWR VGND VPWR VGND sky130_ef_sc_hd__decap_12
XFILLER_71_1566 VPWR VGND VPWR VGND sky130_ef_sc_hd__decap_12
XFILLER_23_57 VGND VGND VPWR VPWR sky130_fd_sc_hd__decap_8
XFILLER_23_79 VGND VGND VPWR VPWR sky130_fd_sc_hd__fill_1
XFILLER_32_1506 VPWR VGND VPWR VGND sky130_ef_sc_hd__decap_12
XTAP_TAPCELL_ROW_46_2_3280 VGND VPWR sky130_fd_sc_hd__tapvpwrvgnd_1
XFILLER_165_933 VPWR VGND VPWR VGND sky130_ef_sc_hd__decap_12
XFILLER_164_421 VPWR VGND VPWR VGND sky130_ef_sc_hd__decap_12
XFILLER_139_57 VPWR VGND VPWR VGND sky130_ef_sc_hd__decap_12
XPHY_EDGE_ROW_180_Right_25 VGND VGND VPWR VPWR sky130_fd_sc_hd__decap_3
XFILLER_180_925 VPWR VGND VPWR VGND sky130_ef_sc_hd__decap_12
XFILLER_165_977 VPWR VGND VPWR VGND sky130_ef_sc_hd__decap_12
XFILLER_99_39 VPWR VGND VPWR VGND sky130_ef_sc_hd__decap_12
XFILLER_191_1301 VPWR VGND VPWR VGND sky130_ef_sc_hd__decap_12
XFILLER_191_273 VGND VGND VPWR VPWR sky130_fd_sc_hd__decap_6
XFILLER_69_1440 VGND VGND VPWR VPWR sky130_fd_sc_hd__fill_1
XFILLER_3_615 VGND VGND VPWR VPWR sky130_fd_sc_hd__fill_1
XFILLER_195_1481 VPWR VGND VPWR VGND sky130_ef_sc_hd__decap_12
XFILLER_191_1345 VPWR VGND VPWR VGND sky130_ef_sc_hd__decap_12
XFILLER_8_1220 VPWR VGND VPWR VGND sky130_ef_sc_hd__decap_12
XTAP_TAPCELL_ROW_38_2_3228 VGND VPWR sky130_fd_sc_hd__tapvpwrvgnd_1
XFILLER_43_1602 VGND VGND VPWR VPWR sky130_fd_sc_hd__decap_3
XFILLER_219_433 VPWR VGND VPWR VGND sky130_ef_sc_hd__decap_12
XFILLER_4_1117 VPWR VGND VPWR VGND sky130_ef_sc_hd__decap_12
XTAP_TAPCELL_ROW_7_987 VGND VPWR sky130_fd_sc_hd__tapvpwrvgnd_1
XTAP_TAPCELL_ROW_7_998 VGND VPWR sky130_fd_sc_hd__tapvpwrvgnd_1
XFILLER_48_65 VGND VGND VPWR VPWR sky130_fd_sc_hd__decap_6
XFILLER_219_477 VPWR VGND VPWR VGND sky130_ef_sc_hd__decap_12
XFILLER_207_617 VPWR VGND VPWR VGND sky130_ef_sc_hd__decap_12
XFILLER_171_55 VGND VGND VPWR VPWR sky130_fd_sc_hd__fill_1
XPHY_EDGE_ROW_92_2_Right_149 VGND VGND VPWR VPWR sky130_fd_sc_hd__decap_3
XFILLER_64_53 VPWR VGND VPWR VGND sky130_ef_sc_hd__decap_12
XFILLER_167_1561 VGND VGND VPWR VPWR sky130_fd_sc_hd__decap_6
XFILLER_64_97 VPWR VGND VPWR VGND sky130_ef_sc_hd__decap_12
XFILLER_202_333 VPWR VGND VPWR VGND sky130_ef_sc_hd__decap_12
XFILLER_199_373 VPWR VGND VPWR VGND sky130_ef_sc_hd__decap_12
XFILLER_163_1425 VGND VGND VPWR VPWR sky130_fd_sc_hd__decap_3
XFILLER_9_15 VPWR VGND VPWR VGND sky130_ef_sc_hd__decap_12
XFILLER_203_889 VGND VGND VPWR VPWR sky130_fd_sc_hd__decap_6
XFILLER_163_1469 VPWR VGND VPWR VGND sky130_ef_sc_hd__decap_12
XFILLER_80_41 VPWR VGND VPWR VGND sky130_ef_sc_hd__decap_12
X_325_ b_addr\[0\] net3 net141 VGND VGND VPWR VPWR s_addr\[0\] sky130_fd_sc_hd__mux2_1
XFILLER_202_377 VPWR VGND VPWR VGND sky130_ef_sc_hd__decap_12
XFILLER_196_41 VPWR VGND VPWR VGND sky130_ef_sc_hd__decap_12
XFILLER_204_1477 VGND VGND VPWR VPWR sky130_fd_sc_hd__decap_6
XFILLER_196_85 VPWR VGND VPWR VGND sky130_ef_sc_hd__decap_12
XFILLER_183_741 VPWR VGND VPWR VGND sky130_ef_sc_hd__decap_12
XFILLER_168_793 VPWR VGND VPWR VGND sky130_ef_sc_hd__decap_12
XFILLER_167_281 VPWR VGND VPWR VGND sky130_ef_sc_hd__decap_12
XFILLER_80_85 VPWR VGND VPWR VGND sky130_ef_sc_hd__decap_12
XFILLER_7_921 VGND VGND VPWR VPWR sky130_fd_sc_hd__decap_3
XFILLER_182_251 VGND VGND VPWR VPWR sky130_fd_sc_hd__fill_1
XFILLER_7_965 VPWR VGND VPWR VGND sky130_ef_sc_hd__decap_12
XFILLER_183_785 VPWR VGND VPWR VGND sky130_ef_sc_hd__decap_12
XFILLER_170_413 VGND VGND VPWR VPWR sky130_fd_sc_hd__decap_6
XFILLER_6_475 VGND VGND VPWR VPWR sky130_fd_sc_hd__fill_1
XFILLER_174_1521 VPWR VGND VPWR VGND sky130_ef_sc_hd__decap_12
XFILLER_170_457 VPWR VGND VPWR VGND sky130_ef_sc_hd__decap_12
XTAP_TAPCELL_ROW_135_2_3856 VGND VPWR sky130_fd_sc_hd__tapvpwrvgnd_1
XFILLER_48_1524 VGND VGND VPWR VPWR sky130_fd_sc_hd__fill_1
XFILLER_215_15 VPWR VGND VPWR VGND sky130_ef_sc_hd__decap_12
XFILLER_174_1565 VPWR VGND VPWR VGND sky130_ef_sc_hd__decap_12
XFILLER_170_1429 VPWR VGND VPWR VGND sky130_ef_sc_hd__decap_12
XFILLER_46_1270 VPWR VGND VPWR VGND sky130_ef_sc_hd__decap_12
XFILLER_1_180 VGND VGND VPWR VPWR sky130_fd_sc_hd__decap_4
XFILLER_211_1437 VPWR VGND VPWR VGND sky130_ef_sc_hd__decap_12
XFILLER_64_121 VGND VGND VPWR VPWR sky130_fd_sc_hd__decap_6
XFILLER_213_609 VGND VGND VPWR VPWR sky130_fd_sc_hd__decap_6
XFILLER_0_1537 VGND VGND VPWR VPWR sky130_fd_sc_hd__decap_3
XFILLER_205_193 VPWR VGND VPWR VGND sky130_ef_sc_hd__decap_12
XFILLER_181_1525 VPWR VGND VPWR VGND sky130_ef_sc_hd__decap_12
XFILLER_178_513 VPWR VGND VPWR VGND sky130_ef_sc_hd__decap_12
XFILLER_209_1399 VGND VGND VPWR VPWR sky130_fd_sc_hd__fill_1
XFILLER_181_1569 VPWR VGND VPWR VGND sky130_ef_sc_hd__decap_12
XFILLER_178_557 VPWR VGND VPWR VGND sky130_ef_sc_hd__decap_12
XFILLER_166_1093 VPWR VGND VPWR VGND sky130_ef_sc_hd__decap_12
XFILLER_100_29 VPWR VGND VPWR VGND sky130_ef_sc_hd__decap_12
XFILLER_18_1350 VGND VGND VPWR VPWR sky130_fd_sc_hd__decap_6
XPHY_EDGE_ROW_54_2_Right_111 VGND VGND VPWR VPWR sky130_fd_sc_hd__decap_3
XFILLER_193_505 VPWR VGND VPWR VGND sky130_ef_sc_hd__decap_12
XFILLER_197_1009 VPWR VGND VPWR VGND sky130_ef_sc_hd__decap_12
XFILLER_140_1244 VGND VGND VPWR VPWR sky130_fd_sc_hd__fill_1
XFILLER_105_1342 VPWR VGND VPWR VGND sky130_ef_sc_hd__decap_12
XFILLER_14_1258 VPWR VGND VPWR VGND sky130_ef_sc_hd__decap_12
XFILLER_18_1394 VPWR VGND VPWR VGND sky130_ef_sc_hd__decap_12
XFILLER_53_1274 VPWR VGND VPWR VGND sky130_ef_sc_hd__decap_12
XFILLER_109_27 VPWR VGND VPWR VGND sky130_ef_sc_hd__decap_12
XFILLER_105_1386 VPWR VGND VPWR VGND sky130_ef_sc_hd__decap_12
XFILLER_88_1326 VPWR VGND VPWR VGND sky130_ef_sc_hd__decap_12
XFILLER_173_273 VGND VGND VPWR VPWR sky130_fd_sc_hd__decap_6
XFILLER_66_1602 VGND VGND VPWR VPWR sky130_fd_sc_hd__decap_3
XFILLER_216_1315 VGND VGND VPWR VPWR sky130_fd_sc_hd__fill_1
XFILLER_125_15 VPWR VGND VPWR VGND sky130_ef_sc_hd__decap_12
XTAP_TAPCELL_ROW_24_2_3136 VGND VPWR sky130_fd_sc_hd__tapvpwrvgnd_1
XFILLER_25_1310 VPWR VGND VPWR VGND sky130_ef_sc_hd__decap_12
XFILLER_214_1061 VPWR VGND VPWR VGND sky130_ef_sc_hd__decap_12
XTAP_TAPCELL_ROW_137_1_1291 VGND VPWR sky130_fd_sc_hd__tapvpwrvgnd_1
XFILLER_64_1370 VPWR VGND VPWR VGND sky130_ef_sc_hd__decap_12
XTAP_TAPCELL_ROW_4_913 VGND VPWR sky130_fd_sc_hd__tapvpwrvgnd_1
XTAP_TAPCELL_ROW_4_902 VGND VPWR sky130_fd_sc_hd__tapvpwrvgnd_1
XFILLER_29_1490 VGND VGND VPWR VPWR sky130_fd_sc_hd__decap_6
XFILLER_205_81 VPWR VGND VPWR VGND sky130_ef_sc_hd__decap_12
XTAP_TAPCELL_ROW_184_1975 VGND VPWR sky130_fd_sc_hd__tapvpwrvgnd_1
XFILLER_151_1384 VGND VGND VPWR VPWR sky130_fd_sc_hd__fill_1
XFILLER_116_1482 VPWR VGND VPWR VGND sky130_ef_sc_hd__decap_12
XFILLER_112_1302 VPWR VGND VPWR VGND sky130_ef_sc_hd__decap_12
XFILLER_99_1422 VPWR VGND VPWR VGND sky130_ef_sc_hd__decap_12
XFILLER_5_1437 VPWR VGND VPWR VGND sky130_ef_sc_hd__decap_12
XFILLER_25_1354 VPWR VGND VPWR VGND sky130_ef_sc_hd__decap_12
XTAP_TAPCELL_ROW_184_1997 VGND VPWR sky130_fd_sc_hd__tapvpwrvgnd_1
XTAP_TAPCELL_ROW_184_1986 VGND VPWR sky130_fd_sc_hd__tapvpwrvgnd_1
XFILLER_99_1466 VPWR VGND VPWR VGND sky130_ef_sc_hd__decap_12
XFILLER_25_1398 VPWR VGND VPWR VGND sky130_ef_sc_hd__decap_12
XFILLER_216_469 VGND VGND VPWR VPWR sky130_fd_sc_hd__decap_6
XFILLER_141_69 VPWR VGND VPWR VGND sky130_ef_sc_hd__decap_12
XPHY_EDGE_ROW_101_2_Left_533 VGND VGND VPWR VPWR sky130_fd_sc_hd__decap_3
XFILLER_197_833 VGND VGND VPWR VPWR sky130_fd_sc_hd__decap_6
XFILLER_197_877 VPWR VGND VPWR VGND sky130_ef_sc_hd__decap_12
XFILLER_196_321 VPWR VGND VPWR VGND sky130_ef_sc_hd__decap_12
XFILLER_180_1035 VGND VGND VPWR VPWR sky130_fd_sc_hd__fill_1
XTAP_TAPCELL_ROW_130_1_1278 VGND VPWR sky130_fd_sc_hd__tapvpwrvgnd_1
XFILLER_200_837 VPWR VGND VPWR VGND sky130_ef_sc_hd__decap_12
XFILLER_196_365 VPWR VGND VPWR VGND sky130_ef_sc_hd__decap_12
XFILLER_71_1330 VPWR VGND VPWR VGND sky130_ef_sc_hd__decap_12
XFILLER_32_1314 VPWR VGND VPWR VGND sky130_ef_sc_hd__decap_12
XFILLER_36_1450 VPWR VGND VPWR VGND sky130_ef_sc_hd__decap_12
XFILLER_165_741 VPWR VGND VPWR VGND sky130_ef_sc_hd__decap_12
XFILLER_126_3 VPWR VGND VPWR VGND sky130_ef_sc_hd__decap_12
XFILLER_123_1442 VPWR VGND VPWR VGND sky130_ef_sc_hd__decap_12
XFILLER_36_1494 VPWR VGND VPWR VGND sky130_ef_sc_hd__decap_12
Xclkload0 clknet_3_0_0_clk VGND VGND VPWR VPWR clkload0/Y sky130_fd_sc_hd__inv_6
XFILLER_164_251 VGND VGND VPWR VPWR sky130_fd_sc_hd__fill_1
XFILLER_32_1358 VPWR VGND VPWR VGND sky130_ef_sc_hd__decap_12
XFILLER_165_785 VPWR VGND VPWR VGND sky130_ef_sc_hd__decap_12
XFILLER_158_1538 VPWR VGND VPWR VGND sky130_ef_sc_hd__decap_12
XTAP_TAPCELL_ROW_121_2_3764 VGND VPWR sky130_fd_sc_hd__tapvpwrvgnd_1
XTAP_TAPCELL_ROW_9_1_1036 VGND VPWR sky130_fd_sc_hd__tapvpwrvgnd_1
XFILLER_50_77 VGND VGND VPWR VPWR sky130_fd_sc_hd__decap_6
XFILLER_180_755 VGND VGND VPWR VPWR sky130_fd_sc_hd__fill_1
XFILLER_166_77 VGND VGND VPWR VPWR sky130_fd_sc_hd__decap_6
XTAP_TAPCELL_ROW_88_2_3547 VGND VPWR sky130_fd_sc_hd__tapvpwrvgnd_1
XFILLER_191_1175 VGND VGND VPWR VPWR sky130_fd_sc_hd__fill_1
XFILLER_182_65 VPWR VGND VPWR VGND sky130_ef_sc_hd__decap_12
XFILLER_117_1268 VGND VGND VPWR VPWR sky130_fd_sc_hd__decap_4
XFILLER_82_1470 VPWR VGND VPWR VGND sky130_ef_sc_hd__decap_12
XFILLER_43_1410 VPWR VGND VPWR VGND sky130_ef_sc_hd__decap_12
XFILLER_47_1590 VPWR VGND VPWR VGND sky130_ef_sc_hd__decap_12
XFILLER_134_1582 VPWR VGND VPWR VGND sky130_ef_sc_hd__decap_12
XFILLER_115_81 VPWR VGND VPWR VGND sky130_ef_sc_hd__decap_12
XTAP_TAPCELL_ROW_68_2_3423 VGND VPWR sky130_fd_sc_hd__tapvpwrvgnd_1
XFILLER_43_1454 VPWR VGND VPWR VGND sky130_ef_sc_hd__decap_12
XFILLER_208_937 VPWR VGND VPWR VGND sky130_ef_sc_hd__decap_12
XFILLER_78_1506 VPWR VGND VPWR VGND sky130_ef_sc_hd__decap_12
XPHY_EDGE_ROW_33_2_Left_465 VGND VGND VPWR VPWR sky130_fd_sc_hd__decap_3
XFILLER_43_1498 VPWR VGND VPWR VGND sky130_ef_sc_hd__decap_12
XFILLER_46_121 VGND VGND VPWR VPWR sky130_fd_sc_hd__decap_6
XFILLER_207_447 VGND VGND VPWR VPWR sky130_fd_sc_hd__fill_1
XFILLER_130_1468 VGND VGND VPWR VPWR sky130_fd_sc_hd__fill_1
XFILLER_216_981 VPWR VGND VPWR VGND sky130_ef_sc_hd__decap_12
XPHY_EDGE_ROW_158_2_Left_590 VGND VGND VPWR VPWR sky130_fd_sc_hd__decap_3
XFILLER_61_113 VPWR VGND VPWR VGND sky130_ef_sc_hd__decap_12
XFILLER_201_39 VPWR VGND VPWR VGND sky130_ef_sc_hd__decap_12
XFILLER_188_811 VGND VGND VPWR VPWR sky130_fd_sc_hd__fill_1
XFILLER_91_51 VGND VGND VPWR VPWR sky130_fd_sc_hd__decap_4
XFILLER_206_1539 VGND VGND VPWR VPWR sky130_fd_sc_hd__fill_1
XFILLER_203_653 VPWR VGND VPWR VGND sky130_ef_sc_hd__decap_12
XTAP_TAPCELL_ROW_202_2492 VGND VPWR sky130_fd_sc_hd__tapvpwrvgnd_1
XFILLER_202_141 VPWR VGND VPWR VGND sky130_ef_sc_hd__decap_12
XFILLER_199_181 VPWR VGND VPWR VGND sky130_ef_sc_hd__decap_12
XFILLER_163_1233 VPWR VGND VPWR VGND sky130_ef_sc_hd__decap_12
XTAP_TAPCELL_ROW_17_2_3090 VGND VPWR sky130_fd_sc_hd__tapvpwrvgnd_1
XFILLER_203_697 VPWR VGND VPWR VGND sky130_ef_sc_hd__decap_12
XTAP_TAPCELL_ROW_194_2282 VGND VPWR sky130_fd_sc_hd__tapvpwrvgnd_1
XTAP_TAPCELL_ROW_194_2271 VGND VPWR sky130_fd_sc_hd__tapvpwrvgnd_1
XTAP_TAPCELL_ROW_194_2260 VGND VPWR sky130_fd_sc_hd__tapvpwrvgnd_1
XFILLER_175_505 VPWR VGND VPWR VGND sky130_ef_sc_hd__decap_12
XFILLER_54_1550 VPWR VGND VPWR VGND sky130_ef_sc_hd__decap_12
XFILLER_204_1241 VPWR VGND VPWR VGND sky130_ef_sc_hd__decap_12
XFILLER_200_1105 VPWR VGND VPWR VGND sky130_ef_sc_hd__decap_12
XFILLER_198_1329 VPWR VGND VPWR VGND sky130_ef_sc_hd__decap_12
XTAP_TAPCELL_ROW_190_2146 VGND VPWR sky130_fd_sc_hd__tapvpwrvgnd_1
XFILLER_89_1602 VGND VGND VPWR VPWR sky130_fd_sc_hd__decap_3
X_308_ net18 net142 net132 VGND VGND VPWR VPWR s_wdata\[15\] sky130_fd_sc_hd__a21o_1
XFILLER_15_1534 VPWR VGND VPWR VGND sky130_ef_sc_hd__decap_12
XFILLER_50_1414 VPWR VGND VPWR VGND sky130_ef_sc_hd__decap_12
XFILLER_54_1594 VGND VGND VPWR VPWR sky130_fd_sc_hd__decap_8
XFILLER_204_1285 VPWR VGND VPWR VGND sky130_ef_sc_hd__decap_12
XTAP_TAPCELL_ROW_190_2168 VGND VPWR sky130_fd_sc_hd__tapvpwrvgnd_1
XTAP_TAPCELL_ROW_190_2157 VGND VPWR sky130_fd_sc_hd__tapvpwrvgnd_1
XFILLER_102_1526 VPWR VGND VPWR VGND sky130_ef_sc_hd__decap_12
XANTENNA__443__A net147 VGND VGND VPWR VPWR sky130_fd_sc_hd__diode_2
XFILLER_15_1578 VPWR VGND VPWR VGND sky130_ef_sc_hd__decap_12
XTAP_TAPCELL_ROW_215_2875 VGND VPWR sky130_fd_sc_hd__tapvpwrvgnd_1
XTAP_TAPCELL_ROW_215_2864 VGND VPWR sky130_fd_sc_hd__tapvpwrvgnd_1
XFILLER_200_1149 VPWR VGND VPWR VGND sky130_ef_sc_hd__decap_12
XFILLER_170_221 VPWR VGND VPWR VGND sky130_ef_sc_hd__decap_12
XTAP_TAPCELL_ROW_10_2_3044 VGND VPWR sky130_fd_sc_hd__tapvpwrvgnd_1
XFILLER_171_777 VGND VGND VPWR VPWR sky130_fd_sc_hd__decap_6
XFILLER_170_265 VPWR VGND VPWR VGND sky130_ef_sc_hd__decap_12
XFILLER_100_1294 VGND VGND VPWR VPWR sky130_fd_sc_hd__decap_6
XFILLER_41_3 VPWR VGND VPWR VGND sky130_ef_sc_hd__decap_12
XTAP_TAPCELL_ROW_188_2097 VGND VPWR sky130_fd_sc_hd__tapvpwrvgnd_1
XTAP_TAPCELL_ROW_188_2086 VGND VPWR sky130_fd_sc_hd__tapvpwrvgnd_1
XFILLER_174_1373 VPWR VGND VPWR VGND sky130_ef_sc_hd__decap_12
XFILLER_83_1256 VPWR VGND VPWR VGND sky130_ef_sc_hd__decap_12
XFILLER_170_1259 VGND VGND VPWR VPWR sky130_fd_sc_hd__fill_1
XFILLER_61_1510 VPWR VGND VPWR VGND sky130_ef_sc_hd__decap_12
XFILLER_215_1381 VPWR VGND VPWR VGND sky130_ef_sc_hd__decap_12
XFILLER_211_1201 VPWR VGND VPWR VGND sky130_ef_sc_hd__decap_12
XFILLER_61_1554 VPWR VGND VPWR VGND sky130_ef_sc_hd__decap_12
XFILLER_211_1245 VPWR VGND VPWR VGND sky130_ef_sc_hd__decap_12
XFILLER_22_1538 VPWR VGND VPWR VGND sky130_ef_sc_hd__decap_12
XFILLER_211_1289 VPWR VGND VPWR VGND sky130_ef_sc_hd__decap_12
XFILLER_0_1301 VPWR VGND VPWR VGND sky130_ef_sc_hd__decap_12
XFILLER_213_417 VPWR VGND VPWR VGND sky130_ef_sc_hd__decap_12
XFILLER_0_1345 VPWR VGND VPWR VGND sky130_ef_sc_hd__decap_12
XFILLER_1_93 VPWR VGND VPWR VGND sky130_ef_sc_hd__decap_12
XFILLER_179_833 VGND VGND VPWR VPWR sky130_fd_sc_hd__decap_6
XFILLER_111_39 VPWR VGND VPWR VGND sky130_ef_sc_hd__decap_12
XFILLER_178_321 VPWR VGND VPWR VGND sky130_ef_sc_hd__decap_12
XFILLER_194_825 VPWR VGND VPWR VGND sky130_ef_sc_hd__decap_12
XFILLER_179_877 VPWR VGND VPWR VGND sky130_ef_sc_hd__decap_12
XFILLER_178_365 VPWR VGND VPWR VGND sky130_ef_sc_hd__decap_12
XTAP_TAPCELL_ROW_18_1_1053 VGND VPWR sky130_fd_sc_hd__tapvpwrvgnd_1
XFILLER_194_869 VPWR VGND VPWR VGND sky130_ef_sc_hd__decap_12
XFILLER_193_335 VGND VGND VPWR VPWR sky130_fd_sc_hd__fill_1
XFILLER_181_1399 VGND VGND VPWR VPWR sky130_fd_sc_hd__fill_1
XPHY_EDGE_ROW_55_2_Right_112 VGND VGND VPWR VPWR sky130_fd_sc_hd__decap_3
XTAP_TAPCELL_ROW_177_1790 VGND VPWR sky130_fd_sc_hd__tapvpwrvgnd_1
XANTENNA__525__B1 net138 VGND VGND VPWR VPWR sky130_fd_sc_hd__diode_2
XANTENNA__353__A net156 VGND VGND VPWR VPWR sky130_fd_sc_hd__diode_2
XTAP_TAPCELL_ROW_173_1676 VGND VPWR sky130_fd_sc_hd__tapvpwrvgnd_1
XTAP_TAPCELL_ROW_173_1665 VGND VPWR sky130_fd_sc_hd__tapvpwrvgnd_1
XTAP_TAPCELL_ROW_106_2_3666 VGND VPWR sky130_fd_sc_hd__tapvpwrvgnd_1
XFILLER_4_209 VPWR VGND VPWR VGND sky130_ef_sc_hd__decap_12
XTAP_TAPCELL_ROW_106_1_1229 VGND VPWR sky130_fd_sc_hd__tapvpwrvgnd_1
XPHY_EDGE_ROW_29_1_Left_248 VGND VGND VPWR VPWR sky130_fd_sc_hd__decap_3
XFILLER_96_29 VPWR VGND VPWR VGND sky130_ef_sc_hd__decap_12
XFILLER_1_949 VGND VGND VPWR VPWR sky130_fd_sc_hd__decap_3
XFILLER_0_426 VGND VGND VPWR VPWR sky130_fd_sc_hd__fill_1
XFILLER_0_459 VGND VGND VPWR VPWR sky130_fd_sc_hd__fill_1
XFILLER_29_34 VGND VGND VPWR VPWR sky130_fd_sc_hd__decap_4
XTAP_TAPCELL_ROW_54_2_3331 VGND VPWR sky130_fd_sc_hd__tapvpwrvgnd_1
XFILLER_188_1509 VPWR VGND VPWR VGND sky130_ef_sc_hd__decap_12
XTAP_TAPCELL_ROW_73_1_1163 VGND VPWR sky130_fd_sc_hd__tapvpwrvgnd_1
XFILLER_5_1201 VPWR VGND VPWR VGND sky130_ef_sc_hd__decap_12
XFILLER_29_78 VGND VGND VPWR VPWR sky130_fd_sc_hd__decap_6
XFILLER_5_1245 VPWR VGND VPWR VGND sky130_ef_sc_hd__decap_12
XFILLER_216_233 VPWR VGND VPWR VGND sky130_ef_sc_hd__decap_12
XPHY_EDGE_ROW_143_1_Left_362 VGND VGND VPWR VPWR sky130_fd_sc_hd__decap_3
XFILLER_99_1274 VPWR VGND VPWR VGND sky130_ef_sc_hd__decap_12
XFILLER_5_1289 VPWR VGND VPWR VGND sky130_ef_sc_hd__decap_12
X_590_ clknet_3_2_0_clk _024_ VGND VGND VPWR VPWR b_addr\[6\] sky130_fd_sc_hd__dfxtp_2
XFILLER_216_277 VPWR VGND VPWR VGND sky130_ef_sc_hd__decap_12
XFILLER_43_113 VPWR VGND VPWR VGND sky130_ef_sc_hd__decap_12
XFILLER_45_55 VGND VGND VPWR VPWR sky130_fd_sc_hd__fill_1
XFILLER_45_77 VGND VGND VPWR VPWR sky130_fd_sc_hd__fill_2
XFILLER_213_951 VGND VGND VPWR VPWR sky130_fd_sc_hd__fill_1
XFILLER_197_641 VPWR VGND VPWR VGND sky130_ef_sc_hd__decap_12
XFILLER_164_1553 VPWR VGND VPWR VGND sky130_ef_sc_hd__decap_12
XTAP_TAPCELL_ROW_161_1_1339 VGND VPWR sky130_fd_sc_hd__tapvpwrvgnd_1
XFILLER_200_601 VPWR VGND VPWR VGND sky130_ef_sc_hd__decap_12
XFILLER_197_685 VPWR VGND VPWR VGND sky130_ef_sc_hd__decap_12
XFILLER_164_1597 VGND VGND VPWR VPWR sky130_fd_sc_hd__decap_8
XFILLER_160_1406 VGND VGND VPWR VPWR sky130_fd_sc_hd__decap_6
XFILLER_205_1561 VGND VGND VPWR VPWR sky130_fd_sc_hd__decap_6
XFILLER_200_645 VPWR VGND VPWR VGND sky130_ef_sc_hd__decap_12
XFILLER_196_195 VGND VGND VPWR VPWR sky130_fd_sc_hd__fill_1
XFILLER_201_1425 VPWR VGND VPWR VGND sky130_ef_sc_hd__decap_12
XFILLER_184_357 VGND VGND VPWR VPWR sky130_fd_sc_hd__decap_6
XFILLER_123_1272 VGND VGND VPWR VPWR sky130_fd_sc_hd__fill_1
XFILLER_201_1469 VPWR VGND VPWR VGND sky130_ef_sc_hd__decap_12
XFILLER_158_1302 VPWR VGND VPWR VGND sky130_ef_sc_hd__decap_12
XFILLER_6_27 VGND VGND VPWR VPWR sky130_fd_sc_hd__fill_1
XFILLER_4_743 VGND VGND VPWR VPWR sky130_fd_sc_hd__fill_1
XFILLER_171_1513 VPWR VGND VPWR VGND sky130_ef_sc_hd__decap_12
XFILLER_212_1521 VPWR VGND VPWR VGND sky130_ef_sc_hd__decap_12
XFILLER_0_993 VPWR VGND VPWR VGND sky130_ef_sc_hd__decap_12
XTAP_TAPCELL_ROW_7_1004 VGND VPWR sky130_fd_sc_hd__tapvpwrvgnd_1
XTAP_TAPCELL_ROW_7_1015 VGND VPWR sky130_fd_sc_hd__tapvpwrvgnd_1
XFILLER_212_1565 VPWR VGND VPWR VGND sky130_ef_sc_hd__decap_12
XFILLER_208_701 VPWR VGND VPWR VGND sky130_ef_sc_hd__decap_12
XFILLER_130_1232 VPWR VGND VPWR VGND sky130_ef_sc_hd__decap_12
XPHY_EDGE_ROW_75_1_Left_294 VGND VGND VPWR VPWR sky130_fd_sc_hd__decap_3
XTAP_TAPCELL_ROW_7_1026 VGND VPWR sky130_fd_sc_hd__tapvpwrvgnd_1
XFILLER_212_27 VGND VGND VPWR VPWR sky130_fd_sc_hd__fill_1
XTAP_TAPCELL_ROW_204_2543 VGND VPWR sky130_fd_sc_hd__tapvpwrvgnd_1
XFILLER_78_1314 VPWR VGND VPWR VGND sky130_ef_sc_hd__decap_12
XTAP_TAPCELL_ROW_204_2565 VGND VPWR sky130_fd_sc_hd__tapvpwrvgnd_1
XTAP_TAPCELL_ROW_204_2554 VGND VPWR sky130_fd_sc_hd__tapvpwrvgnd_1
XTAP_TAPCELL_ROW_143_2_3907 VGND VPWR sky130_fd_sc_hd__tapvpwrvgnd_1
XFILLER_78_1358 VPWR VGND VPWR VGND sky130_ef_sc_hd__decap_12
XTAP_TAPCELL_ROW_200_2429 VGND VPWR sky130_fd_sc_hd__tapvpwrvgnd_1
XTAP_TAPCELL_ROW_196_2333 VGND VPWR sky130_fd_sc_hd__tapvpwrvgnd_1
XTAP_TAPCELL_ROW_196_2322 VGND VPWR sky130_fd_sc_hd__tapvpwrvgnd_1
XFILLER_204_973 VGND VGND VPWR VPWR sky130_fd_sc_hd__decap_6
XTAP_TAPCELL_ROW_98_1_1214 VGND VPWR sky130_fd_sc_hd__tapvpwrvgnd_1
XTAP_TAPCELL_ROW_217_2915 VGND VPWR sky130_fd_sc_hd__tapvpwrvgnd_1
XFILLER_203_461 VPWR VGND VPWR VGND sky130_ef_sc_hd__decap_12
XTAP_TAPCELL_ROW_192_2219 VGND VPWR sky130_fd_sc_hd__tapvpwrvgnd_1
XTAP_TAPCELL_ROW_192_2208 VGND VPWR sky130_fd_sc_hd__tapvpwrvgnd_1
XFILLER_176_825 VPWR VGND VPWR VGND sky130_ef_sc_hd__decap_12
XTAP_TAPCELL_ROW_217_2937 VGND VPWR sky130_fd_sc_hd__tapvpwrvgnd_1
XTAP_TAPCELL_ROW_217_2926 VGND VPWR sky130_fd_sc_hd__tapvpwrvgnd_1
XFILLER_175_335 VGND VGND VPWR VPWR sky130_fd_sc_hd__fill_1
XFILLER_89_3 VPWR VGND VPWR VGND sky130_ef_sc_hd__decap_12
XTAP_TAPCELL_ROW_80_2_3498 VGND VPWR sky130_fd_sc_hd__tapvpwrvgnd_1
XANTENNA_clkbuf_0_clk_A clk VGND VGND VPWR VPWR sky130_fd_sc_hd__diode_2
XFILLER_176_869 VPWR VGND VPWR VGND sky130_ef_sc_hd__decap_12
XFILLER_106_1470 VPWR VGND VPWR VGND sky130_ef_sc_hd__decap_12
XFILLER_89_1410 VPWR VGND VPWR VGND sky130_ef_sc_hd__decap_12
XANTENNA__507__B1 net135 VGND VGND VPWR VPWR sky130_fd_sc_hd__diode_2
XFILLER_15_1342 VPWR VGND VPWR VGND sky130_ef_sc_hd__decap_12
XFILLER_50_1244 VGND VGND VPWR VPWR sky130_fd_sc_hd__fill_1
XFILLER_204_1093 VPWR VGND VPWR VGND sky130_ef_sc_hd__decap_12
XFILLER_191_839 VGND VGND VPWR VPWR sky130_fd_sc_hd__fill_1
XFILLER_102_1356 VGND VGND VPWR VPWR sky130_fd_sc_hd__fill_1
XFILLER_89_1454 VPWR VGND VPWR VGND sky130_ef_sc_hd__decap_12
XFILLER_15_1386 VPWR VGND VPWR VGND sky130_ef_sc_hd__decap_12
XFILLER_171_541 VPWR VGND VPWR VGND sky130_ef_sc_hd__decap_12
XFILLER_89_1498 VPWR VGND VPWR VGND sky130_ef_sc_hd__decap_12
XFILLER_171_585 VPWR VGND VPWR VGND sky130_ef_sc_hd__decap_12
XTAP_TAPCELL_ROW_39_2_3233 VGND VPWR sky130_fd_sc_hd__tapvpwrvgnd_1
XFILLER_6_1521 VPWR VGND VPWR VGND sky130_ef_sc_hd__decap_12
XTAP_TAPCELL_ROW_181_1912 VGND VPWR sky130_fd_sc_hd__tapvpwrvgnd_1
XTAP_TAPCELL_ROW_181_1901 VGND VPWR sky130_fd_sc_hd__tapvpwrvgnd_1
XFILLER_6_1565 VPWR VGND VPWR VGND sky130_ef_sc_hd__decap_12
XFILLER_22_1302 VPWR VGND VPWR VGND sky130_ef_sc_hd__decap_12
XFILLER_26_1482 VPWR VGND VPWR VGND sky130_ef_sc_hd__decap_12
XFILLER_61_1384 VGND VGND VPWR VPWR sky130_fd_sc_hd__fill_1
XTAP_TAPCELL_ROW_166_1480 VGND VPWR sky130_fd_sc_hd__tapvpwrvgnd_1
XFILLER_122_27 VGND VGND VPWR VPWR sky130_fd_sc_hd__fill_1
XFILLER_96_1414 VPWR VGND VPWR VGND sky130_ef_sc_hd__decap_12
XFILLER_2_1429 VPWR VGND VPWR VGND sky130_ef_sc_hd__decap_12
XFILLER_148_1526 VPWR VGND VPWR VGND sky130_ef_sc_hd__decap_12
XFILLER_113_1496 VGND VGND VPWR VPWR sky130_fd_sc_hd__fill_1
XFILLER_25_124 VGND VGND VPWR VPWR sky130_fd_sc_hd__decap_3
XFILLER_214_737 VPWR VGND VPWR VGND sky130_ef_sc_hd__decap_12
XFILLER_213_225 VPWR VGND VPWR VGND sky130_ef_sc_hd__decap_12
XFILLER_179_641 VPWR VGND VPWR VGND sky130_ef_sc_hd__decap_12
XTAP_TAPCELL_ROW_179_1830 VGND VPWR sky130_fd_sc_hd__tapvpwrvgnd_1
XTAP_TAPCELL_ROW_179_1852 VGND VPWR sky130_fd_sc_hd__tapvpwrvgnd_1
XTAP_TAPCELL_ROW_179_1841 VGND VPWR sky130_fd_sc_hd__tapvpwrvgnd_1
XFILLER_179_685 VPWR VGND VPWR VGND sky130_ef_sc_hd__decap_12
XTAP_TAPCELL_ROW_175_1738 VGND VPWR sky130_fd_sc_hd__tapvpwrvgnd_1
XTAP_TAPCELL_ROW_175_1727 VGND VPWR sky130_fd_sc_hd__tapvpwrvgnd_1
XTAP_TAPCELL_ROW_175_1716 VGND VPWR sky130_fd_sc_hd__tapvpwrvgnd_1
XFILLER_146_1294 VGND VGND VPWR VPWR sky130_fd_sc_hd__decap_6
XFILLER_107_1256 VPWR VGND VPWR VGND sky130_ef_sc_hd__decap_12
XFILLER_178_195 VGND VGND VPWR VPWR sky130_fd_sc_hd__fill_1
XFILLER_166_357 VGND VGND VPWR VPWR sky130_fd_sc_hd__decap_6
XFILLER_120_1412 VGND VGND VPWR VPWR sky130_fd_sc_hd__fill_1
XFILLER_33_1442 VPWR VGND VPWR VGND sky130_ef_sc_hd__decap_12
XPHY_EDGE_ROW_56_2_Right_113 VGND VGND VPWR VPWR sky130_fd_sc_hd__decap_3
XFILLER_194_699 VGND VGND VPWR VPWR sky130_fd_sc_hd__fill_1
XFILLER_181_305 VPWR VGND VPWR VGND sky130_ef_sc_hd__decap_12
XFILLER_31_57 VPWR VGND VPWR VGND sky130_ef_sc_hd__decap_12
XFILLER_181_349 VPWR VGND VPWR VGND sky130_ef_sc_hd__decap_12
XFILLER_147_57 VPWR VGND VPWR VGND sky130_ef_sc_hd__decap_12
XFILLER_68_1538 VPWR VGND VPWR VGND sky130_ef_sc_hd__decap_12
XFILLER_218_1229 VPWR VGND VPWR VGND sky130_ef_sc_hd__decap_12
XFILLER_190_861 VGND VGND VPWR VPWR sky130_fd_sc_hd__decap_6
XPHY_EDGE_ROW_140_1_Right_726 VGND VGND VPWR VPWR sky130_fd_sc_hd__decap_3
XTAP_TAPCELL_ROW_136_2_3861 VGND VPWR sky130_fd_sc_hd__tapvpwrvgnd_1
XFILLER_1_724 VGND VGND VPWR VPWR sky130_fd_sc_hd__fill_2
Xoutput46 net46 VGND VGND VPWR VPWR bist_busy sky130_fd_sc_hd__buf_2
Xoutput57 net57 VGND VGND VPWR VPWR bist_fail_bits[0] sky130_fd_sc_hd__buf_2
Xoutput68 net68 VGND VGND VPWR VPWR bist_fail_bits[1] sky130_fd_sc_hd__buf_2
Xoutput79 net79 VGND VGND VPWR VPWR bist_fail_bits[2] sky130_fd_sc_hd__buf_2
XFILLER_193_3 VPWR VGND VPWR VGND sky130_ef_sc_hd__decap_12
XFILLER_1_779 VGND VGND VPWR VPWR sky130_fd_sc_hd__decap_4
XFILLER_7_1329 VPWR VGND VPWR VGND sky130_ef_sc_hd__decap_12
XFILLER_27_1268 VGND VGND VPWR VPWR sky130_fd_sc_hd__decap_4
XFILLER_188_1317 VPWR VGND VPWR VGND sky130_ef_sc_hd__decap_12
XFILLER_153_1298 VPWR VGND VPWR VGND sky130_ef_sc_hd__decap_12
XFILLER_44_1582 VPWR VGND VPWR VGND sky130_ef_sc_hd__decap_12
XFILLER_131_1552 VGND VGND VPWR VPWR sky130_fd_sc_hd__fill_1
XTAP_TAPCELL_ROW_128_2_3809 VGND VPWR sky130_fd_sc_hd__tapvpwrvgnd_1
XFILLER_56_65 VPWR VGND VPWR VGND sky130_ef_sc_hd__decap_12
XFILLER_217_553 VGND VGND VPWR VPWR sky130_fd_sc_hd__decap_6
XFILLER_16_102 VPWR VGND VPWR VGND sky130_ef_sc_hd__decap_12
XFILLER_40_1468 VGND VGND VPWR VPWR sky130_fd_sc_hd__fill_1
XFILLER_56_98 VPWR VGND VPWR VGND sky130_ef_sc_hd__decap_12
XFILLER_217_597 VPWR VGND VPWR VGND sky130_ef_sc_hd__decap_12
XFILLER_189_405 VPWR VGND VPWR VGND sky130_ef_sc_hd__decap_12
X_573_ clknet_3_1_0_clk _011_ VGND VGND VPWR VPWR u_ctrl.cmp_addr\[5\] sky130_fd_sc_hd__dfxtp_1
XFILLER_189_449 VPWR VGND VPWR VGND sky130_ef_sc_hd__decap_12
XFILLER_186_1085 VGND VGND VPWR VPWR sky130_fd_sc_hd__decap_6
XFILLER_72_53 VPWR VGND VPWR VGND sky130_ef_sc_hd__decap_12
XTAP_TAPCELL_ROW_0_790 VGND VPWR sky130_fd_sc_hd__tapvpwrvgnd_1
XFILLER_201_921 VPWR VGND VPWR VGND sky130_ef_sc_hd__decap_12
XFILLER_198_961 VPWR VGND VPWR VGND sky130_ef_sc_hd__decap_12
XFILLER_188_53 VPWR VGND VPWR VGND sky130_ef_sc_hd__decap_12
XFILLER_73_1244 VPWR VGND VPWR VGND sky130_ef_sc_hd__decap_12
XFILLER_201_965 VPWR VGND VPWR VGND sky130_ef_sc_hd__decap_12
XFILLER_199_1413 VPWR VGND VPWR VGND sky130_ef_sc_hd__decap_12
XFILLER_72_97 VPWR VGND VPWR VGND sky130_ef_sc_hd__decap_12
XFILLER_200_475 VGND VGND VPWR VPWR sky130_fd_sc_hd__fill_1
XFILLER_188_97 VPWR VGND VPWR VGND sky130_ef_sc_hd__decap_12
XFILLER_184_121 VPWR VGND VPWR VGND sky130_ef_sc_hd__decap_12
XFILLER_160_1258 VPWR VGND VPWR VGND sky130_ef_sc_hd__decap_12
XFILLER_125_1378 VGND VGND VPWR VPWR sky130_fd_sc_hd__decap_6
XFILLER_90_1580 VGND VGND VPWR VPWR sky130_fd_sc_hd__fill_1
XFILLER_201_1233 VPWR VGND VPWR VGND sky130_ef_sc_hd__decap_12
XFILLER_199_1457 VPWR VGND VPWR VGND sky130_ef_sc_hd__decap_12
XFILLER_184_165 VPWR VGND VPWR VGND sky130_ef_sc_hd__decap_12
XFILLER_173_839 VGND VGND VPWR VPWR sky130_fd_sc_hd__fill_1
XFILLER_12_1526 VPWR VGND VPWR VGND sky130_ef_sc_hd__decap_12
XFILLER_193_1001 VGND VGND VPWR VPWR sky130_fd_sc_hd__decap_6
XFILLER_207_27 VPWR VGND VPWR VGND sky130_ef_sc_hd__decap_12
XFILLER_193_1045 VPWR VGND VPWR VGND sky130_ef_sc_hd__decap_12
XTAP_TAPCELL_ROW_25_2_3141 VGND VPWR sky130_fd_sc_hd__tapvpwrvgnd_1
XTAP_TAPCELL_ROW_185_2012 VGND VPWR sky130_fd_sc_hd__tapvpwrvgnd_1
XTAP_TAPCELL_ROW_185_2001 VGND VPWR sky130_fd_sc_hd__tapvpwrvgnd_1
XANTENNA__440__B net91 VGND VGND VPWR VPWR sky130_fd_sc_hd__diode_2
XFILLER_10_1294 VGND VGND VPWR VPWR sky130_fd_sc_hd__decap_6
XFILLER_193_1089 VPWR VGND VPWR VGND sky130_ef_sc_hd__decap_12
XTAP_TAPCELL_ROW_185_2023 VGND VPWR sky130_fd_sc_hd__tapvpwrvgnd_1
XFILLER_171_1343 VGND VGND VPWR VPWR sky130_fd_sc_hd__fill_1
XTAP_TAPCELL_ROW_206_2616 VGND VPWR sky130_fd_sc_hd__tapvpwrvgnd_1
XTAP_TAPCELL_ROW_206_2605 VGND VPWR sky130_fd_sc_hd__tapvpwrvgnd_1
XFILLER_132_1338 VPWR VGND VPWR VGND sky130_ef_sc_hd__decap_12
XFILLER_0_790 VGND VGND VPWR VPWR sky130_fd_sc_hd__fill_1
XFILLER_212_1373 VPWR VGND VPWR VGND sky130_ef_sc_hd__decap_12
XFILLER_208_531 VGND VGND VPWR VPWR sky130_fd_sc_hd__fill_1
XFILLER_208_1409 VPWR VGND VPWR VGND sky130_ef_sc_hd__decap_12
XFILLER_211_729 VPWR VGND VPWR VGND sky130_ef_sc_hd__decap_12
XFILLER_204_781 VPWR VGND VPWR VGND sky130_ef_sc_hd__decap_12
XFILLER_165_1169 VGND VGND VPWR VPWR sky130_fd_sc_hd__decap_6
XFILLER_91_1322 VGND VGND VPWR VPWR sky130_fd_sc_hd__decap_6
XFILLER_182_1483 VGND VGND VPWR VPWR sky130_fd_sc_hd__fill_1
XFILLER_143_1434 VGND VGND VPWR VPWR sky130_fd_sc_hd__decap_6
XFILLER_91_1366 VPWR VGND VPWR VGND sky130_ef_sc_hd__decap_12
XTAP_TAPCELL_ROW_35_1_1088 VGND VPWR sky130_fd_sc_hd__tapvpwrvgnd_1
XFILLER_143_1478 VPWR VGND VPWR VGND sky130_ef_sc_hd__decap_12
XFILLER_176_699 VGND VGND VPWR VPWR sky130_fd_sc_hd__fill_1
XFILLER_163_305 VGND VGND VPWR VPWR sky130_fd_sc_hd__decap_3
XFILLER_163_349 VPWR VGND VPWR VGND sky130_ef_sc_hd__decap_12
XFILLER_172_861 VGND VGND VPWR VPWR sky130_fd_sc_hd__decap_6
XFILLER_117_27 VPWR VGND VPWR VGND sky130_ef_sc_hd__decap_12
XPHY_EDGE_ROW_110_2_Left_542 VGND VGND VPWR VPWR sky130_fd_sc_hd__decap_3
XFILLER_89_105 VGND VGND VPWR VPWR sky130_fd_sc_hd__decap_6
XFILLER_172_1129 VPWR VGND VPWR VGND sky130_ef_sc_hd__decap_12
XFILLER_171_393 VPWR VGND VPWR VGND sky130_ef_sc_hd__decap_12
XTAP_TAPCELL_ROW_168_1520 VGND VPWR sky130_fd_sc_hd__tapvpwrvgnd_1
XTAP_TAPCELL_ROW_168_1542 VGND VPWR sky130_fd_sc_hd__tapvpwrvgnd_1
XTAP_TAPCELL_ROW_168_1531 VGND VPWR sky130_fd_sc_hd__tapvpwrvgnd_1
XFILLER_154_1574 VGND VGND VPWR VPWR sky130_fd_sc_hd__decap_6
XPHY_EDGE_ROW_0_Left_220 VGND VGND VPWR VPWR sky130_fd_sc_hd__decap_3
XTAP_TAPCELL_ROW_164_1417 VGND VPWR sky130_fd_sc_hd__tapvpwrvgnd_1
XTAP_TAPCELL_ROW_164_1406 VGND VPWR sky130_fd_sc_hd__tapvpwrvgnd_1
XFILLER_150_1438 VPWR VGND VPWR VGND sky130_ef_sc_hd__decap_12
XFILLER_133_15 VPWR VGND VPWR VGND sky130_ef_sc_hd__decap_12
XTAP_TAPCELL_ROW_114_2_3717 VGND VPWR sky130_fd_sc_hd__tapvpwrvgnd_1
XTAP_TAPCELL_ROW_90_1_1198 VGND VPWR sky130_fd_sc_hd__tapvpwrvgnd_1
XTAP_TAPCELL_ROW_164_1428 VGND VPWR sky130_fd_sc_hd__tapvpwrvgnd_1
XFILLER_6_1373 VPWR VGND VPWR VGND sky130_ef_sc_hd__decap_12
XFILLER_214_501 VPWR VGND VPWR VGND sky130_ef_sc_hd__decap_12
XFILLER_213_81 VPWR VGND VPWR VGND sky130_ef_sc_hd__decap_12
XFILLER_96_1244 VGND VGND VPWR VPWR sky130_fd_sc_hd__fill_1
XFILLER_2_1259 VGND VGND VPWR VPWR sky130_fd_sc_hd__fill_1
XFILLER_214_545 VPWR VGND VPWR VGND sky130_ef_sc_hd__decap_12
XFILLER_187_909 VPWR VGND VPWR VGND sky130_ef_sc_hd__decap_12
XFILLER_183_1225 VGND VGND VPWR VPWR sky130_fd_sc_hd__decap_6
XFILLER_148_1356 VGND VGND VPWR VPWR sky130_fd_sc_hd__fill_1
XFILLER_214_589 VPWR VGND VPWR VGND sky130_ef_sc_hd__decap_12
XFILLER_201_217 VGND VGND VPWR VPWR sky130_fd_sc_hd__decap_6
XFILLER_186_419 VGND VGND VPWR VPWR sky130_fd_sc_hd__fill_1
XFILLER_183_1269 VPWR VGND VPWR VGND sky130_ef_sc_hd__decap_12
XFILLER_161_1534 VPWR VGND VPWR VGND sky130_ef_sc_hd__decap_12
XFILLER_70_1406 VGND VGND VPWR VPWR sky130_fd_sc_hd__decap_6
XFILLER_195_953 VPWR VGND VPWR VGND sky130_ef_sc_hd__decap_12
XFILLER_166_121 VPWR VGND VPWR VGND sky130_ef_sc_hd__decap_12
XFILLER_161_1578 VPWR VGND VPWR VGND sky130_ef_sc_hd__decap_12
XFILLER_122_1518 VGND VGND VPWR VPWR sky130_fd_sc_hd__decap_6
XFILLER_202_1553 VPWR VGND VPWR VGND sky130_ef_sc_hd__decap_12
XFILLER_182_625 VPWR VGND VPWR VGND sky130_ef_sc_hd__decap_12
XFILLER_166_165 VPWR VGND VPWR VGND sky130_ef_sc_hd__decap_12
XFILLER_120_1220 VPWR VGND VPWR VGND sky130_ef_sc_hd__decap_12
XFILLER_6_805 VGND VGND VPWR VPWR sky130_fd_sc_hd__decap_4
XFILLER_33_1272 VGND VGND VPWR VPWR sky130_fd_sc_hd__fill_1
XFILLER_181_113 VPWR VGND VPWR VGND sky130_ef_sc_hd__decap_12
XFILLER_177_1007 VGND VGND VPWR VPWR sky130_fd_sc_hd__fill_1
XFILLER_68_1302 VPWR VGND VPWR VGND sky130_ef_sc_hd__decap_12
XFILLER_5_337 VPWR VGND VPWR VGND sky130_ef_sc_hd__decap_12
XANTENNA__578__CLK clknet_3_0_0_clk VGND VGND VPWR VPWR sky130_fd_sc_hd__diode_2
XPHY_EDGE_ROW_42_2_Left_474 VGND VGND VPWR VPWR sky130_fd_sc_hd__decap_3
XPHY_EDGE_ROW_57_2_Right_114 VGND VGND VPWR VPWR sky130_fd_sc_hd__decap_3
XFILLER_206_3 VPWR VGND VPWR VGND sky130_ef_sc_hd__decap_12
XFILLER_202_1597 VGND VGND VPWR VPWR sky130_fd_sc_hd__decap_8
XFILLER_182_669 VPWR VGND VPWR VGND sky130_ef_sc_hd__decap_12
XANTENNA__541__A net135 VGND VGND VPWR VPWR sky130_fd_sc_hd__diode_2
XFILLER_218_1037 VPWR VGND VPWR VGND sky130_ef_sc_hd__decap_12
XFILLER_194_1365 VGND VGND VPWR VPWR sky130_fd_sc_hd__decap_6
XFILLER_159_1496 VGND VGND VPWR VPWR sky130_fd_sc_hd__fill_1
XFILLER_190_1229 VPWR VGND VPWR VGND sky130_ef_sc_hd__decap_12
XFILLER_174_77 VGND VGND VPWR VPWR sky130_fd_sc_hd__decap_6
XPHY_EDGE_ROW_141_1_Right_727 VGND VGND VPWR VPWR sky130_fd_sc_hd__decap_3
XFILLER_107_93 VPWR VGND VPWR VGND sky130_ef_sc_hd__decap_12
XFILLER_81_1546 VGND VGND VPWR VPWR sky130_fd_sc_hd__decap_6
XFILLER_3_39 VPWR VGND VPWR VGND sky130_ef_sc_hd__decap_12
XFILLER_209_317 VPWR VGND VPWR VGND sky130_ef_sc_hd__decap_12
XFILLER_190_65 VPWR VGND VPWR VGND sky130_ef_sc_hd__decap_12
XFILLER_188_1147 VGND VGND VPWR VPWR sky130_fd_sc_hd__fill_1
XFILLER_79_1442 VPWR VGND VPWR VGND sky130_ef_sc_hd__decap_12
XFILLER_40_1243 VGND VGND VPWR VPWR sky130_fd_sc_hd__fill_2
XFILLER_217_361 VPWR VGND VPWR VGND sky130_ef_sc_hd__decap_12
XFILLER_123_81 VPWR VGND VPWR VGND sky130_ef_sc_hd__decap_12
X_625_ clknet_3_1_0_clk _059_ VGND VGND VPWR VPWR net50 sky130_fd_sc_hd__dfxtp_1
XFILLER_75_1328 VGND VGND VPWR VPWR sky130_fd_sc_hd__fill_1
X_556_ net53 u_ctrl.cmp_addr\[4\] net122 VGND VGND VPWR VPWR _252_ sky130_fd_sc_hd__mux2_1
XPHY_EDGE_ROW_106_1_Left_325 VGND VGND VPWR VPWR sky130_fd_sc_hd__decap_3
XFILLER_189_279 VGND VGND VPWR VPWR sky130_fd_sc_hd__fill_1
X_487_ net149 _175_ net127 net135 _217_ VGND VGND VPWR VPWR _027_ sky130_fd_sc_hd__o311a_1
XFILLER_185_441 VGND VGND VPWR VPWR sky130_fd_sc_hd__decap_6
XTAP_TAPCELL_ROW_95_2_3595 VGND VPWR sky130_fd_sc_hd__tapvpwrvgnd_1
XFILLER_185_485 VPWR VGND VPWR VGND sky130_ef_sc_hd__decap_12
XTAP_TAPCELL_ROW_107_2_3671 VGND VPWR sky130_fd_sc_hd__tapvpwrvgnd_1
XFILLER_16_1470 VPWR VGND VPWR VGND sky130_ef_sc_hd__decap_12
XFILLER_218_15 VPWR VGND VPWR VGND sky130_ef_sc_hd__decap_12
XFILLER_201_1063 VGND VGND VPWR VPWR sky130_fd_sc_hd__fill_1
XFILLER_199_1287 VGND VGND VPWR VPWR sky130_fd_sc_hd__fill_1
XFILLER_103_1440 VGND VGND VPWR VPWR sky130_fd_sc_hd__fill_1
XANTENNA__451__A net147 VGND VGND VPWR VPWR sky130_fd_sc_hd__diode_2
XFILLER_12_1356 VGND VGND VPWR VPWR sky130_fd_sc_hd__fill_1
XFILLER_86_1468 VGND VGND VPWR VPWR sky130_fd_sc_hd__fill_1
XFILLER_5_893 VGND VGND VPWR VPWR sky130_fd_sc_hd__decap_3
XFILLER_173_1449 VGND VGND VPWR VPWR sky130_fd_sc_hd__decap_6
XTAP_TAPCELL_ROW_100_2_3625 VGND VPWR sky130_fd_sc_hd__tapvpwrvgnd_1
XFILLER_136_1282 VPWR VGND VPWR VGND sky130_ef_sc_hd__decap_12
XFILLER_3_1513 VPWR VGND VPWR VGND sky130_ef_sc_hd__decap_12
XFILLER_114_1580 VGND VGND VPWR VPWR sky130_fd_sc_hd__fill_1
XFILLER_209_895 VGND VGND VPWR VPWR sky130_fd_sc_hd__fill_1
XFILLER_23_1496 VGND VGND VPWR VPWR sky130_fd_sc_hd__fill_1
XFILLER_58_1526 VPWR VGND VPWR VGND sky130_ef_sc_hd__decap_12
XFILLER_208_1217 VPWR VGND VPWR VGND sky130_ef_sc_hd__decap_12
XPHY_EDGE_ROW_38_1_Left_257 VGND VGND VPWR VPWR sky130_fd_sc_hd__decap_3
XFILLER_184_1589 VGND VGND VPWR VPWR sky130_fd_sc_hd__decap_6
XFILLER_180_1409 VPWR VGND VPWR VGND sky130_ef_sc_hd__decap_12
XFILLER_169_909 VPWR VGND VPWR VGND sky130_ef_sc_hd__decap_12
XFILLER_1_1281 VGND VGND VPWR VPWR sky130_fd_sc_hd__decap_6
XFILLER_211_559 VGND VGND VPWR VPWR sky130_fd_sc_hd__fill_1
XFILLER_195_205 VPWR VGND VPWR VGND sky130_ef_sc_hd__decap_12
XFILLER_168_419 VGND VGND VPWR VPWR sky130_fd_sc_hd__fill_1
XFILLER_143_1220 VPWR VGND VPWR VGND sky130_ef_sc_hd__decap_12
XTAP_TAPCELL_ROW_66_1_1149 VGND VPWR sky130_fd_sc_hd__tapvpwrvgnd_1
XANTENNA_fanout146_A net148 VGND VGND VPWR VPWR sky130_fd_sc_hd__diode_2
XFILLER_195_249 VPWR VGND VPWR VGND sky130_ef_sc_hd__decap_12
XFILLER_177_953 VPWR VGND VPWR VGND sky130_ef_sc_hd__decap_12
XFILLER_148_121 VGND VGND VPWR VPWR sky130_fd_sc_hd__decap_6
XFILLER_17_1256 VPWR VGND VPWR VGND sky130_ef_sc_hd__decap_12
XFILLER_56_1294 VGND VGND VPWR VPWR sky130_fd_sc_hd__decap_6
XFILLER_192_923 VGND VGND VPWR VPWR sky130_fd_sc_hd__fill_1
XFILLER_164_625 VPWR VGND VPWR VGND sky130_ef_sc_hd__decap_12
XFILLER_143_1286 VPWR VGND VPWR VGND sky130_ef_sc_hd__decap_12
XFILLER_163_113 VPWR VGND VPWR VGND sky130_ef_sc_hd__decap_12
XFILLER_128_15 VPWR VGND VPWR VGND sky130_ef_sc_hd__decap_12
XFILLER_12_37 VGND VGND VPWR VPWR sky130_fd_sc_hd__fill_1
XFILLER_12_59 VPWR VGND VPWR VGND sky130_ef_sc_hd__decap_12
XFILLER_30_1412 VGND VGND VPWR VPWR sky130_fd_sc_hd__fill_1
XFILLER_219_1313 VGND VGND VPWR VPWR sky130_fd_sc_hd__decap_3
XFILLER_164_669 VPWR VGND VPWR VGND sky130_ef_sc_hd__decap_12
XFILLER_191_1505 VGND VGND VPWR VPWR sky130_fd_sc_hd__decap_6
XPHY_EDGE_ROW_152_1_Left_371 VGND VGND VPWR VPWR sky130_fd_sc_hd__decap_3
XFILLER_2_329 VGND VGND VPWR VPWR sky130_fd_sc_hd__fill_1
XFILLER_219_1357 VPWR VGND VPWR VGND sky130_ef_sc_hd__decap_12
XFILLER_191_1549 VPWR VGND VPWR VGND sky130_ef_sc_hd__decap_12
XFILLER_176_1073 VPWR VGND VPWR VGND sky130_ef_sc_hd__decap_12
XFILLER_63_1232 VPWR VGND VPWR VGND sky130_ef_sc_hd__decap_12
XFILLER_189_1401 VPWR VGND VPWR VGND sky130_ef_sc_hd__decap_12
XFILLER_154_1382 VPWR VGND VPWR VGND sky130_ef_sc_hd__decap_12
XFILLER_115_1322 VGND VGND VPWR VPWR sky130_fd_sc_hd__decap_6
XANTENNA_clkbuf_3_6_0_clk_A clknet_0_clk VGND VGND VPWR VPWR sky130_fd_sc_hd__diode_2
XFILLER_8_1468 VGND VGND VPWR VPWR sky130_fd_sc_hd__fill_1
XFILLER_150_1246 VPWR VGND VPWR VGND sky130_ef_sc_hd__decap_12
XFILLER_115_1366 VPWR VGND VPWR VGND sky130_ef_sc_hd__decap_12
XFILLER_63_1298 VPWR VGND VPWR VGND sky130_ef_sc_hd__decap_12
XFILLER_206_309 VPWR VGND VPWR VGND sky130_ef_sc_hd__decap_12
XTAP_TAPCELL_ROW_2_841 VGND VPWR sky130_fd_sc_hd__tapvpwrvgnd_1
XFILLER_41_1552 VGND VGND VPWR VPWR sky130_fd_sc_hd__fill_1
XFILLER_215_821 VPWR VGND VPWR VGND sky130_ef_sc_hd__decap_12
XTAP_TAPCELL_ROW_144_2_3912 VGND VPWR sky130_fd_sc_hd__tapvpwrvgnd_1
XTAP_TAPCELL_ROW_2_863 VGND VPWR sky130_fd_sc_hd__tapvpwrvgnd_1
XTAP_TAPCELL_ROW_2_852 VGND VPWR sky130_fd_sc_hd__tapvpwrvgnd_1
XFILLER_215_865 VPWR VGND VPWR VGND sky130_ef_sc_hd__decap_12
X_410_ _144_ _145_ VGND VGND VPWR VPWR _146_ sky130_fd_sc_hd__or2_1
XFILLER_183_1033 VPWR VGND VPWR VGND sky130_ef_sc_hd__decap_12
XFILLER_156_3 VPWR VGND VPWR VGND sky130_ef_sc_hd__decap_12
X_341_ net157 _091_ VGND VGND VPWR VPWR _007_ sky130_fd_sc_hd__and2_1
XFILLER_183_1077 VPWR VGND VPWR VGND sky130_ef_sc_hd__decap_12
XTAP_TAPCELL_ROW_113_1_1244 VGND VPWR sky130_fd_sc_hd__tapvpwrvgnd_1
XFILLER_74_1350 VGND VGND VPWR VPWR sky130_fd_sc_hd__decap_6
XFILLER_53_55 VGND VGND VPWR VPWR sky130_fd_sc_hd__fill_1
XFILLER_169_55 VGND VGND VPWR VPWR sky130_fd_sc_hd__fill_1
XFILLER_167_441 VGND VGND VPWR VPWR sky130_fd_sc_hd__decap_6
XFILLER_161_1342 VPWR VGND VPWR VGND sky130_ef_sc_hd__decap_12
XFILLER_126_1462 VGND VGND VPWR VPWR sky130_fd_sc_hd__decap_6
XFILLER_74_1394 VPWR VGND VPWR VGND sky130_ef_sc_hd__decap_12
X_272_ u_ctrl.elem_idx\[0\] VGND VGND VPWR VPWR _071_ sky130_fd_sc_hd__inv_2
XFILLER_210_581 VGND VGND VPWR VPWR sky130_fd_sc_hd__decap_6
XFILLER_195_783 VGND VGND VPWR VPWR sky130_fd_sc_hd__fill_1
XFILLER_161_1386 VPWR VGND VPWR VGND sky130_ef_sc_hd__decap_12
XFILLER_122_1326 VPWR VGND VPWR VGND sky130_ef_sc_hd__decap_12
XFILLER_70_1258 VPWR VGND VPWR VGND sky130_ef_sc_hd__decap_12
XFILLER_35_1378 VGND VGND VPWR VPWR sky130_fd_sc_hd__decap_6
XFILLER_196_1427 VGND VGND VPWR VPWR sky130_fd_sc_hd__fill_1
XFILLER_183_945 VGND VGND VPWR VPWR sky130_fd_sc_hd__decap_6
XFILLER_182_433 VPWR VGND VPWR VGND sky130_ef_sc_hd__decap_12
XFILLER_167_485 VPWR VGND VPWR VGND sky130_ef_sc_hd__decap_12
XFILLER_100_1602 VGND VGND VPWR VPWR sky130_fd_sc_hd__decap_3
XFILLER_183_989 VPWR VGND VPWR VGND sky130_ef_sc_hd__decap_12
XFILLER_182_477 VPWR VGND VPWR VGND sky130_ef_sc_hd__decap_12
XFILLER_6_657 VPWR VGND VPWR VGND sky130_ef_sc_hd__decap_12
XPHY_EDGE_ROW_58_2_Right_115 VGND VGND VPWR VPWR sky130_fd_sc_hd__decap_3
XFILLER_5_167 VGND VGND VPWR VPWR sky130_fd_sc_hd__fill_1
XANTENNA__340__A1 b_addr\[1\] VGND VGND VPWR VPWR sky130_fd_sc_hd__diode_2
XFILLER_194_1173 VPWR VGND VPWR VGND sky130_ef_sc_hd__decap_12
XFILLER_78_41 VPWR VGND VPWR VGND sky130_ef_sc_hd__decap_12
XFILLER_190_1037 VPWR VGND VPWR VGND sky130_ef_sc_hd__decap_12
XPHY_EDGE_ROW_142_1_Right_728 VGND VGND VPWR VPWR sky130_fd_sc_hd__decap_3
XFILLER_85_1490 VGND VGND VPWR VPWR sky130_fd_sc_hd__decap_6
XFILLER_81_1310 VPWR VGND VPWR VGND sky130_ef_sc_hd__decap_12
XFILLER_78_85 VPWR VGND VPWR VGND sky130_ef_sc_hd__decap_12
XFILLER_1_351 VGND VGND VPWR VPWR sky130_fd_sc_hd__fill_1
XFILLER_133_1422 VPWR VGND VPWR VGND sky130_ef_sc_hd__decap_12
XFILLER_81_1354 VPWR VGND VPWR VGND sky130_ef_sc_hd__decap_12
XFILLER_209_125 VPWR VGND VPWR VGND sky130_ef_sc_hd__decap_12
XFILLER_133_1466 VPWR VGND VPWR VGND sky130_ef_sc_hd__decap_12
XFILLER_81_1398 VPWR VGND VPWR VGND sky130_ef_sc_hd__decap_12
XFILLER_42_1338 VPWR VGND VPWR VGND sky130_ef_sc_hd__decap_12
XFILLER_209_169 VPWR VGND VPWR VGND sky130_ef_sc_hd__decap_12
XFILLER_91_111 VGND VGND VPWR VPWR sky130_fd_sc_hd__fill_1
XFILLER_218_681 VPWR VGND VPWR VGND sky130_ef_sc_hd__decap_12
XFILLER_79_1272 VGND VGND VPWR VPWR sky130_fd_sc_hd__fill_1
X_608_ clknet_3_6_0_clk _042_ VGND VGND VPWR VPWR net64 sky130_fd_sc_hd__dfxtp_1
XFILLER_209_1537 VPWR VGND VPWR VGND sky130_ef_sc_hd__decap_12
XFILLER_166_1253 VGND VGND VPWR VPWR sky130_fd_sc_hd__decap_6
XANTENNA__446__A net147 VGND VGND VPWR VPWR sky130_fd_sc_hd__diode_2
XFILLER_177_205 VPWR VGND VPWR VGND sky130_ef_sc_hd__decap_12
XFILLER_166_1297 VPWR VGND VPWR VGND sky130_ef_sc_hd__decap_12
XFILLER_92_1450 VPWR VGND VPWR VGND sky130_ef_sc_hd__decap_12
X_539_ net151 _196_ net129 net139 _243_ VGND VGND VPWR VPWR _053_ sky130_fd_sc_hd__o311a_1
XFILLER_193_709 VPWR VGND VPWR VGND sky130_ef_sc_hd__decap_12
XFILLER_177_249 VPWR VGND VPWR VGND sky130_ef_sc_hd__decap_12
XFILLER_144_1562 VPWR VGND VPWR VGND sky130_ef_sc_hd__decap_12
XFILLER_92_1494 VPWR VGND VPWR VGND sky130_ef_sc_hd__decap_12
XFILLER_53_1434 VGND VGND VPWR VPWR sky130_fd_sc_hd__decap_6
XFILLER_174_923 VGND VGND VPWR VPWR sky130_fd_sc_hd__fill_1
XFILLER_140_1426 VPWR VGND VPWR VGND sky130_ef_sc_hd__decap_12
XFILLER_105_1546 VGND VGND VPWR VPWR sky130_fd_sc_hd__decap_6
XFILLER_53_1478 VPWR VGND VPWR VGND sky130_ef_sc_hd__decap_12
XFILLER_203_1169 VGND VGND VPWR VPWR sky130_fd_sc_hd__decap_6
XFILLER_185_293 VPWR VGND VPWR VGND sky130_ef_sc_hd__decap_12
XFILLER_145_113 VPWR VGND VPWR VGND sky130_ef_sc_hd__decap_12
XFILLER_71_3 VPWR VGND VPWR VGND sky130_ef_sc_hd__decap_12
XFILLER_138_1300 VGND VGND VPWR VPWR sky130_fd_sc_hd__fill_1
XFILLER_86_1232 VPWR VGND VPWR VGND sky130_ef_sc_hd__decap_12
XPHY_EDGE_ROW_206_Left_425 VGND VGND VPWR VPWR sky130_fd_sc_hd__decap_3
XFILLER_177_1393 VGND VGND VPWR VPWR sky130_fd_sc_hd__decap_6
XFILLER_173_1213 VPWR VGND VPWR VGND sky130_ef_sc_hd__decap_12
XFILLER_5_690 VGND VGND VPWR VPWR sky130_fd_sc_hd__decap_4
XFILLER_173_1257 VPWR VGND VPWR VGND sky130_ef_sc_hd__decap_12
XTAP_TAPCELL_ROW_149_2_3949 VGND VPWR sky130_fd_sc_hd__tapvpwrvgnd_1
XTAP_TAPCELL_ROW_150_2_3955 VGND VPWR sky130_fd_sc_hd__tapvpwrvgnd_1
XFILLER_151_1522 VPWR VGND VPWR VGND sky130_ef_sc_hd__decap_12
XFILLER_64_1574 VGND VGND VPWR VPWR sky130_fd_sc_hd__decap_6
XFILLER_151_1566 VPWR VGND VPWR VGND sky130_ef_sc_hd__decap_12
XFILLER_112_1506 VPWR VGND VPWR VGND sky130_ef_sc_hd__decap_12
XFILLER_60_1438 VPWR VGND VPWR VGND sky130_ef_sc_hd__decap_12
XFILLER_210_1129 VPWR VGND VPWR VGND sky130_ef_sc_hd__decap_12
XTAP_TAPCELL_ROW_129_2_3814 VGND VPWR sky130_fd_sc_hd__tapvpwrvgnd_1
XTAP_TAPCELL_ROW_130_2_3820 VGND VPWR sky130_fd_sc_hd__tapvpwrvgnd_1
XFILLER_3_1343 VGND VGND VPWR VPWR sky130_fd_sc_hd__fill_1
XFILLER_149_1440 VGND VGND VPWR VPWR sky130_fd_sc_hd__fill_1
XFILLER_130_27 VGND VGND VPWR VPWR sky130_fd_sc_hd__fill_1
XPHY_EDGE_ROW_215_Left_434 VGND VGND VPWR VPWR sky130_fd_sc_hd__decap_3
XFILLER_212_813 VPWR VGND VPWR VGND sky130_ef_sc_hd__decap_12
XFILLER_184_1353 VPWR VGND VPWR VGND sky130_ef_sc_hd__decap_12
XFILLER_58_1356 VGND VGND VPWR VPWR sky130_fd_sc_hd__fill_1
XFILLER_196_525 VGND VGND VPWR VPWR sky130_fd_sc_hd__decap_6
XFILLER_184_1397 VPWR VGND VPWR VGND sky130_ef_sc_hd__decap_12
XFILLER_180_1217 VPWR VGND VPWR VGND sky130_ef_sc_hd__decap_12
XFILLER_196_569 VPWR VGND VPWR VGND sky130_ef_sc_hd__decap_12
XFILLER_123_1602 VGND VGND VPWR VPWR sky130_fd_sc_hd__decap_3
XFILLER_71_1534 VPWR VGND VPWR VGND sky130_ef_sc_hd__decap_12
XANTENNA_fanout149_X net149 VGND VGND VPWR VPWR sky130_fd_sc_hd__diode_2
XFILLER_177_783 VGND VGND VPWR VPWR sky130_fd_sc_hd__fill_1
XFILLER_71_1578 VPWR VGND VPWR VGND sky130_ef_sc_hd__decap_12
XFILLER_32_1518 VGND VGND VPWR VPWR sky130_fd_sc_hd__decap_6
XFILLER_165_945 VGND VGND VPWR VPWR sky130_fd_sc_hd__decap_6
XFILLER_164_433 VPWR VGND VPWR VGND sky130_ef_sc_hd__decap_12
XFILLER_139_69 VPWR VGND VPWR VGND sky130_ef_sc_hd__decap_12
XFILLER_30_1220 VPWR VGND VPWR VGND sky130_ef_sc_hd__decap_12
XFILLER_165_989 VPWR VGND VPWR VGND sky130_ef_sc_hd__decap_12
XFILLER_219_1121 VPWR VGND VPWR VGND sky130_ef_sc_hd__decap_12
XFILLER_180_937 VPWR VGND VPWR VGND sky130_ef_sc_hd__decap_12
XFILLER_164_477 VPWR VGND VPWR VGND sky130_ef_sc_hd__decap_12
XFILLER_151_105 VGND VGND VPWR VPWR sky130_fd_sc_hd__decap_6
XFILLER_195_1493 VPWR VGND VPWR VGND sky130_ef_sc_hd__decap_12
XFILLER_191_1313 VPWR VGND VPWR VGND sky130_ef_sc_hd__decap_12
XFILLER_155_57 VPWR VGND VPWR VGND sky130_ef_sc_hd__decap_12
XFILLER_69_1496 VGND VGND VPWR VPWR sky130_fd_sc_hd__fill_1
XFILLER_215_1007 VGND VGND VPWR VPWR sky130_fd_sc_hd__fill_1
XFILLER_191_1357 VPWR VGND VPWR VGND sky130_ef_sc_hd__decap_12
XANTENNA__616__CLK clknet_3_6_0_clk VGND VGND VPWR VPWR sky130_fd_sc_hd__diode_2
XFILLER_8_1232 VPWR VGND VPWR VGND sky130_ef_sc_hd__decap_12
XTAP_TAPCELL_ROW_7_988 VGND VPWR sky130_fd_sc_hd__tapvpwrvgnd_1
XTAP_TAPCELL_ROW_7_999 VGND VPWR sky130_fd_sc_hd__tapvpwrvgnd_1
XFILLER_219_445 VGND VGND VPWR VPWR sky130_fd_sc_hd__decap_3
XFILLER_189_1231 VGND VGND VPWR VPWR sky130_fd_sc_hd__fill_1
XFILLER_4_1129 VPWR VGND VPWR VGND sky130_ef_sc_hd__decap_12
XFILLER_219_489 VPWR VGND VPWR VGND sky130_ef_sc_hd__decap_12
XFILLER_207_629 VPWR VGND VPWR VGND sky130_ef_sc_hd__decap_12
XFILLER_73_111 VGND VGND VPWR VPWR sky130_fd_sc_hd__fill_1
XFILLER_0_29 VGND VGND VPWR VPWR sky130_fd_sc_hd__decap_8
XFILLER_206_139 VGND VGND VPWR VPWR sky130_fd_sc_hd__fill_1
XFILLER_104_83 VGND VGND VPWR VPWR sky130_fd_sc_hd__fill_1
XFILLER_76_1412 VGND VGND VPWR VPWR sky130_fd_sc_hd__fill_1
XFILLER_215_673 VPWR VGND VPWR VGND sky130_ef_sc_hd__decap_12
XFILLER_128_1524 VGND VGND VPWR VPWR sky130_fd_sc_hd__fill_1
XFILLER_64_65 VPWR VGND VPWR VGND sky130_ef_sc_hd__decap_12
XFILLER_202_301 VGND VGND VPWR VPWR sky130_fd_sc_hd__decap_6
XFILLER_199_385 VGND VGND VPWR VPWR sky130_fd_sc_hd__decap_6
XFILLER_187_503 VGND VGND VPWR VPWR sky130_fd_sc_hd__fill_1
XTAP_TAPCELL_ROW_144_1_1305 VGND VPWR sky130_fd_sc_hd__tapvpwrvgnd_1
XFILLER_9_27 VPWR VGND VPWR VGND sky130_ef_sc_hd__decap_12
XFILLER_202_345 VPWR VGND VPWR VGND sky130_ef_sc_hd__decap_12
XFILLER_175_709 VPWR VGND VPWR VGND sky130_ef_sc_hd__decap_12
X_324_ net36 net144 net134 VGND VGND VPWR VPWR s_wdata\[31\] sky130_fd_sc_hd__a21o_1
XFILLER_202_389 VPWR VGND VPWR VGND sky130_ef_sc_hd__decap_12
XFILLER_126_1270 VPWR VGND VPWR VGND sky130_ef_sc_hd__decap_12
XFILLER_80_53 VPWR VGND VPWR VGND sky130_ef_sc_hd__decap_12
XFILLER_200_1309 VGND VGND VPWR VPWR sky130_fd_sc_hd__decap_6
XFILLER_196_53 VPWR VGND VPWR VGND sky130_ef_sc_hd__decap_12
XFILLER_127_113 VPWR VGND VPWR VGND sky130_ef_sc_hd__decap_12
XFILLER_80_97 VPWR VGND VPWR VGND sky130_ef_sc_hd__decap_12
XFILLER_196_97 VPWR VGND VPWR VGND sky130_ef_sc_hd__decap_12
XFILLER_183_753 VPWR VGND VPWR VGND sky130_ef_sc_hd__decap_12
XFILLER_167_293 VPWR VGND VPWR VGND sky130_ef_sc_hd__decap_12
XFILLER_6_421 VPWR VGND VPWR VGND sky130_ef_sc_hd__decap_12
XFILLER_7_977 VGND VGND VPWR VPWR sky130_fd_sc_hd__decap_3
XFILLER_13_1440 VGND VGND VPWR VPWR sky130_fd_sc_hd__fill_1
XFILLER_183_797 VPWR VGND VPWR VGND sky130_ef_sc_hd__decap_12
XFILLER_89_51 VGND VGND VPWR VPWR sky130_fd_sc_hd__decap_4
XFILLER_87_1552 VGND VGND VPWR VPWR sky130_fd_sc_hd__fill_1
XFILLER_50_8 VPWR VGND VPWR VGND sky130_ef_sc_hd__decap_12
XFILLER_174_1533 VGND VGND VPWR VPWR sky130_fd_sc_hd__decap_6
XTAP_TAPCELL_ROW_135_2_3857 VGND VPWR sky130_fd_sc_hd__tapvpwrvgnd_1
XPHY_EDGE_ROW_59_2_Right_116 VGND VGND VPWR VPWR sky130_fd_sc_hd__decap_3
XFILLER_174_1577 VPWR VGND VPWR VGND sky130_ef_sc_hd__decap_12
XFILLER_170_469 VGND VGND VPWR VPWR sky130_fd_sc_hd__decap_6
XFILLER_215_27 VPWR VGND VPWR VGND sky130_ef_sc_hd__decap_12
XPHY_EDGE_ROW_143_1_Right_729 VGND VGND VPWR VPWR sky130_fd_sc_hd__decap_3
XFILLER_46_1282 VPWR VGND VPWR VGND sky130_ef_sc_hd__decap_12
XFILLER_211_1449 VGND VGND VPWR VPWR sky130_fd_sc_hd__decap_6
XFILLER_133_1274 VPWR VGND VPWR VGND sky130_ef_sc_hd__decap_12
XFILLER_168_1315 VGND VGND VPWR VPWR sky130_fd_sc_hd__fill_1
XFILLER_24_1580 VGND VGND VPWR VPWR sky130_fd_sc_hd__fill_1
XFILLER_209_1301 VPWR VGND VPWR VGND sky130_ef_sc_hd__decap_12
XFILLER_212_109 VPWR VGND VPWR VGND sky130_ef_sc_hd__decap_12
XFILLER_146_1602 VGND VGND VPWR VPWR sky130_fd_sc_hd__decap_3
XFILLER_209_1345 VPWR VGND VPWR VGND sky130_ef_sc_hd__decap_12
XFILLER_205_161 VGND VGND VPWR VPWR sky130_fd_sc_hd__decap_6
XFILLER_181_1537 VPWR VGND VPWR VGND sky130_ef_sc_hd__decap_12
XFILLER_178_525 VGND VGND VPWR VPWR sky130_fd_sc_hd__decap_6
XFILLER_166_1061 VPWR VGND VPWR VGND sky130_ef_sc_hd__decap_12
XFILLER_53_1220 VPWR VGND VPWR VGND sky130_ef_sc_hd__decap_12
XFILLER_193_517 VPWR VGND VPWR VGND sky130_ef_sc_hd__decap_12
XFILLER_178_569 VPWR VGND VPWR VGND sky130_ef_sc_hd__decap_12
XFILLER_144_1370 VPWR VGND VPWR VGND sky130_ef_sc_hd__decap_12
XFILLER_109_1490 VGND VGND VPWR VPWR sky130_fd_sc_hd__decap_6
XFILLER_105_1310 VPWR VGND VPWR VGND sky130_ef_sc_hd__decap_12
XFILLER_105_1354 VPWR VGND VPWR VGND sky130_ef_sc_hd__decap_12
XTAP_TAPCELL_ROW_8_2_3030 VGND VPWR sky130_fd_sc_hd__tapvpwrvgnd_1
XFILLER_53_1286 VPWR VGND VPWR VGND sky130_ef_sc_hd__decap_12
XFILLER_179_1455 VGND VGND VPWR VPWR sky130_fd_sc_hd__fill_1
XFILLER_105_1398 VPWR VGND VPWR VGND sky130_ef_sc_hd__decap_12
XFILLER_88_1338 VPWR VGND VPWR VGND sky130_ef_sc_hd__decap_12
XFILLER_133_105 VGND VGND VPWR VPWR sky130_fd_sc_hd__decap_6
XFILLER_109_39 VPWR VGND VPWR VGND sky130_ef_sc_hd__decap_12
XFILLER_173_1021 VPWR VGND VPWR VGND sky130_ef_sc_hd__decap_12
XFILLER_170_981 VPWR VGND VPWR VGND sky130_ef_sc_hd__decap_12
XTAP_TAPCELL_ROW_24_2_3137 VGND VPWR sky130_fd_sc_hd__tapvpwrvgnd_1
XFILLER_173_1065 VPWR VGND VPWR VGND sky130_ef_sc_hd__decap_12
XFILLER_125_27 VPWR VGND VPWR VGND sky130_ef_sc_hd__decap_12
XFILLER_151_1330 VPWR VGND VPWR VGND sky130_ef_sc_hd__decap_12
XTAP_TAPCELL_ROW_137_1_1292 VGND VPWR sky130_fd_sc_hd__tapvpwrvgnd_1
XFILLER_116_1450 VPWR VGND VPWR VGND sky130_ef_sc_hd__decap_12
XFILLER_64_1382 VPWR VGND VPWR VGND sky130_ef_sc_hd__decap_12
XTAP_TAPCELL_ROW_4_914 VGND VPWR sky130_fd_sc_hd__tapvpwrvgnd_1
XTAP_TAPCELL_ROW_4_903 VGND VPWR sky130_fd_sc_hd__tapvpwrvgnd_1
XFILLER_9_1552 VGND VGND VPWR VPWR sky130_fd_sc_hd__fill_1
XFILLER_25_1322 VGND VGND VPWR VPWR sky130_fd_sc_hd__decap_6
XFILLER_214_1073 VPWR VGND VPWR VGND sky130_ef_sc_hd__decap_12
XFILLER_116_1494 VPWR VGND VPWR VGND sky130_ef_sc_hd__decap_12
XFILLER_112_1314 VPWR VGND VPWR VGND sky130_ef_sc_hd__decap_12
XFILLER_99_1434 VGND VGND VPWR VPWR sky130_fd_sc_hd__decap_6
XFILLER_5_1449 VGND VGND VPWR VPWR sky130_fd_sc_hd__decap_6
XFILLER_25_1366 VPWR VGND VPWR VGND sky130_ef_sc_hd__decap_12
XFILLER_60_1246 VPWR VGND VPWR VGND sky130_ef_sc_hd__decap_12
XFILLER_205_93 VPWR VGND VPWR VGND sky130_ef_sc_hd__decap_12
XTAP_TAPCELL_ROW_184_1998 VGND VPWR sky130_fd_sc_hd__tapvpwrvgnd_1
XTAP_TAPCELL_ROW_184_1987 VGND VPWR sky130_fd_sc_hd__tapvpwrvgnd_1
XTAP_TAPCELL_ROW_184_1976 VGND VPWR sky130_fd_sc_hd__tapvpwrvgnd_1
XFILLER_141_15 VPWR VGND VPWR VGND sky130_ef_sc_hd__decap_12
XFILLER_112_1358 VPWR VGND VPWR VGND sky130_ef_sc_hd__decap_12
XFILLER_55_111 VGND VGND VPWR VPWR sky130_fd_sc_hd__fill_1
XFILLER_99_1478 VPWR VGND VPWR VGND sky130_ef_sc_hd__decap_12
XPHY_EDGE_ROW_51_2_Left_483 VGND VGND VPWR VPWR sky130_fd_sc_hd__decap_3
XFILLER_184_1161 VPWR VGND VPWR VGND sky130_ef_sc_hd__decap_12
XFILLER_169_503 VGND VGND VPWR VPWR sky130_fd_sc_hd__fill_1
XFILLER_212_643 VGND VGND VPWR VPWR sky130_fd_sc_hd__fill_1
XFILLER_200_805 VGND VGND VPWR VPWR sky130_fd_sc_hd__decap_6
XFILLER_196_333 VPWR VGND VPWR VGND sky130_ef_sc_hd__decap_12
XFILLER_200_849 VPWR VGND VPWR VGND sky130_ef_sc_hd__decap_12
XFILLER_197_889 VGND VGND VPWR VPWR sky130_fd_sc_hd__decap_6
XFILLER_196_377 VPWR VGND VPWR VGND sky130_ef_sc_hd__decap_12
XFILLER_162_1470 VPWR VGND VPWR VGND sky130_ef_sc_hd__decap_12
XFILLER_127_1590 VPWR VGND VPWR VGND sky130_ef_sc_hd__decap_12
XFILLER_123_1410 VPWR VGND VPWR VGND sky130_ef_sc_hd__decap_12
XFILLER_71_1342 VPWR VGND VPWR VGND sky130_ef_sc_hd__decap_12
XFILLER_36_1462 VGND VGND VPWR VPWR sky130_fd_sc_hd__decap_6
XFILLER_197_1511 VGND VGND VPWR VPWR sky130_fd_sc_hd__fill_1
XFILLER_123_1454 VPWR VGND VPWR VGND sky130_ef_sc_hd__decap_12
XFILLER_109_113 VPWR VGND VPWR VGND sky130_ef_sc_hd__decap_12
XFILLER_71_1386 VPWR VGND VPWR VGND sky130_ef_sc_hd__decap_12
XFILLER_7_218 VGND VGND VPWR VPWR sky130_fd_sc_hd__decap_3
XFILLER_32_1326 VPWR VGND VPWR VGND sky130_ef_sc_hd__decap_12
Xclkload1 clknet_3_1_0_clk VGND VGND VPWR VPWR clkload1/Y sky130_fd_sc_hd__clkinvlp_4
XFILLER_165_753 VPWR VGND VPWR VGND sky130_ef_sc_hd__decap_12
XFILLER_123_1498 VPWR VGND VPWR VGND sky130_ef_sc_hd__decap_12
XFILLER_10_1602 VGND VGND VPWR VPWR sky130_fd_sc_hd__decap_3
XFILLER_180_701 VPWR VGND VPWR VGND sky130_ef_sc_hd__decap_12
XFILLER_165_797 VPWR VGND VPWR VGND sky130_ef_sc_hd__decap_12
XFILLER_158_1506 VPWR VGND VPWR VGND sky130_ef_sc_hd__decap_12
XTAP_TAPCELL_ROW_121_2_3765 VGND VPWR sky130_fd_sc_hd__tapvpwrvgnd_1
XFILLER_119_3 VPWR VGND VPWR VGND sky130_ef_sc_hd__decap_12
XFILLER_4_903 VGND VGND VPWR VPWR sky130_fd_sc_hd__fill_1
XFILLER_191_1121 VPWR VGND VPWR VGND sky130_ef_sc_hd__decap_12
XTAP_TAPCELL_ROW_88_2_3548 VGND VPWR sky130_fd_sc_hd__tapvpwrvgnd_1
XFILLER_3_446 VGND VGND VPWR VPWR sky130_fd_sc_hd__fill_2
XFILLER_1_3 VPWR VGND VPWR VGND sky130_ef_sc_hd__decap_12
XFILLER_182_77 VGND VGND VPWR VPWR sky130_fd_sc_hd__decap_6
XFILLER_134_1550 VPWR VGND VPWR VGND sky130_ef_sc_hd__decap_12
XPHY_EDGE_ROW_115_1_Left_334 VGND VGND VPWR VPWR sky130_fd_sc_hd__decap_3
XFILLER_82_1482 VPWR VGND VPWR VGND sky130_ef_sc_hd__decap_12
XANTENNA_input39_A func_wdata[5] VGND VGND VPWR VPWR sky130_fd_sc_hd__diode_2
XFILLER_43_1422 VPWR VGND VPWR VGND sky130_ef_sc_hd__decap_12
XFILLER_208_905 VPWR VGND VPWR VGND sky130_ef_sc_hd__decap_12
XFILLER_130_1414 VPWR VGND VPWR VGND sky130_ef_sc_hd__decap_12
XFILLER_43_1466 VPWR VGND VPWR VGND sky130_ef_sc_hd__decap_12
XFILLER_219_253 VPWR VGND VPWR VGND sky130_ef_sc_hd__decap_12
XFILLER_208_949 VPWR VGND VPWR VGND sky130_ef_sc_hd__decap_12
XFILLER_134_1594 VGND VGND VPWR VPWR sky130_fd_sc_hd__decap_8
XFILLER_115_93 VPWR VGND VPWR VGND sky130_ef_sc_hd__decap_12
XFILLER_78_1518 VGND VGND VPWR VPWR sky130_fd_sc_hd__decap_6
XFILLER_76_1220 VPWR VGND VPWR VGND sky130_ef_sc_hd__decap_12
XFILLER_61_125 VGND VGND VPWR VPWR sky130_fd_sc_hd__fill_2
XFILLER_216_993 VPWR VGND VPWR VGND sky130_ef_sc_hd__decap_12
XFILLER_167_1381 VPWR VGND VPWR VGND sky130_ef_sc_hd__decap_12
XFILLER_163_1201 VGND VGND VPWR VPWR sky130_fd_sc_hd__decap_3
XFILLER_131_81 VPWR VGND VPWR VGND sky130_ef_sc_hd__decap_12
XFILLER_203_665 VGND VGND VPWR VPWR sky130_fd_sc_hd__decap_6
XTAP_TAPCELL_ROW_202_2493 VGND VPWR sky130_fd_sc_hd__tapvpwrvgnd_1
XFILLER_199_193 VPWR VGND VPWR VGND sky130_ef_sc_hd__decap_12
XFILLER_188_867 VGND VGND VPWR VPWR sky130_fd_sc_hd__fill_1
XFILLER_163_1245 VPWR VGND VPWR VGND sky130_ef_sc_hd__decap_12
XTAP_TAPCELL_ROW_17_2_3091 VGND VPWR sky130_fd_sc_hd__tapvpwrvgnd_1
XFILLER_202_153 VPWR VGND VPWR VGND sky130_ef_sc_hd__decap_12
XTAP_TAPCELL_ROW_194_2272 VGND VPWR sky130_fd_sc_hd__tapvpwrvgnd_1
XTAP_TAPCELL_ROW_194_2261 VGND VPWR sky130_fd_sc_hd__tapvpwrvgnd_1
XFILLER_175_517 VPWR VGND VPWR VGND sky130_ef_sc_hd__decap_12
XFILLER_163_1289 VPWR VGND VPWR VGND sky130_ef_sc_hd__decap_12
XFILLER_141_1510 VPWR VGND VPWR VGND sky130_ef_sc_hd__decap_12
X_307_ net17 net142 net132 VGND VGND VPWR VPWR s_wdata\[14\] sky130_fd_sc_hd__a21o_1
XFILLER_54_1562 VPWR VGND VPWR VGND sky130_ef_sc_hd__decap_12
XTAP_TAPCELL_ROW_219_2990 VGND VPWR sky130_fd_sc_hd__tapvpwrvgnd_1
XFILLER_204_1253 VGND VGND VPWR VPWR sky130_fd_sc_hd__decap_6
XFILLER_202_197 VPWR VGND VPWR VGND sky130_ef_sc_hd__decap_12
XTAP_TAPCELL_ROW_194_2283 VGND VPWR sky130_fd_sc_hd__tapvpwrvgnd_1
XTAP_TAPCELL_ROW_190_2147 VGND VPWR sky130_fd_sc_hd__tapvpwrvgnd_1
XFILLER_141_1554 VPWR VGND VPWR VGND sky130_ef_sc_hd__decap_12
XFILLER_15_1546 VGND VGND VPWR VPWR sky130_fd_sc_hd__decap_6
XFILLER_50_1426 VPWR VGND VPWR VGND sky130_ef_sc_hd__decap_12
XTAP_TAPCELL_ROW_215_2854 VGND VPWR sky130_fd_sc_hd__tapvpwrvgnd_1
XFILLER_204_1297 VPWR VGND VPWR VGND sky130_ef_sc_hd__decap_12
XFILLER_200_1117 VPWR VGND VPWR VGND sky130_ef_sc_hd__decap_12
XTAP_TAPCELL_ROW_190_2169 VGND VPWR sky130_fd_sc_hd__tapvpwrvgnd_1
XTAP_TAPCELL_ROW_190_2158 VGND VPWR sky130_fd_sc_hd__tapvpwrvgnd_1
XFILLER_102_1538 VPWR VGND VPWR VGND sky130_ef_sc_hd__decap_12
XFILLER_7_741 VPWR VGND VPWR VGND sky130_ef_sc_hd__decap_12
XTAP_TAPCELL_ROW_215_2876 VGND VPWR sky130_fd_sc_hd__tapvpwrvgnd_1
XTAP_TAPCELL_ROW_215_2865 VGND VPWR sky130_fd_sc_hd__tapvpwrvgnd_1
XFILLER_183_561 VPWR VGND VPWR VGND sky130_ef_sc_hd__decap_12
XFILLER_115_105 VGND VGND VPWR VPWR sky130_fd_sc_hd__decap_6
XFILLER_6_251 VGND VGND VPWR VPWR sky130_fd_sc_hd__fill_1
XFILLER_7_785 VPWR VGND VPWR VGND sky130_ef_sc_hd__decap_12
XFILLER_170_233 VPWR VGND VPWR VGND sky130_ef_sc_hd__decap_12
XTAP_TAPCELL_ROW_10_2_3045 VGND VPWR sky130_fd_sc_hd__tapvpwrvgnd_1
XFILLER_48_1300 VGND VGND VPWR VPWR sky130_fd_sc_hd__fill_1
XFILLER_174_1341 VPWR VGND VPWR VGND sky130_ef_sc_hd__decap_12
XFILLER_170_277 VPWR VGND VPWR VGND sky130_ef_sc_hd__decap_12
XTAP_TAPCELL_ROW_188_2098 VGND VPWR sky130_fd_sc_hd__tapvpwrvgnd_1
XTAP_TAPCELL_ROW_188_2087 VGND VPWR sky130_fd_sc_hd__tapvpwrvgnd_1
XFILLER_174_1385 VPWR VGND VPWR VGND sky130_ef_sc_hd__decap_12
XFILLER_170_1205 VPWR VGND VPWR VGND sky130_ef_sc_hd__decap_12
XFILLER_83_1268 VGND VGND VPWR VPWR sky130_fd_sc_hd__decap_4
XFILLER_34_3 VPWR VGND VPWR VGND sky130_ef_sc_hd__decap_12
XPHY_EDGE_ROW_47_1_Left_266 VGND VGND VPWR VPWR sky130_fd_sc_hd__decap_3
XFILLER_61_1522 VPWR VGND VPWR VGND sky130_ef_sc_hd__decap_12
XFILLER_215_1393 VGND VGND VPWR VPWR sky130_fd_sc_hd__decap_6
XFILLER_211_1213 VPWR VGND VPWR VGND sky130_ef_sc_hd__decap_12
XFILLER_22_1506 VPWR VGND VPWR VGND sky130_ef_sc_hd__decap_12
XFILLER_61_1566 VPWR VGND VPWR VGND sky130_ef_sc_hd__decap_12
XFILLER_211_1257 VPWR VGND VPWR VGND sky130_ef_sc_hd__decap_12
XFILLER_37_111 VGND VGND VPWR VPWR sky130_fd_sc_hd__fill_1
XFILLER_0_1313 VGND VGND VPWR VPWR sky130_fd_sc_hd__decap_3
XFILLER_59_1440 VGND VGND VPWR VPWR sky130_fd_sc_hd__fill_1
XFILLER_213_429 VPWR VGND VPWR VGND sky130_ef_sc_hd__decap_12
XFILLER_185_1481 VPWR VGND VPWR VGND sky130_ef_sc_hd__decap_12
XFILLER_181_1301 VPWR VGND VPWR VGND sky130_ef_sc_hd__decap_12
XPHY_EDGE_ROW_161_1_Left_380 VGND VGND VPWR VPWR sky130_fd_sc_hd__decap_3
XFILLER_0_1357 VPWR VGND VPWR VGND sky130_ef_sc_hd__decap_12
XFILLER_209_1175 VGND VGND VPWR VPWR sky130_fd_sc_hd__fill_1
XFILLER_181_1345 VPWR VGND VPWR VGND sky130_ef_sc_hd__decap_12
XFILLER_178_333 VPWR VGND VPWR VGND sky130_ef_sc_hd__decap_12
XFILLER_179_889 VGND VGND VPWR VPWR sky130_fd_sc_hd__decap_6
XFILLER_178_377 VPWR VGND VPWR VGND sky130_ef_sc_hd__decap_12
XTAP_TAPCELL_ROW_18_1_1054 VGND VPWR sky130_fd_sc_hd__tapvpwrvgnd_1
XFILLER_33_1602 VGND VGND VPWR VPWR sky130_fd_sc_hd__decap_3
XFILLER_194_837 VPWR VGND VPWR VGND sky130_ef_sc_hd__decap_12
XTAP_TAPCELL_ROW_177_1780 VGND VPWR sky130_fd_sc_hd__tapvpwrvgnd_1
XTAP_TAPCELL_ROW_177_1791 VGND VPWR sky130_fd_sc_hd__tapvpwrvgnd_1
XANTENNA__525__A1 net151 VGND VGND VPWR VPWR sky130_fd_sc_hd__diode_2
XTAP_TAPCELL_ROW_173_1677 VGND VPWR sky130_fd_sc_hd__tapvpwrvgnd_1
XTAP_TAPCELL_ROW_173_1666 VGND VPWR sky130_fd_sc_hd__tapvpwrvgnd_1
XTAP_TAPCELL_ROW_106_2_3667 VGND VPWR sky130_fd_sc_hd__tapvpwrvgnd_1
XFILLER_20_15 VPWR VGND VPWR VGND sky130_ef_sc_hd__decap_12
XFILLER_136_15 VPWR VGND VPWR VGND sky130_ef_sc_hd__decap_12
XTAP_TAPCELL_ROW_74_2_3456 VGND VPWR sky130_fd_sc_hd__tapvpwrvgnd_1
XFILLER_192_1441 VPWR VGND VPWR VGND sky130_ef_sc_hd__decap_12
XFILLER_0_416 VGND VGND VPWR VPWR sky130_fd_sc_hd__decap_4
XFILLER_192_1485 VPWR VGND VPWR VGND sky130_ef_sc_hd__decap_12
XFILLER_0_438 VGND VGND VPWR VPWR sky130_fd_sc_hd__decap_3
XTAP_TAPCELL_ROW_54_2_3332 VGND VPWR sky130_fd_sc_hd__tapvpwrvgnd_1
XTAP_TAPCELL_ROW_73_1_1164 VGND VPWR sky130_fd_sc_hd__tapvpwrvgnd_1
XFILLER_5_1213 VPWR VGND VPWR VGND sky130_ef_sc_hd__decap_12
XFILLER_29_57 VPWR VGND VPWR VGND sky130_ef_sc_hd__decap_12
XFILLER_99_1220 VPWR VGND VPWR VGND sky130_ef_sc_hd__decap_12
XFILLER_5_1257 VPWR VGND VPWR VGND sky130_ef_sc_hd__decap_12
XFILLER_216_245 VGND VGND VPWR VPWR sky130_fd_sc_hd__decap_6
XFILLER_189_609 VGND VGND VPWR VPWR sky130_fd_sc_hd__decap_6
XPHY_EDGE_ROW_166_Left_385 VGND VGND VPWR VPWR sky130_fd_sc_hd__decap_3
XFILLER_99_1286 VPWR VGND VPWR VGND sky130_ef_sc_hd__decap_12
XANTENNA__528__B net125 VGND VGND VPWR VPWR sky130_fd_sc_hd__diode_2
XFILLER_43_125 VGND VGND VPWR VPWR sky130_fd_sc_hd__fill_2
XFILLER_216_289 VPWR VGND VPWR VGND sky130_ef_sc_hd__decap_12
XFILLER_164_1521 VPWR VGND VPWR VGND sky130_ef_sc_hd__decap_12
XFILLER_38_1524 VGND VGND VPWR VPWR sky130_fd_sc_hd__fill_1
XFILLER_101_51 VGND VGND VPWR VPWR sky130_fd_sc_hd__decap_4
XFILLER_200_613 VPWR VGND VPWR VGND sky130_ef_sc_hd__decap_12
XFILLER_197_653 VPWR VGND VPWR VGND sky130_ef_sc_hd__decap_12
XFILLER_196_141 VPWR VGND VPWR VGND sky130_ef_sc_hd__decap_12
XFILLER_164_1565 VPWR VGND VPWR VGND sky130_ef_sc_hd__decap_12
XFILLER_200_657 VPWR VGND VPWR VGND sky130_ef_sc_hd__decap_12
XFILLER_197_697 VPWR VGND VPWR VGND sky130_ef_sc_hd__decap_12
XFILLER_36_1270 VPWR VGND VPWR VGND sky130_ef_sc_hd__decap_12
XFILLER_61_55 VGND VGND VPWR VPWR sky130_fd_sc_hd__fill_1
XFILLER_201_1437 VPWR VGND VPWR VGND sky130_ef_sc_hd__decap_12
XFILLER_177_55 VGND VGND VPWR VPWR sky130_fd_sc_hd__fill_1
XPHY_EDGE_ROW_175_Left_394 VGND VGND VPWR VPWR sky130_fd_sc_hd__decap_3
XFILLER_165_561 VPWR VGND VPWR VGND sky130_ef_sc_hd__decap_12
XFILLER_180_531 VGND VGND VPWR VPWR sky130_fd_sc_hd__fill_1
XFILLER_158_1314 VPWR VGND VPWR VGND sky130_ef_sc_hd__decap_12
XFILLER_158_1358 VPWR VGND VPWR VGND sky130_ef_sc_hd__decap_12
XFILLER_4_777 VGND VGND VPWR VPWR sky130_fd_sc_hd__decap_8
XFILLER_3_221 VGND VGND VPWR VPWR sky130_fd_sc_hd__decap_3
XFILLER_171_1525 VPWR VGND VPWR VGND sky130_ef_sc_hd__decap_12
XTAP_TAPCELL_ROW_151_2_3960 VGND VPWR sky130_fd_sc_hd__tapvpwrvgnd_1
XFILLER_212_1533 VGND VGND VPWR VPWR sky130_fd_sc_hd__decap_6
XFILLER_171_1569 VPWR VGND VPWR VGND sky130_ef_sc_hd__decap_12
XFILLER_86_41 VPWR VGND VPWR VGND sky130_ef_sc_hd__decap_12
XTAP_TAPCELL_ROW_7_1005 VGND VPWR sky130_fd_sc_hd__tapvpwrvgnd_1
XTAP_TAPCELL_ROW_7_1016 VGND VPWR sky130_fd_sc_hd__tapvpwrvgnd_1
XFILLER_208_713 VPWR VGND VPWR VGND sky130_ef_sc_hd__decap_12
XFILLER_187_1009 VPWR VGND VPWR VGND sky130_ef_sc_hd__decap_12
XFILLER_86_85 VPWR VGND VPWR VGND sky130_ef_sc_hd__decap_12
XTAP_TAPCELL_ROW_7_1027 VGND VPWR sky130_fd_sc_hd__tapvpwrvgnd_1
XFILLER_19_111 VGND VGND VPWR VPWR sky130_fd_sc_hd__fill_1
XFILLER_43_1274 VPWR VGND VPWR VGND sky130_ef_sc_hd__decap_12
XFILLER_212_1577 VPWR VGND VPWR VGND sky130_ef_sc_hd__decap_12
XTAP_TAPCELL_ROW_208_2680 VGND VPWR sky130_fd_sc_hd__tapvpwrvgnd_1
XFILLER_208_757 VPWR VGND VPWR VGND sky130_ef_sc_hd__decap_12
XFILLER_207_223 VGND VGND VPWR VPWR sky130_fd_sc_hd__fill_1
XFILLER_130_1244 VGND VGND VPWR VPWR sky130_fd_sc_hd__fill_1
XFILLER_78_1326 VPWR VGND VPWR VGND sky130_ef_sc_hd__decap_12
XFILLER_19_90 VGND VGND VPWR VPWR sky130_fd_sc_hd__decap_6
XTAP_TAPCELL_ROW_204_2566 VGND VPWR sky130_fd_sc_hd__tapvpwrvgnd_1
XTAP_TAPCELL_ROW_204_2555 VGND VPWR sky130_fd_sc_hd__tapvpwrvgnd_1
XTAP_TAPCELL_ROW_204_2544 VGND VPWR sky130_fd_sc_hd__tapvpwrvgnd_1
XTAP_TAPCELL_ROW_143_2_3908 VGND VPWR sky130_fd_sc_hd__tapvpwrvgnd_1
XTAP_TAPCELL_ROW_196_2323 VGND VPWR sky130_fd_sc_hd__tapvpwrvgnd_1
XTAP_TAPCELL_ROW_196_2312 VGND VPWR sky130_fd_sc_hd__tapvpwrvgnd_1
XFILLER_56_1602 VGND VGND VPWR VPWR sky130_fd_sc_hd__decap_3
XFILLER_206_1315 VGND VGND VPWR VPWR sky130_fd_sc_hd__fill_1
XTAP_TAPCELL_ROW_196_2334 VGND VPWR sky130_fd_sc_hd__tapvpwrvgnd_1
XFILLER_163_1031 VGND VGND VPWR VPWR sky130_fd_sc_hd__decap_4
XFILLER_203_473 VPWR VGND VPWR VGND sky130_ef_sc_hd__decap_12
XTAP_TAPCELL_ROW_192_2209 VGND VPWR sky130_fd_sc_hd__tapvpwrvgnd_1
XTAP_TAPCELL_ROW_217_2938 VGND VPWR sky130_fd_sc_hd__tapvpwrvgnd_1
XTAP_TAPCELL_ROW_217_2927 VGND VPWR sky130_fd_sc_hd__tapvpwrvgnd_1
XTAP_TAPCELL_ROW_217_2916 VGND VPWR sky130_fd_sc_hd__tapvpwrvgnd_1
XFILLER_198_1105 VPWR VGND VPWR VGND sky130_ef_sc_hd__decap_12
XFILLER_176_837 VPWR VGND VPWR VGND sky130_ef_sc_hd__decap_12
XTAP_TAPCELL_ROW_80_2_3499 VGND VPWR sky130_fd_sc_hd__tapvpwrvgnd_1
XFILLER_15_1310 VPWR VGND VPWR VGND sky130_ef_sc_hd__decap_12
XFILLER_19_1490 VGND VGND VPWR VPWR sky130_fd_sc_hd__decap_6
XFILLER_54_1370 VPWR VGND VPWR VGND sky130_ef_sc_hd__decap_12
XFILLER_204_1061 VPWR VGND VPWR VGND sky130_ef_sc_hd__decap_12
XFILLER_106_1482 VPWR VGND VPWR VGND sky130_ef_sc_hd__decap_12
XFILLER_102_1302 VPWR VGND VPWR VGND sky130_ef_sc_hd__decap_12
XFILLER_89_1422 VPWR VGND VPWR VGND sky130_ef_sc_hd__decap_12
XFILLER_15_1354 VPWR VGND VPWR VGND sky130_ef_sc_hd__decap_12
XFILLER_198_1149 VPWR VGND VPWR VGND sky130_ef_sc_hd__decap_12
XFILLER_184_881 VPWR VGND VPWR VGND sky130_ef_sc_hd__decap_12
XFILLER_141_1384 VGND VGND VPWR VPWR sky130_fd_sc_hd__fill_1
XFILLER_15_1398 VPWR VGND VPWR VGND sky130_ef_sc_hd__decap_12
XFILLER_183_391 VGND VGND VPWR VPWR sky130_fd_sc_hd__fill_1
XFILLER_89_1466 VPWR VGND VPWR VGND sky130_ef_sc_hd__decap_12
XFILLER_171_553 VGND VGND VPWR VPWR sky130_fd_sc_hd__decap_6
XFILLER_171_597 VPWR VGND VPWR VGND sky130_ef_sc_hd__decap_12
XTAP_TAPCELL_ROW_40_2_3240 VGND VPWR sky130_fd_sc_hd__tapvpwrvgnd_1
XFILLER_217_1455 VGND VGND VPWR VPWR sky130_fd_sc_hd__fill_1
XFILLER_106_29 VPWR VGND VPWR VGND sky130_ef_sc_hd__decap_12
XTAP_TAPCELL_ROW_39_2_3234 VGND VPWR sky130_fd_sc_hd__tapvpwrvgnd_1
XFILLER_170_1035 VGND VGND VPWR VPWR sky130_fd_sc_hd__fill_1
XFILLER_26_1450 VPWR VGND VPWR VGND sky130_ef_sc_hd__decap_12
XFILLER_61_1330 VPWR VGND VPWR VGND sky130_ef_sc_hd__decap_12
XFILLER_211_1021 VPWR VGND VPWR VGND sky130_ef_sc_hd__decap_12
XTAP_TAPCELL_ROW_181_1902 VGND VPWR sky130_fd_sc_hd__tapvpwrvgnd_1
XFILLER_113_1442 VPWR VGND VPWR VGND sky130_ef_sc_hd__decap_12
XFILLER_6_1533 VGND VGND VPWR VPWR sky130_fd_sc_hd__decap_6
XFILLER_22_1314 VPWR VGND VPWR VGND sky130_ef_sc_hd__decap_12
XFILLER_26_1494 VPWR VGND VPWR VGND sky130_ef_sc_hd__decap_12
XFILLER_211_1065 VPWR VGND VPWR VGND sky130_ef_sc_hd__decap_12
XTAP_TAPCELL_ROW_166_1481 VGND VPWR sky130_fd_sc_hd__tapvpwrvgnd_1
XTAP_TAPCELL_ROW_166_1470 VGND VPWR sky130_fd_sc_hd__tapvpwrvgnd_1
XFILLER_6_1577 VPWR VGND VPWR VGND sky130_ef_sc_hd__decap_12
XFILLER_22_1358 VPWR VGND VPWR VGND sky130_ef_sc_hd__decap_12
XFILLER_96_1426 VPWR VGND VPWR VGND sky130_ef_sc_hd__decap_12
XFILLER_214_749 VGND VGND VPWR VPWR sky130_fd_sc_hd__decap_6
XFILLER_148_1538 VPWR VGND VPWR VGND sky130_ef_sc_hd__decap_12
XFILLER_0_1121 VPWR VGND VPWR VGND sky130_ef_sc_hd__decap_12
XFILLER_213_237 VPWR VGND VPWR VGND sky130_ef_sc_hd__decap_12
XFILLER_202_83 VGND VGND VPWR VPWR sky130_fd_sc_hd__fill_1
XTAP_TAPCELL_ROW_179_1831 VGND VPWR sky130_fd_sc_hd__tapvpwrvgnd_1
XFILLER_15_15 VPWR VGND VPWR VGND sky130_ef_sc_hd__decap_12
XFILLER_194_601 VPWR VGND VPWR VGND sky130_ef_sc_hd__decap_12
XTAP_TAPCELL_ROW_179_1853 VGND VPWR sky130_fd_sc_hd__tapvpwrvgnd_1
XTAP_TAPCELL_ROW_179_1842 VGND VPWR sky130_fd_sc_hd__tapvpwrvgnd_1
XFILLER_179_653 VPWR VGND VPWR VGND sky130_ef_sc_hd__decap_12
XFILLER_178_141 VPWR VGND VPWR VGND sky130_ef_sc_hd__decap_12
XTAP_TAPCELL_ROW_49_1_1115 VGND VPWR sky130_fd_sc_hd__tapvpwrvgnd_1
XFILLER_193_111 VGND VGND VPWR VPWR sky130_fd_sc_hd__fill_1
XFILLER_181_1175 VGND VGND VPWR VPWR sky130_fd_sc_hd__fill_1
XFILLER_179_697 VPWR VGND VPWR VGND sky130_ef_sc_hd__decap_12
XTAP_TAPCELL_ROW_175_1739 VGND VPWR sky130_fd_sc_hd__tapvpwrvgnd_1
XTAP_TAPCELL_ROW_175_1728 VGND VPWR sky130_fd_sc_hd__tapvpwrvgnd_1
XTAP_TAPCELL_ROW_175_1717 VGND VPWR sky130_fd_sc_hd__tapvpwrvgnd_1
XFILLER_107_1268 VGND VGND VPWR VPWR sky130_fd_sc_hd__decap_4
XFILLER_72_1470 VPWR VGND VPWR VGND sky130_ef_sc_hd__decap_12
XFILLER_33_1410 VPWR VGND VPWR VGND sky130_ef_sc_hd__decap_12
XFILLER_37_1590 VPWR VGND VPWR VGND sky130_ef_sc_hd__decap_12
XFILLER_194_645 VPWR VGND VPWR VGND sky130_ef_sc_hd__decap_12
XFILLER_33_1454 VPWR VGND VPWR VGND sky130_ef_sc_hd__decap_12
XFILLER_181_317 VPWR VGND VPWR VGND sky130_ef_sc_hd__decap_12
XFILLER_124_1582 VPWR VGND VPWR VGND sky130_ef_sc_hd__decap_12
XFILLER_5_519 VGND VGND VPWR VPWR sky130_fd_sc_hd__decap_8
XFILLER_147_69 VPWR VGND VPWR VGND sky130_ef_sc_hd__decap_12
XFILLER_120_1468 VGND VGND VPWR VPWR sky130_fd_sc_hd__fill_1
XFILLER_68_1506 VPWR VGND VPWR VGND sky130_ef_sc_hd__decap_12
XFILLER_31_69 VGND VGND VPWR VPWR sky130_fd_sc_hd__fill_1
XFILLER_33_1498 VPWR VGND VPWR VGND sky130_ef_sc_hd__decap_12
XTAP_TAPCELL_ROW_136_2_3862 VGND VPWR sky130_fd_sc_hd__tapvpwrvgnd_1
Xoutput58 net58 VGND VGND VPWR VPWR bist_fail_bits[10] sky130_fd_sc_hd__buf_2
Xoutput47 net47 VGND VGND VPWR VPWR bist_done sky130_fd_sc_hd__buf_2
XFILLER_0_235 VGND VGND VPWR VPWR sky130_fd_sc_hd__decap_3
Xoutput69 net69 VGND VGND VPWR VPWR bist_fail_bits[20] sky130_fd_sc_hd__buf_2
XFILLER_163_57 VPWR VGND VPWR VGND sky130_ef_sc_hd__decap_12
XFILLER_44_1550 VPWR VGND VPWR VGND sky130_ef_sc_hd__decap_12
XFILLER_5_1021 VPWR VGND VPWR VGND sky130_ef_sc_hd__decap_12
XFILLER_40_1414 VPWR VGND VPWR VGND sky130_ef_sc_hd__decap_12
XFILLER_188_1329 VPWR VGND VPWR VGND sky130_ef_sc_hd__decap_12
XFILLER_186_3 VPWR VGND VPWR VGND sky130_ef_sc_hd__decap_12
XFILLER_79_1602 VGND VGND VPWR VPWR sky130_fd_sc_hd__decap_3
XFILLER_5_1065 VPWR VGND VPWR VGND sky130_ef_sc_hd__decap_12
XFILLER_44_1594 VGND VGND VPWR VPWR sky130_fd_sc_hd__decap_8
X_572_ clknet_3_2_0_clk _010_ VGND VGND VPWR VPWR u_ctrl.cmp_addr\[4\] sky130_fd_sc_hd__dfxtp_1
XFILLER_16_114 VPWR VGND VPWR VGND sky130_ef_sc_hd__decap_12
XFILLER_56_77 VGND VGND VPWR VPWR sky130_fd_sc_hd__decap_6
XFILLER_205_727 VGND VGND VPWR VPWR sky130_fd_sc_hd__fill_1
XFILLER_189_417 VPWR VGND VPWR VGND sky130_ef_sc_hd__decap_12
XFILLER_112_83 VGND VGND VPWR VPWR sky130_fd_sc_hd__fill_1
XTAP_TAPCELL_ROW_0_791 VGND VPWR sky130_fd_sc_hd__tapvpwrvgnd_1
XTAP_TAPCELL_ROW_0_780 VGND VPWR sky130_fd_sc_hd__tapvpwrvgnd_1
XFILLER_198_973 VGND VGND VPWR VPWR sky130_fd_sc_hd__decap_6
XFILLER_164_1373 VPWR VGND VPWR VGND sky130_ef_sc_hd__decap_12
XFILLER_73_1256 VPWR VGND VPWR VGND sky130_ef_sc_hd__decap_12
XFILLER_72_65 VPWR VGND VPWR VGND sky130_ef_sc_hd__decap_12
XFILLER_201_933 VPWR VGND VPWR VGND sky130_ef_sc_hd__decap_12
XFILLER_200_421 VPWR VGND VPWR VGND sky130_ef_sc_hd__decap_12
XFILLER_197_461 VPWR VGND VPWR VGND sky130_ef_sc_hd__decap_12
XFILLER_188_65 VPWR VGND VPWR VGND sky130_ef_sc_hd__decap_12
XPHY_EDGE_ROW_14_2_Left_446 VGND VGND VPWR VPWR sky130_fd_sc_hd__decap_3
XFILLER_51_1510 VPWR VGND VPWR VGND sky130_ef_sc_hd__decap_12
XFILLER_205_1381 VPWR VGND VPWR VGND sky130_ef_sc_hd__decap_12
XFILLER_201_1201 VPWR VGND VPWR VGND sky130_ef_sc_hd__decap_12
XFILLER_201_977 VPWR VGND VPWR VGND sky130_ef_sc_hd__decap_12
XFILLER_199_1425 VPWR VGND VPWR VGND sky130_ef_sc_hd__decap_12
XFILLER_184_133 VGND VGND VPWR VPWR sky130_fd_sc_hd__decap_6
XPHY_EDGE_ROW_183_Left_402 VGND VGND VPWR VPWR sky130_fd_sc_hd__decap_3
XFILLER_201_1245 VPWR VGND VPWR VGND sky130_ef_sc_hd__decap_12
XFILLER_199_1469 VPWR VGND VPWR VGND sky130_ef_sc_hd__decap_12
XFILLER_184_177 VPWR VGND VPWR VGND sky130_ef_sc_hd__decap_12
XFILLER_166_881 VPWR VGND VPWR VGND sky130_ef_sc_hd__decap_12
XPHY_EDGE_ROW_139_2_Left_571 VGND VGND VPWR VPWR sky130_fd_sc_hd__decap_3
XFILLER_12_1538 VPWR VGND VPWR VGND sky130_ef_sc_hd__decap_12
XFILLER_51_1554 VPWR VGND VPWR VGND sky130_ef_sc_hd__decap_12
XFILLER_165_391 VGND VGND VPWR VPWR sky130_fd_sc_hd__fill_1
XFILLER_201_1289 VPWR VGND VPWR VGND sky130_ef_sc_hd__decap_12
XFILLER_4_541 VGND VGND VPWR VPWR sky130_fd_sc_hd__decap_8
XFILLER_21_91 VPWR VGND VPWR VGND sky130_ef_sc_hd__decap_12
XFILLER_207_39 VPWR VGND VPWR VGND sky130_ef_sc_hd__decap_12
XFILLER_193_1057 VGND VGND VPWR VPWR sky130_fd_sc_hd__decap_6
XTAP_TAPCELL_ROW_185_2002 VGND VPWR sky130_fd_sc_hd__tapvpwrvgnd_1
XFILLER_181_895 VGND VGND VPWR VPWR sky130_fd_sc_hd__fill_1
XFILLER_4_585 VGND VGND VPWR VPWR sky130_fd_sc_hd__decap_3
XFILLER_4_574 VGND VGND VPWR VPWR sky130_fd_sc_hd__decap_4
XTAP_TAPCELL_ROW_25_2_3142 VGND VPWR sky130_fd_sc_hd__tapvpwrvgnd_1
XTAP_TAPCELL_ROW_185_2024 VGND VPWR sky130_fd_sc_hd__tapvpwrvgnd_1
XTAP_TAPCELL_ROW_185_2013 VGND VPWR sky130_fd_sc_hd__tapvpwrvgnd_1
XFILLER_97_51 VGND VGND VPWR VPWR sky130_fd_sc_hd__decap_4
XPHY_EDGE_ROW_192_Left_411 VGND VGND VPWR VPWR sky130_fd_sc_hd__decap_3
XTAP_TAPCELL_ROW_151_1_1320 VGND VPWR sky130_fd_sc_hd__tapvpwrvgnd_1
XFILLER_212_1341 VPWR VGND VPWR VGND sky130_ef_sc_hd__decap_12
XTAP_TAPCELL_ROW_206_2617 VGND VPWR sky130_fd_sc_hd__tapvpwrvgnd_1
XTAP_TAPCELL_ROW_206_2606 VGND VPWR sky130_fd_sc_hd__tapvpwrvgnd_1
XFILLER_171_1399 VGND VGND VPWR VPWR sky130_fd_sc_hd__fill_1
XFILLER_212_1385 VPWR VGND VPWR VGND sky130_ef_sc_hd__decap_12
XFILLER_208_587 VGND VGND VPWR VPWR sky130_fd_sc_hd__fill_1
XFILLER_189_951 VGND VGND VPWR VPWR sky130_fd_sc_hd__fill_1
XFILLER_204_793 VPWR VGND VPWR VGND sky130_ef_sc_hd__decap_12
XFILLER_203_281 VPWR VGND VPWR VGND sky130_ef_sc_hd__decap_12
XFILLER_176_601 VPWR VGND VPWR VGND sky130_ef_sc_hd__decap_12
XFILLER_91_1378 VGND VGND VPWR VPWR sky130_fd_sc_hd__decap_6
XFILLER_176_645 VPWR VGND VPWR VGND sky130_ef_sc_hd__decap_12
XFILLER_175_111 VGND VGND VPWR VPWR sky130_fd_sc_hd__fill_1
XFILLER_191_615 VGND VGND VPWR VPWR sky130_fd_sc_hd__fill_1
XFILLER_178_1509 VPWR VGND VPWR VGND sky130_ef_sc_hd__decap_12
XTAP_TAPCELL_ROW_122_2_3770 VGND VPWR sky130_fd_sc_hd__tapvpwrvgnd_1
XFILLER_89_1274 VPWR VGND VPWR VGND sky130_ef_sc_hd__decap_12
XFILLER_171_361 VPWR VGND VPWR VGND sky130_ef_sc_hd__decap_12
XFILLER_117_39 VPWR VGND VPWR VGND sky130_ef_sc_hd__decap_12
XPHY_EDGE_ROW_60_2_Left_492 VGND VGND VPWR VPWR sky130_fd_sc_hd__decap_3
XTAP_TAPCELL_ROW_168_1532 VGND VPWR sky130_fd_sc_hd__tapvpwrvgnd_1
XTAP_TAPCELL_ROW_168_1521 VGND VPWR sky130_fd_sc_hd__tapvpwrvgnd_1
XFILLER_150_1406 VGND VGND VPWR VPWR sky130_fd_sc_hd__decap_6
XFILLER_218_307 VGND VGND VPWR VPWR sky130_fd_sc_hd__fill_1
XTAP_TAPCELL_ROW_164_1418 VGND VPWR sky130_fd_sc_hd__tapvpwrvgnd_1
XTAP_TAPCELL_ROW_164_1407 VGND VPWR sky130_fd_sc_hd__tapvpwrvgnd_1
XFILLER_133_27 VPWR VGND VPWR VGND sky130_ef_sc_hd__decap_12
XTAP_TAPCELL_ROW_114_2_3718 VGND VPWR sky130_fd_sc_hd__tapvpwrvgnd_1
XFILLER_2_1205 VPWR VGND VPWR VGND sky130_ef_sc_hd__decap_12
XFILLER_6_1341 VPWR VGND VPWR VGND sky130_ef_sc_hd__decap_12
XFILLER_113_1272 VGND VGND VPWR VPWR sky130_fd_sc_hd__fill_1
XFILLER_6_1385 VPWR VGND VPWR VGND sky130_ef_sc_hd__decap_12
XFILLER_214_513 VPWR VGND VPWR VGND sky130_ef_sc_hd__decap_12
XFILLER_213_93 VPWR VGND VPWR VGND sky130_ef_sc_hd__decap_12
XFILLER_148_1302 VPWR VGND VPWR VGND sky130_ef_sc_hd__decap_12
XFILLER_214_557 VPWR VGND VPWR VGND sky130_ef_sc_hd__decap_12
XFILLER_195_921 VPWR VGND VPWR VGND sky130_ef_sc_hd__decap_12
XFILLER_179_461 VPWR VGND VPWR VGND sky130_ef_sc_hd__decap_12
XFILLER_161_1546 VGND VGND VPWR VPWR sky130_fd_sc_hd__decap_6
XANTENNA_clkbuf_3_2_0_clk_A clknet_0_clk VGND VGND VPWR VPWR sky130_fd_sc_hd__diode_2
XFILLER_195_965 VPWR VGND VPWR VGND sky130_ef_sc_hd__decap_12
XFILLER_166_133 VGND VGND VPWR VPWR sky130_fd_sc_hd__decap_6
XPHY_EDGE_ROW_124_1_Left_343 VGND VGND VPWR VPWR sky130_fd_sc_hd__decap_3
XFILLER_202_1521 VPWR VGND VPWR VGND sky130_ef_sc_hd__decap_12
XFILLER_194_475 VGND VGND VPWR VPWR sky130_fd_sc_hd__fill_1
XFILLER_202_1565 VPWR VGND VPWR VGND sky130_ef_sc_hd__decap_12
XFILLER_182_637 VGND VGND VPWR VPWR sky130_fd_sc_hd__decap_6
XFILLER_181_125 VPWR VGND VPWR VGND sky130_ef_sc_hd__decap_12
XFILLER_166_177 VPWR VGND VPWR VGND sky130_ef_sc_hd__decap_12
XFILLER_120_1232 VPWR VGND VPWR VGND sky130_ef_sc_hd__decap_12
XFILLER_218_1005 VPWR VGND VPWR VGND sky130_ef_sc_hd__decap_12
XFILLER_181_169 VPWR VGND VPWR VGND sky130_ef_sc_hd__decap_12
XFILLER_159_1442 VPWR VGND VPWR VGND sky130_ef_sc_hd__decap_12
XFILLER_68_1314 VPWR VGND VPWR VGND sky130_ef_sc_hd__decap_12
XFILLER_5_349 VPWR VGND VPWR VGND sky130_ef_sc_hd__decap_12
XTAP_TAPCELL_ROW_11_2_3050 VGND VPWR sky130_fd_sc_hd__tapvpwrvgnd_1
XFILLER_190_681 VPWR VGND VPWR VGND sky130_ef_sc_hd__decap_12
XFILLER_155_1328 VGND VGND VPWR VPWR sky130_fd_sc_hd__fill_1
XFILLER_101_3 VPWR VGND VPWR VGND sky130_ef_sc_hd__decap_12
XFILLER_68_1358 VPWR VGND VPWR VGND sky130_ef_sc_hd__decap_12
XFILLER_1_500 VGND VGND VPWR VPWR sky130_fd_sc_hd__decap_4
XFILLER_218_1049 VPWR VGND VPWR VGND sky130_ef_sc_hd__decap_12
XFILLER_7_1105 VPWR VGND VPWR VGND sky130_ef_sc_hd__decap_12
XFILLER_7_1149 VPWR VGND VPWR VGND sky130_ef_sc_hd__decap_12
XFILLER_209_329 VGND VGND VPWR VPWR sky130_fd_sc_hd__decap_6
XFILLER_190_77 VGND VGND VPWR VPWR sky130_fd_sc_hd__decap_6
XANTENNA_input21_A func_wdata[18] VGND VGND VPWR VPWR sky130_fd_sc_hd__diode_2
XTAP_TAPCELL_ROW_41_1_1099 VGND VPWR sky130_fd_sc_hd__tapvpwrvgnd_1
XFILLER_79_1410 VPWR VGND VPWR VGND sky130_ef_sc_hd__decap_12
XFILLER_217_373 VPWR VGND VPWR VGND sky130_ef_sc_hd__decap_12
XFILLER_123_93 VPWR VGND VPWR VGND sky130_ef_sc_hd__decap_12
XFILLER_79_1454 VPWR VGND VPWR VGND sky130_ef_sc_hd__decap_12
X_624_ clknet_3_1_0_clk _058_ VGND VGND VPWR VPWR net49 sky130_fd_sc_hd__dfxtp_1
XFILLER_189_225 VPWR VGND VPWR VGND sky130_ef_sc_hd__decap_12
XFILLER_79_1498 VPWR VGND VPWR VGND sky130_ef_sc_hd__decap_12
X_555_ net136 _251_ VGND VGND VPWR VPWR _061_ sky130_fd_sc_hd__and2_1
X_486_ net68 net121 VGND VGND VPWR VPWR _217_ sky130_fd_sc_hd__or2_1
XFILLER_198_781 VPWR VGND VPWR VGND sky130_ef_sc_hd__decap_12
XPHY_EDGE_ROW_56_1_Left_275 VGND VGND VPWR VPWR sky130_fd_sc_hd__decap_3
XFILLER_201_741 VPWR VGND VPWR VGND sky130_ef_sc_hd__decap_12
XFILLER_157_111 VGND VGND VPWR VPWR sky130_fd_sc_hd__fill_1
XTAP_TAPCELL_ROW_95_2_3596 VGND VPWR sky130_fd_sc_hd__tapvpwrvgnd_1
XFILLER_201_785 VPWR VGND VPWR VGND sky130_ef_sc_hd__decap_12
XFILLER_200_251 VGND VGND VPWR VPWR sky130_fd_sc_hd__fill_1
XFILLER_199_1233 VPWR VGND VPWR VGND sky130_ef_sc_hd__decap_12
XFILLER_173_615 VGND VGND VPWR VPWR sky130_fd_sc_hd__fill_1
XFILLER_12_1302 VPWR VGND VPWR VGND sky130_ef_sc_hd__decap_12
XFILLER_218_27 VGND VGND VPWR VPWR sky130_fd_sc_hd__fill_1
XFILLER_195_1119 VGND VGND VPWR VPWR sky130_fd_sc_hd__fill_1
XFILLER_185_497 VGND VGND VPWR VPWR sky130_fd_sc_hd__decap_6
XTAP_TAPCELL_ROW_107_2_3672 VGND VPWR sky130_fd_sc_hd__tapvpwrvgnd_1
XFILLER_16_1482 VPWR VGND VPWR VGND sky130_ef_sc_hd__decap_12
XFILLER_51_1384 VGND VGND VPWR VPWR sky130_fd_sc_hd__fill_1
XFILLER_103_1496 VGND VGND VPWR VPWR sky130_fd_sc_hd__fill_1
XFILLER_86_1414 VPWR VGND VPWR VGND sky130_ef_sc_hd__decap_12
XFILLER_138_1526 VPWR VGND VPWR VGND sky130_ef_sc_hd__decap_12
XTAP_TAPCELL_ROW_100_2_3626 VGND VPWR sky130_fd_sc_hd__tapvpwrvgnd_1
XFILLER_86_109 VPWR VGND VPWR VGND sky130_ef_sc_hd__decap_12
XFILLER_136_1294 VGND VGND VPWR VPWR sky130_fd_sc_hd__decap_6
XFILLER_23_1442 VPWR VGND VPWR VGND sky130_ef_sc_hd__decap_12
XFILLER_209_841 VPWR VGND VPWR VGND sky130_ef_sc_hd__decap_12
XFILLER_110_1412 VGND VGND VPWR VPWR sky130_fd_sc_hd__fill_1
XFILLER_97_1510 VPWR VGND VPWR VGND sky130_ef_sc_hd__decap_12
XFILLER_3_1525 VPWR VGND VPWR VGND sky130_ef_sc_hd__decap_12
XPHY_EDGE_ROW_209_Right_54 VGND VGND VPWR VPWR sky130_fd_sc_hd__decap_3
XFILLER_97_1554 VPWR VGND VPWR VGND sky130_ef_sc_hd__decap_12
XFILLER_3_1569 VPWR VGND VPWR VGND sky130_ef_sc_hd__decap_12
XANTENNA__466__X _198_ VGND VGND VPWR VPWR sky130_fd_sc_hd__diode_2
XFILLER_58_1538 VPWR VGND VPWR VGND sky130_ef_sc_hd__decap_12
XFILLER_211_505 VPWR VGND VPWR VGND sky130_ef_sc_hd__decap_12
XFILLER_208_1229 VPWR VGND VPWR VGND sky130_ef_sc_hd__decap_12
XPHY_EDGE_ROW_70_1_Right_656 VGND VGND VPWR VPWR sky130_fd_sc_hd__decap_3
XFILLER_195_217 VGND VGND VPWR VPWR sky130_fd_sc_hd__decap_6
XFILLER_177_921 VPWR VGND VPWR VGND sky130_ef_sc_hd__decap_12
XFILLER_177_965 VPWR VGND VPWR VGND sky130_ef_sc_hd__decap_12
XFILLER_143_1232 VPWR VGND VPWR VGND sky130_ef_sc_hd__decap_12
XFILLER_176_475 VGND VGND VPWR VPWR sky130_fd_sc_hd__fill_1
XFILLER_143_1298 VPWR VGND VPWR VGND sky130_ef_sc_hd__decap_12
XFILLER_12_27 VGND VGND VPWR VPWR sky130_fd_sc_hd__fill_1
XFILLER_17_1268 VGND VGND VPWR VPWR sky130_fd_sc_hd__decap_4
XPHY_EDGE_ROW_218_Right_63 VGND VGND VPWR VPWR sky130_fd_sc_hd__decap_3
XFILLER_178_1317 VPWR VGND VPWR VGND sky130_ef_sc_hd__decap_12
XFILLER_164_637 VGND VGND VPWR VPWR sky130_fd_sc_hd__decap_6
XFILLER_163_125 VPWR VGND VPWR VGND sky130_ef_sc_hd__decap_12
XFILLER_128_27 VGND VGND VPWR VPWR sky130_fd_sc_hd__fill_1
XFILLER_121_1552 VGND VGND VPWR VPWR sky130_fd_sc_hd__fill_1
XFILLER_34_1582 VPWR VGND VPWR VGND sky130_ef_sc_hd__decap_12
XFILLER_192_979 VGND VGND VPWR VPWR sky130_fd_sc_hd__fill_1
XFILLER_3_809 VGND VGND VPWR VPWR sky130_fd_sc_hd__decap_6
XFILLER_30_1468 VGND VGND VPWR VPWR sky130_fd_sc_hd__fill_1
XFILLER_172_681 VPWR VGND VPWR VGND sky130_ef_sc_hd__decap_12
XFILLER_163_169 VPWR VGND VPWR VGND sky130_ef_sc_hd__decap_12
XFILLER_219_1369 VGND VGND VPWR VPWR sky130_fd_sc_hd__decap_3
XFILLER_176_1085 VGND VGND VPWR VPWR sky130_fd_sc_hd__decap_6
XFILLER_144_15 VPWR VGND VPWR VGND sky130_ef_sc_hd__decap_12
XFILLER_154_1350 VGND VGND VPWR VPWR sky130_fd_sc_hd__decap_6
XFILLER_8_1414 VPWR VGND VPWR VGND sky130_ef_sc_hd__decap_12
XFILLER_154_1394 VPWR VGND VPWR VGND sky130_ef_sc_hd__decap_12
XFILLER_63_1244 VPWR VGND VPWR VGND sky130_ef_sc_hd__decap_12
XFILLER_189_1413 VPWR VGND VPWR VGND sky130_ef_sc_hd__decap_12
XFILLER_150_1258 VPWR VGND VPWR VGND sky130_ef_sc_hd__decap_12
XFILLER_115_1378 VGND VGND VPWR VPWR sky130_fd_sc_hd__decap_6
XFILLER_80_1580 VGND VGND VPWR VPWR sky130_fd_sc_hd__fill_1
XFILLER_189_1457 VPWR VGND VPWR VGND sky130_ef_sc_hd__decap_12
XTAP_TAPCELL_ROW_2_842 VGND VPWR sky130_fd_sc_hd__tapvpwrvgnd_1
XFILLER_37_57 VPWR VGND VPWR VGND sky130_ef_sc_hd__decap_12
XTAP_TAPCELL_ROW_144_2_3913 VGND VPWR sky130_fd_sc_hd__tapvpwrvgnd_1
XFILLER_2_1035 VGND VGND VPWR VPWR sky130_fd_sc_hd__fill_1
XTAP_TAPCELL_ROW_2_853 VGND VPWR sky130_fd_sc_hd__tapvpwrvgnd_1
XFILLER_215_833 VGND VGND VPWR VPWR sky130_fd_sc_hd__decap_6
XFILLER_214_321 VPWR VGND VPWR VGND sky130_ef_sc_hd__decap_12
XFILLER_183_1001 VGND VGND VPWR VPWR sky130_fd_sc_hd__decap_6
XFILLER_215_877 VPWR VGND VPWR VGND sky130_ef_sc_hd__decap_12
XFILLER_214_365 VPWR VGND VPWR VGND sky130_ef_sc_hd__decap_12
XFILLER_183_1045 VPWR VGND VPWR VGND sky130_ef_sc_hd__decap_12
X_340_ u_ctrl.cmp_addr\[1\] b_addr\[1\] net153 VGND VGND VPWR VPWR _091_ sky130_fd_sc_hd__mux2_1
XFILLER_187_729 VPWR VGND VPWR VGND sky130_ef_sc_hd__decap_12
XFILLER_183_1089 VPWR VGND VPWR VGND sky130_ef_sc_hd__decap_12
XFILLER_161_1310 VPWR VGND VPWR VGND sky130_ef_sc_hd__decap_12
XFILLER_149_3 VPWR VGND VPWR VGND sky130_ef_sc_hd__decap_12
XFILLER_161_1354 VPWR VGND VPWR VGND sky130_ef_sc_hd__decap_12
XFILLER_139_111 VGND VGND VPWR VPWR sky130_fd_sc_hd__fill_1
X_271_ u_ctrl.elem_idx\[1\] VGND VGND VPWR VPWR _070_ sky130_fd_sc_hd__inv_2
XFILLER_182_401 VPWR VGND VPWR VGND sky130_ef_sc_hd__decap_12
XFILLER_122_1338 VPWR VGND VPWR VGND sky130_ef_sc_hd__decap_12
XFILLER_167_497 VGND VGND VPWR VPWR sky130_fd_sc_hd__decap_6
XFILLER_161_1398 VPWR VGND VPWR VGND sky130_ef_sc_hd__decap_12
XFILLER_5_113 VPWR VGND VPWR VGND sky130_ef_sc_hd__decap_12
XFILLER_202_1373 VPWR VGND VPWR VGND sky130_ef_sc_hd__decap_12
XFILLER_185_55 VGND VGND VPWR VPWR sky130_fd_sc_hd__fill_1
XFILLER_182_445 VPWR VGND VPWR VGND sky130_ef_sc_hd__decap_12
XFILLER_6_669 VPWR VGND VPWR VGND sky130_ef_sc_hd__decap_12
XFILLER_194_1141 VGND VGND VPWR VPWR sky130_fd_sc_hd__decap_6
XFILLER_182_489 VPWR VGND VPWR VGND sky130_ef_sc_hd__decap_12
XFILLER_159_1272 VGND VGND VPWR VPWR sky130_fd_sc_hd__fill_1
XFILLER_194_1185 VPWR VGND VPWR VGND sky130_ef_sc_hd__decap_12
XFILLER_190_1005 VPWR VGND VPWR VGND sky130_ef_sc_hd__decap_12
XFILLER_190_1049 VPWR VGND VPWR VGND sky130_ef_sc_hd__decap_12
XFILLER_81_1322 VGND VGND VPWR VPWR sky130_fd_sc_hd__decap_6
XFILLER_78_53 VPWR VGND VPWR VGND sky130_ef_sc_hd__decap_12
XFILLER_68_109 VPWR VGND VPWR VGND sky130_ef_sc_hd__decap_12
XFILLER_172_1483 VGND VGND VPWR VPWR sky130_fd_sc_hd__fill_1
XFILLER_133_1434 VGND VGND VPWR VPWR sky130_fd_sc_hd__decap_6
XFILLER_81_1366 VPWR VGND VPWR VGND sky130_ef_sc_hd__decap_12
XFILLER_78_97 VPWR VGND VPWR VGND sky130_ef_sc_hd__decap_12
XFILLER_204_29 VPWR VGND VPWR VGND sky130_ef_sc_hd__decap_12
XFILLER_209_137 VPWR VGND VPWR VGND sky130_ef_sc_hd__decap_12
XFILLER_133_1478 VPWR VGND VPWR VGND sky130_ef_sc_hd__decap_12
XFILLER_94_41 VPWR VGND VPWR VGND sky130_ef_sc_hd__decap_12
XFILLER_206_811 VGND VGND VPWR VPWR sky130_fd_sc_hd__fill_1
XFILLER_94_85 VPWR VGND VPWR VGND sky130_ef_sc_hd__decap_12
XFILLER_218_693 VGND VGND VPWR VPWR sky130_fd_sc_hd__decap_6
XFILLER_217_181 VPWR VGND VPWR VGND sky130_ef_sc_hd__decap_12
XFILLER_209_1505 VGND VGND VPWR VPWR sky130_fd_sc_hd__decap_6
X_607_ clknet_3_6_0_clk _041_ VGND VGND VPWR VPWR net63 sky130_fd_sc_hd__dfxtp_1
XFILLER_209_1549 VPWR VGND VPWR VGND sky130_ef_sc_hd__decap_12
XFILLER_177_217 VGND VGND VPWR VPWR sky130_fd_sc_hd__decap_6
XFILLER_92_1462 VGND VGND VPWR VPWR sky130_fd_sc_hd__decap_6
X_538_ net76 net123 VGND VGND VPWR VPWR _243_ sky130_fd_sc_hd__or2_1
X_469_ _170_ _176_ _191_ _192_ VGND VGND VPWR VPWR _201_ sky130_fd_sc_hd__or4_1
XFILLER_192_209 VPWR VGND VPWR VGND sky130_ef_sc_hd__decap_12
XFILLER_144_1574 VGND VGND VPWR VPWR sky130_fd_sc_hd__decap_6
XFILLER_199_1063 VGND VGND VPWR VPWR sky130_fd_sc_hd__fill_1
XFILLER_185_261 VPWR VGND VPWR VGND sky130_ef_sc_hd__decap_12
XFILLER_145_125 VGND VGND VPWR VPWR sky130_fd_sc_hd__fill_2
XFILLER_140_1438 VPWR VGND VPWR VGND sky130_ef_sc_hd__decap_12
XPHY_EDGE_ROW_113_2_Right_170 VGND VGND VPWR VPWR sky130_fd_sc_hd__decap_3
XFILLER_174_979 VGND VGND VPWR VPWR sky130_fd_sc_hd__fill_1
XFILLER_64_3 VPWR VGND VPWR VGND sky130_ef_sc_hd__decap_12
XFILLER_86_1244 VGND VGND VPWR VPWR sky130_fd_sc_hd__fill_1
XFILLER_216_1509 VPWR VGND VPWR VGND sky130_ef_sc_hd__decap_12
XFILLER_173_1225 VGND VGND VPWR VPWR sky130_fd_sc_hd__decap_6
XFILLER_173_1269 VPWR VGND VPWR VGND sky130_ef_sc_hd__decap_12
XTAP_TAPCELL_ROW_150_2_3956 VGND VPWR sky130_fd_sc_hd__tapvpwrvgnd_1
XFILLER_138_1356 VGND VGND VPWR VPWR sky130_fd_sc_hd__fill_1
XFILLER_4_83 VGND VGND VPWR VPWR sky130_fd_sc_hd__fill_1
XFILLER_60_1406 VGND VGND VPWR VPWR sky130_fd_sc_hd__decap_6
XFILLER_151_1534 VPWR VGND VPWR VGND sky130_ef_sc_hd__decap_12
XFILLER_114_29 VPWR VGND VPWR VGND sky130_ef_sc_hd__decap_12
XFILLER_151_1578 VPWR VGND VPWR VGND sky130_ef_sc_hd__decap_12
XTAP_TAPCELL_ROW_129_2_3815 VGND VPWR sky130_fd_sc_hd__tapvpwrvgnd_1
XTAP_TAPCELL_ROW_130_2_3821 VGND VPWR sky130_fd_sc_hd__tapvpwrvgnd_1
XFILLER_112_1518 VGND VGND VPWR VPWR sky130_fd_sc_hd__decap_6
XFILLER_209_671 VGND VGND VPWR VPWR sky130_fd_sc_hd__fill_1
XFILLER_167_1007 VGND VGND VPWR VPWR sky130_fd_sc_hd__fill_1
XFILLER_110_1220 VPWR VGND VPWR VGND sky130_ef_sc_hd__decap_12
XANTENNA__568__CLK clknet_3_1_0_clk VGND VGND VPWR VPWR sky130_fd_sc_hd__diode_2
XFILLER_23_1272 VGND VGND VPWR VPWR sky130_fd_sc_hd__fill_1
XFILLER_58_1302 VPWR VGND VPWR VGND sky130_ef_sc_hd__decap_12
XFILLER_184_1365 VGND VGND VPWR VPWR sky130_fd_sc_hd__decap_6
XFILLER_97_1384 VGND VGND VPWR VPWR sky130_fd_sc_hd__fill_1
XFILLER_3_1399 VGND VGND VPWR VPWR sky130_fd_sc_hd__fill_1
XFILLER_212_825 VPWR VGND VPWR VGND sky130_ef_sc_hd__decap_12
XFILLER_208_1037 VPWR VGND VPWR VGND sky130_ef_sc_hd__decap_12
XFILLER_180_1229 VPWR VGND VPWR VGND sky130_ef_sc_hd__decap_12
XFILLER_169_729 VPWR VGND VPWR VGND sky130_ef_sc_hd__decap_12
XFILLER_149_1496 VGND VGND VPWR VPWR sky130_fd_sc_hd__fill_1
XPHY_EDGE_ROW_71_1_Right_657 VGND VGND VPWR VPWR sky130_fd_sc_hd__decap_3
XFILLER_212_869 VPWR VGND VPWR VGND sky130_ef_sc_hd__decap_12
XFILLER_211_335 VGND VGND VPWR VPWR sky130_fd_sc_hd__fill_1
XFILLER_210_83 VGND VGND VPWR VPWR sky130_fd_sc_hd__fill_1
XFILLER_23_15 VPWR VGND VPWR VGND sky130_ef_sc_hd__decap_12
XFILLER_139_15 VPWR VGND VPWR VGND sky130_ef_sc_hd__decap_12
XFILLER_71_1546 VGND VGND VPWR VPWR sky130_fd_sc_hd__decap_6
XFILLER_164_401 VPWR VGND VPWR VGND sky130_ef_sc_hd__decap_12
XFILLER_180_905 VPWR VGND VPWR VGND sky130_ef_sc_hd__decap_12
XFILLER_178_1147 VGND VGND VPWR VPWR sky130_fd_sc_hd__fill_1
XFILLER_164_445 VPWR VGND VPWR VGND sky130_ef_sc_hd__decap_12
XFILLER_30_1232 VPWR VGND VPWR VGND sky130_ef_sc_hd__decap_12
XFILLER_219_81 VGND VGND VPWR VPWR sky130_fd_sc_hd__decap_3
XFILLER_180_949 VPWR VGND VPWR VGND sky130_ef_sc_hd__decap_12
XFILLER_164_489 VPWR VGND VPWR VGND sky130_ef_sc_hd__decap_12
XFILLER_69_1442 VPWR VGND VPWR VGND sky130_ef_sc_hd__decap_12
XFILLER_3_617 VPWR VGND VPWR VGND sky130_ef_sc_hd__decap_12
XFILLER_219_1133 VPWR VGND VPWR VGND sky130_ef_sc_hd__decap_12
XFILLER_191_1325 VPWR VGND VPWR VGND sky130_ef_sc_hd__decap_12
XFILLER_156_1412 VGND VGND VPWR VPWR sky130_fd_sc_hd__fill_1
XFILLER_65_1328 VGND VGND VPWR VPWR sky130_fd_sc_hd__fill_1
XFILLER_219_1177 VPWR VGND VPWR VGND sky130_ef_sc_hd__decap_12
XFILLER_155_69 VPWR VGND VPWR VGND sky130_ef_sc_hd__decap_12
XFILLER_191_1369 VPWR VGND VPWR VGND sky130_ef_sc_hd__decap_12
XTAP_TAPCELL_ROW_7_978 VGND VPWR sky130_fd_sc_hd__tapvpwrvgnd_1
XTAP_TAPCELL_ROW_7_989 VGND VPWR sky130_fd_sc_hd__tapvpwrvgnd_1
XFILLER_8_1244 VGND VGND VPWR VPWR sky130_fd_sc_hd__fill_1
XPHY_EDGE_ROW_23_2_Left_455 VGND VGND VPWR VPWR sky130_fd_sc_hd__decap_3
XTAP_TAPCELL_ROW_56_1_1130 VGND VPWR sky130_fd_sc_hd__tapvpwrvgnd_1
XFILLER_171_57 VPWR VGND VPWR VGND sky130_ef_sc_hd__decap_12
XPHY_EDGE_ROW_148_2_Left_580 VGND VGND VPWR VPWR sky130_fd_sc_hd__decap_3
XFILLER_215_641 VPWR VGND VPWR VGND sky130_ef_sc_hd__decap_12
XFILLER_189_1287 VGND VGND VPWR VPWR sky130_fd_sc_hd__fill_1
XFILLER_64_77 VGND VGND VPWR VPWR sky130_fd_sc_hd__decap_6
XFILLER_215_685 VPWR VGND VPWR VGND sky130_ef_sc_hd__decap_12
XTAP_TAPCELL_ROW_144_1_1306 VGND VPWR sky130_fd_sc_hd__tapvpwrvgnd_1
XFILLER_76_1468 VGND VGND VPWR VPWR sky130_fd_sc_hd__fill_1
XFILLER_214_195 VGND VGND VPWR VPWR sky130_fd_sc_hd__fill_1
XFILLER_202_357 VGND VGND VPWR VPWR sky130_fd_sc_hd__decap_6
XFILLER_187_559 VGND VGND VPWR VPWR sky130_fd_sc_hd__fill_1
XFILLER_120_83 VGND VGND VPWR VPWR sky130_fd_sc_hd__fill_1
X_323_ net35 net144 net134 VGND VGND VPWR VPWR s_wdata\[30\] sky130_fd_sc_hd__a21o_1
XFILLER_9_39 VPWR VGND VPWR VGND sky130_ef_sc_hd__decap_12
XFILLER_174_209 VPWR VGND VPWR VGND sky130_ef_sc_hd__decap_12
XFILLER_126_1282 VPWR VGND VPWR VGND sky130_ef_sc_hd__decap_12
XFILLER_80_65 VPWR VGND VPWR VGND sky130_ef_sc_hd__decap_12
XFILLER_196_1203 VGND VGND VPWR VPWR sky130_fd_sc_hd__fill_1
XFILLER_196_65 VPWR VGND VPWR VGND sky130_ef_sc_hd__decap_12
XFILLER_183_721 VGND VGND VPWR VPWR sky130_fd_sc_hd__decap_6
XFILLER_167_261 VPWR VGND VPWR VGND sky130_ef_sc_hd__decap_12
XFILLER_183_765 VPWR VGND VPWR VGND sky130_ef_sc_hd__decap_12
XFILLER_127_125 VGND VGND VPWR VPWR sky130_fd_sc_hd__fill_2
XFILLER_6_433 VPWR VGND VPWR VGND sky130_ef_sc_hd__decap_12
XFILLER_13_81 VGND VGND VPWR VPWR sky130_fd_sc_hd__decap_8
XFILLER_182_253 VPWR VGND VPWR VGND sky130_ef_sc_hd__decap_12
XFILLER_129_81 VPWR VGND VPWR VGND sky130_ef_sc_hd__decap_12
XFILLER_104_1580 VGND VGND VPWR VPWR sky130_fd_sc_hd__fill_1
XFILLER_13_1496 VGND VGND VPWR VPWR sky130_fd_sc_hd__fill_1
XFILLER_48_1526 VPWR VGND VPWR VGND sky130_ef_sc_hd__decap_12
XTAP_TAPCELL_ROW_135_2_3858 VGND VPWR sky130_fd_sc_hd__tapvpwrvgnd_1
XFILLER_215_39 VPWR VGND VPWR VGND sky130_ef_sc_hd__decap_12
XFILLER_174_1589 VGND VGND VPWR VPWR sky130_fd_sc_hd__decap_6
XFILLER_170_1409 VPWR VGND VPWR VGND sky130_ef_sc_hd__decap_12
XFILLER_133_1220 VPWR VGND VPWR VGND sky130_ef_sc_hd__decap_12
XTAP_TAPCELL_ROW_115_2_3723 VGND VPWR sky130_fd_sc_hd__tapvpwrvgnd_1
XFILLER_1_171 VGND VGND VPWR VPWR sky130_fd_sc_hd__fill_2
XFILLER_46_1294 VGND VGND VPWR VPWR sky130_fd_sc_hd__decap_6
XFILLER_133_1286 VPWR VGND VPWR VGND sky130_ef_sc_hd__decap_12
XFILLER_20_1412 VGND VGND VPWR VPWR sky130_fd_sc_hd__fill_1
XANTENNA__457__A net147 VGND VGND VPWR VPWR sky130_fd_sc_hd__diode_2
XFILLER_209_1313 VPWR VGND VPWR VGND sky130_ef_sc_hd__decap_12
XFILLER_94_1524 VGND VGND VPWR VPWR sky130_fd_sc_hd__fill_1
XFILLER_209_1357 VPWR VGND VPWR VGND sky130_ef_sc_hd__decap_12
XTAP_TAPCELL_ROW_199_2398 VGND VPWR sky130_fd_sc_hd__tapvpwrvgnd_1
XFILLER_181_1505 VGND VGND VPWR VPWR sky130_fd_sc_hd__decap_6
XFILLER_166_1073 VPWR VGND VPWR VGND sky130_ef_sc_hd__decap_12
XFILLER_181_1549 VPWR VGND VPWR VGND sky130_ef_sc_hd__decap_12
XFILLER_92_1270 VPWR VGND VPWR VGND sky130_ef_sc_hd__decap_12
XFILLER_105_1322 VGND VGND VPWR VPWR sky130_fd_sc_hd__decap_6
XFILLER_53_1232 VPWR VGND VPWR VGND sky130_ef_sc_hd__decap_12
XFILLER_193_529 VPWR VGND VPWR VGND sky130_ef_sc_hd__decap_12
XFILLER_186_581 VGND VGND VPWR VPWR sky130_fd_sc_hd__decap_6
XFILLER_179_1401 VPWR VGND VPWR VGND sky130_ef_sc_hd__decap_12
XFILLER_144_1382 VPWR VGND VPWR VGND sky130_ef_sc_hd__decap_12
XFILLER_140_1246 VPWR VGND VPWR VGND sky130_ef_sc_hd__decap_12
XTAP_TAPCELL_ROW_8_2_3031 VGND VPWR sky130_fd_sc_hd__tapvpwrvgnd_1
XFILLER_53_1298 VPWR VGND VPWR VGND sky130_ef_sc_hd__decap_12
XFILLER_105_1366 VPWR VGND VPWR VGND sky130_ef_sc_hd__decap_12
XPHY_EDGE_ROW_19_1_Left_238 VGND VGND VPWR VPWR sky130_fd_sc_hd__decap_3
XFILLER_31_1552 VGND VGND VPWR VPWR sky130_fd_sc_hd__fill_1
XPHY_EDGE_ROW_114_2_Right_171 VGND VGND VPWR VPWR sky130_fd_sc_hd__decap_3
XFILLER_216_1317 VPWR VGND VPWR VGND sky130_ef_sc_hd__decap_12
XFILLER_173_1033 VPWR VGND VPWR VGND sky130_ef_sc_hd__decap_12
XFILLER_173_1077 VPWR VGND VPWR VGND sky130_ef_sc_hd__decap_12
XFILLER_170_993 VPWR VGND VPWR VGND sky130_ef_sc_hd__decap_12
XFILLER_125_39 VPWR VGND VPWR VGND sky130_ef_sc_hd__decap_12
XFILLER_64_1350 VGND VGND VPWR VPWR sky130_fd_sc_hd__decap_6
XTAP_TAPCELL_ROW_4_915 VGND VPWR sky130_fd_sc_hd__tapvpwrvgnd_1
XTAP_TAPCELL_ROW_4_904 VGND VPWR sky130_fd_sc_hd__tapvpwrvgnd_1
XFILLER_214_1085 VGND VGND VPWR VPWR sky130_fd_sc_hd__decap_6
XFILLER_151_1342 VPWR VGND VPWR VGND sky130_ef_sc_hd__decap_12
XFILLER_116_1462 VGND VGND VPWR VPWR sky130_fd_sc_hd__decap_6
XFILLER_112_1326 VPWR VGND VPWR VGND sky130_ef_sc_hd__decap_12
XFILLER_64_1394 VPWR VGND VPWR VGND sky130_ef_sc_hd__decap_12
XFILLER_18_15 VPWR VGND VPWR VGND sky130_ef_sc_hd__decap_12
XFILLER_25_1378 VGND VGND VPWR VPWR sky130_fd_sc_hd__decap_6
XFILLER_60_1258 VPWR VGND VPWR VGND sky130_ef_sc_hd__decap_12
XTAP_TAPCELL_ROW_184_1988 VGND VPWR sky130_fd_sc_hd__tapvpwrvgnd_1
XTAP_TAPCELL_ROW_184_1977 VGND VPWR sky130_fd_sc_hd__tapvpwrvgnd_1
XFILLER_151_1386 VPWR VGND VPWR VGND sky130_ef_sc_hd__decap_12
XFILLER_141_27 VPWR VGND VPWR VGND sky130_ef_sc_hd__decap_12
XPHY_EDGE_ROW_133_1_Left_352 VGND VGND VPWR VPWR sky130_fd_sc_hd__decap_3
XFILLER_186_1427 VGND VGND VPWR VPWR sky130_fd_sc_hd__fill_1
XFILLER_196_301 VGND VGND VPWR VPWR sky130_fd_sc_hd__decap_6
XFILLER_184_1173 VPWR VGND VPWR VGND sky130_ef_sc_hd__decap_12
XFILLER_180_1037 VPWR VGND VPWR VGND sky130_ef_sc_hd__decap_12
XFILLER_169_559 VGND VGND VPWR VPWR sky130_fd_sc_hd__fill_1
XFILLER_71_1310 VPWR VGND VPWR VGND sky130_ef_sc_hd__decap_12
XFILLER_212_699 VGND VGND VPWR VPWR sky130_fd_sc_hd__fill_1
XFILLER_196_345 VPWR VGND VPWR VGND sky130_ef_sc_hd__decap_12
XFILLER_75_1490 VGND VGND VPWR VPWR sky130_fd_sc_hd__decap_6
XPHY_EDGE_ROW_72_1_Right_658 VGND VGND VPWR VPWR sky130_fd_sc_hd__decap_3
XFILLER_71_1354 VPWR VGND VPWR VGND sky130_ef_sc_hd__decap_12
XFILLER_196_389 VPWR VGND VPWR VGND sky130_ef_sc_hd__decap_12
XFILLER_165_721 VGND VGND VPWR VPWR sky130_fd_sc_hd__decap_6
XFILLER_162_1482 VPWR VGND VPWR VGND sky130_ef_sc_hd__decap_12
XFILLER_123_1422 VPWR VGND VPWR VGND sky130_ef_sc_hd__decap_12
XFILLER_32_1338 VPWR VGND VPWR VGND sky130_ef_sc_hd__decap_12
Xclkload2 clknet_3_2_0_clk VGND VGND VPWR VPWR clkload2/X sky130_fd_sc_hd__clkbuf_8
XFILLER_165_765 VPWR VGND VPWR VGND sky130_ef_sc_hd__decap_12
XFILLER_123_1466 VPWR VGND VPWR VGND sky130_ef_sc_hd__decap_12
XFILLER_109_125 VGND VGND VPWR VPWR sky130_fd_sc_hd__fill_2
XFILLER_71_1398 VPWR VGND VPWR VGND sky130_ef_sc_hd__decap_12
XANTENNA__543__A2 _198_ VGND VGND VPWR VPWR sky130_fd_sc_hd__diode_2
XFILLER_197_1567 VGND VGND VPWR VPWR sky130_fd_sc_hd__fill_1
XFILLER_180_713 VPWR VGND VPWR VGND sky130_ef_sc_hd__decap_12
XFILLER_164_253 VPWR VGND VPWR VGND sky130_ef_sc_hd__decap_12
XFILLER_158_1518 VGND VGND VPWR VPWR sky130_fd_sc_hd__decap_6
XFILLER_180_757 VPWR VGND VPWR VGND sky130_ef_sc_hd__decap_12
XFILLER_156_1220 VPWR VGND VPWR VGND sky130_ef_sc_hd__decap_12
XTAP_TAPCELL_ROW_121_2_3766 VGND VPWR sky130_fd_sc_hd__tapvpwrvgnd_1
XFILLER_69_1272 VGND VGND VPWR VPWR sky130_fd_sc_hd__fill_1
XFILLER_191_1133 VPWR VGND VPWR VGND sky130_ef_sc_hd__decap_12
XTAP_TAPCELL_ROW_88_2_3549 VGND VPWR sky130_fd_sc_hd__tapvpwrvgnd_1
XFILLER_59_55 VGND VGND VPWR VPWR sky130_fd_sc_hd__fill_1
XFILLER_191_1177 VPWR VGND VPWR VGND sky130_ef_sc_hd__decap_12
XFILLER_82_1450 VPWR VGND VPWR VGND sky130_ef_sc_hd__decap_12
XFILLER_43_1434 VGND VGND VPWR VPWR sky130_fd_sc_hd__decap_6
XFILLER_219_221 VGND VGND VPWR VPWR sky130_fd_sc_hd__decap_3
XFILLER_134_1562 VPWR VGND VPWR VGND sky130_ef_sc_hd__decap_12
XFILLER_82_1494 VPWR VGND VPWR VGND sky130_ef_sc_hd__decap_12
XPHY_EDGE_ROW_65_1_Left_284 VGND VGND VPWR VPWR sky130_fd_sc_hd__decap_3
XFILLER_219_265 VPWR VGND VPWR VGND sky130_ef_sc_hd__decap_12
XFILLER_208_917 VGND VGND VPWR VPWR sky130_fd_sc_hd__decap_6
XFILLER_207_405 VPWR VGND VPWR VGND sky130_ef_sc_hd__decap_12
XFILLER_130_1426 VPWR VGND VPWR VGND sky130_ef_sc_hd__decap_12
XFILLER_43_1478 VPWR VGND VPWR VGND sky130_ef_sc_hd__decap_12
XFILLER_207_449 VPWR VGND VPWR VGND sky130_ef_sc_hd__decap_12
XFILLER_216_961 VPWR VGND VPWR VGND sky130_ef_sc_hd__decap_12
XFILLER_210_1483 VGND VGND VPWR VPWR sky130_fd_sc_hd__fill_1
XFILLER_128_1300 VGND VGND VPWR VPWR sky130_fd_sc_hd__fill_1
XFILLER_76_1232 VPWR VGND VPWR VGND sky130_ef_sc_hd__decap_12
XFILLER_199_161 VGND VGND VPWR VPWR sky130_fd_sc_hd__decap_6
XFILLER_188_813 VPWR VGND VPWR VGND sky130_ef_sc_hd__decap_12
XFILLER_131_93 VPWR VGND VPWR VGND sky130_ef_sc_hd__decap_12
XTAP_TAPCELL_ROW_202_2494 VGND VPWR sky130_fd_sc_hd__tapvpwrvgnd_1
XFILLER_202_121 VPWR VGND VPWR VGND sky130_ef_sc_hd__decap_12
XTAP_TAPCELL_ROW_202_2483 VGND VPWR sky130_fd_sc_hd__tapvpwrvgnd_1
XFILLER_167_1393 VGND VGND VPWR VPWR sky130_fd_sc_hd__decap_6
XFILLER_202_165 VPWR VGND VPWR VGND sky130_ef_sc_hd__decap_12
XTAP_TAPCELL_ROW_194_2273 VGND VPWR sky130_fd_sc_hd__tapvpwrvgnd_1
XTAP_TAPCELL_ROW_194_2262 VGND VPWR sky130_fd_sc_hd__tapvpwrvgnd_1
XFILLER_163_1257 VGND VGND VPWR VPWR sky130_fd_sc_hd__decap_3
XFILLER_93_1590 VPWR VGND VPWR VGND sky130_ef_sc_hd__decap_12
X_306_ net16 net142 net132 VGND VGND VPWR VPWR s_wdata\[13\] sky130_fd_sc_hd__a21o_1
XTAP_TAPCELL_ROW_219_2980 VGND VPWR sky130_fd_sc_hd__tapvpwrvgnd_1
XFILLER_198_1309 VGND VGND VPWR VPWR sky130_fd_sc_hd__decap_6
XFILLER_175_529 VPWR VGND VPWR VGND sky130_ef_sc_hd__decap_12
XFILLER_168_581 VGND VGND VPWR VPWR sky130_fd_sc_hd__decap_6
XFILLER_141_1522 VPWR VGND VPWR VGND sky130_ef_sc_hd__decap_12
XFILLER_54_1574 VGND VGND VPWR VPWR sky130_fd_sc_hd__decap_6
XTAP_TAPCELL_ROW_219_2991 VGND VPWR sky130_fd_sc_hd__tapvpwrvgnd_1
XFILLER_200_1129 VPWR VGND VPWR VGND sky130_ef_sc_hd__decap_12
XTAP_TAPCELL_ROW_190_2159 VGND VPWR sky130_fd_sc_hd__tapvpwrvgnd_1
XTAP_TAPCELL_ROW_190_2148 VGND VPWR sky130_fd_sc_hd__tapvpwrvgnd_1
XFILLER_141_1566 VPWR VGND VPWR VGND sky130_ef_sc_hd__decap_12
XFILLER_102_1506 VPWR VGND VPWR VGND sky130_ef_sc_hd__decap_12
XFILLER_50_1438 VPWR VGND VPWR VGND sky130_ef_sc_hd__decap_12
XTAP_TAPCELL_ROW_215_2877 VGND VPWR sky130_fd_sc_hd__tapvpwrvgnd_1
XTAP_TAPCELL_ROW_215_2866 VGND VPWR sky130_fd_sc_hd__tapvpwrvgnd_1
XTAP_TAPCELL_ROW_215_2855 VGND VPWR sky130_fd_sc_hd__tapvpwrvgnd_1
XFILLER_183_573 VPWR VGND VPWR VGND sky130_ef_sc_hd__decap_12
XFILLER_7_753 VGND VGND VPWR VPWR sky130_fd_sc_hd__decap_3
XFILLER_7_797 VPWR VGND VPWR VGND sky130_ef_sc_hd__decap_12
XTAP_TAPCELL_ROW_10_2_3046 VGND VPWR sky130_fd_sc_hd__tapvpwrvgnd_1
XFILLER_170_245 VGND VGND VPWR VPWR sky130_fd_sc_hd__decap_6
XFILLER_139_1440 VGND VGND VPWR VPWR sky130_fd_sc_hd__fill_1
XPHY_EDGE_ROW_8_2_Left_440 VGND VGND VPWR VPWR sky130_fd_sc_hd__decap_3
XPHY_EDGE_ROW_34_1_Right_620 VGND VGND VPWR VPWR sky130_fd_sc_hd__decap_3
XTAP_TAPCELL_ROW_188_2088 VGND VPWR sky130_fd_sc_hd__tapvpwrvgnd_1
XFILLER_174_1353 VPWR VGND VPWR VGND sky130_ef_sc_hd__decap_12
XFILLER_170_1217 VPWR VGND VPWR VGND sky130_ef_sc_hd__decap_12
XFILLER_170_289 VPWR VGND VPWR VGND sky130_ef_sc_hd__decap_12
XFILLER_130_109 VPWR VGND VPWR VGND sky130_ef_sc_hd__decap_12
XFILLER_48_1356 VGND VGND VPWR VPWR sky130_fd_sc_hd__fill_1
XTAP_TAPCELL_ROW_188_2099 VGND VPWR sky130_fd_sc_hd__tapvpwrvgnd_1
XFILLER_174_1397 VPWR VGND VPWR VGND sky130_ef_sc_hd__decap_12
XFILLER_211_1225 VGND VGND VPWR VPWR sky130_fd_sc_hd__decap_6
XFILLER_113_1602 VGND VGND VPWR VPWR sky130_fd_sc_hd__decap_3
XFILLER_61_1534 VPWR VGND VPWR VGND sky130_ef_sc_hd__decap_12
XFILLER_22_1518 VGND VGND VPWR VPWR sky130_fd_sc_hd__decap_6
XFILLER_61_1578 VPWR VGND VPWR VGND sky130_ef_sc_hd__decap_12
XFILLER_211_1269 VPWR VGND VPWR VGND sky130_ef_sc_hd__decap_12
XFILLER_1_51 VGND VGND VPWR VPWR sky130_fd_sc_hd__decap_4
XFILLER_20_1220 VPWR VGND VPWR VGND sky130_ef_sc_hd__decap_12
XFILLER_4_1483 VGND VGND VPWR VPWR sky130_fd_sc_hd__fill_1
XFILLER_209_1121 VPWR VGND VPWR VGND sky130_ef_sc_hd__decap_12
XFILLER_178_301 VGND VGND VPWR VPWR sky130_fd_sc_hd__decap_6
XFILLER_0_1369 VGND VGND VPWR VPWR sky130_fd_sc_hd__decap_3
XFILLER_52_126 VGND VGND VPWR VPWR sky130_fd_sc_hd__fill_1
XFILLER_205_1007 VGND VGND VPWR VPWR sky130_fd_sc_hd__fill_1
XFILLER_185_1493 VPWR VGND VPWR VGND sky130_ef_sc_hd__decap_12
XFILLER_181_1313 VPWR VGND VPWR VGND sky130_ef_sc_hd__decap_12
XANTENNA__606__CLK clknet_3_6_0_clk VGND VGND VPWR VPWR sky130_fd_sc_hd__diode_2
XFILLER_59_1496 VGND VGND VPWR VPWR sky130_fd_sc_hd__fill_1
XFILLER_194_805 VGND VGND VPWR VPWR sky130_fd_sc_hd__decap_6
XFILLER_181_1357 VPWR VGND VPWR VGND sky130_ef_sc_hd__decap_12
XFILLER_178_345 VPWR VGND VPWR VGND sky130_ef_sc_hd__decap_12
XFILLER_194_849 VPWR VGND VPWR VGND sky130_ef_sc_hd__decap_12
XFILLER_178_389 VPWR VGND VPWR VGND sky130_ef_sc_hd__decap_12
XFILLER_193_337 VPWR VGND VPWR VGND sky130_ef_sc_hd__decap_12
XTAP_TAPCELL_ROW_177_1792 VGND VPWR sky130_fd_sc_hd__tapvpwrvgnd_1
XTAP_TAPCELL_ROW_177_1781 VGND VPWR sky130_fd_sc_hd__tapvpwrvgnd_1
XANTENNA_fanout121_A net122 VGND VGND VPWR VPWR sky130_fd_sc_hd__diode_2
XFILLER_179_1231 VGND VGND VPWR VPWR sky130_fd_sc_hd__fill_1
XTAP_TAPCELL_ROW_173_1678 VGND VPWR sky130_fd_sc_hd__tapvpwrvgnd_1
XTAP_TAPCELL_ROW_173_1667 VGND VPWR sky130_fd_sc_hd__tapvpwrvgnd_1
XTAP_TAPCELL_ROW_106_2_3668 VGND VPWR sky130_fd_sc_hd__tapvpwrvgnd_1
XPHY_EDGE_ROW_115_2_Right_172 VGND VGND VPWR VPWR sky130_fd_sc_hd__decap_3
XTAP_TAPCELL_ROW_74_2_3457 VGND VPWR sky130_fd_sc_hd__tapvpwrvgnd_1
XFILLER_20_27 VGND VGND VPWR VPWR sky130_fd_sc_hd__fill_1
XFILLER_136_27 VGND VGND VPWR VPWR sky130_fd_sc_hd__fill_1
XFILLER_66_1412 VGND VGND VPWR VPWR sky130_fd_sc_hd__fill_1
XFILLER_192_1453 VPWR VGND VPWR VGND sky130_ef_sc_hd__decap_12
XFILLER_118_1524 VGND VGND VPWR VPWR sky130_fd_sc_hd__fill_1
XFILLER_216_1147 VGND VGND VPWR VPWR sky130_fd_sc_hd__fill_1
XFILLER_192_1497 VPWR VGND VPWR VGND sky130_ef_sc_hd__decap_12
XPHY_EDGE_ROW_168_Right_13 VGND VGND VPWR VPWR sky130_fd_sc_hd__decap_3
XFILLER_152_15 VPWR VGND VPWR VGND sky130_ef_sc_hd__decap_12
XFILLER_29_69 VGND VGND VPWR VPWR sky130_fd_sc_hd__decap_4
XFILLER_116_1270 VPWR VGND VPWR VGND sky130_ef_sc_hd__decap_12
XFILLER_99_1232 VPWR VGND VPWR VGND sky130_ef_sc_hd__decap_12
XFILLER_5_1225 VGND VGND VPWR VPWR sky130_fd_sc_hd__decap_6
XFILLER_5_1269 VPWR VGND VPWR VGND sky130_ef_sc_hd__decap_12
XFILLER_205_909 VPWR VGND VPWR VGND sky130_ef_sc_hd__decap_12
XFILLER_99_1298 VPWR VGND VPWR VGND sky130_ef_sc_hd__decap_12
XFILLER_204_419 VGND VGND VPWR VPWR sky130_fd_sc_hd__fill_1
XFILLER_188_109 VPWR VGND VPWR VGND sky130_ef_sc_hd__decap_12
XFILLER_77_1552 VGND VGND VPWR VPWR sky130_fd_sc_hd__fill_1
XFILLER_45_57 VPWR VGND VPWR VGND sky130_ef_sc_hd__decap_12
XFILLER_213_953 VPWR VGND VPWR VGND sky130_ef_sc_hd__decap_12
XFILLER_164_1533 VGND VGND VPWR VPWR sky130_fd_sc_hd__decap_6
XFILLER_197_665 VGND VGND VPWR VPWR sky130_fd_sc_hd__decap_6
XFILLER_196_153 VPWR VGND VPWR VGND sky130_ef_sc_hd__decap_12
XPHY_EDGE_ROW_177_Right_22 VGND VGND VPWR VPWR sky130_fd_sc_hd__decap_3
XFILLER_164_1577 VPWR VGND VPWR VGND sky130_ef_sc_hd__decap_12
XFILLER_200_625 VPWR VGND VPWR VGND sky130_ef_sc_hd__decap_12
XFILLER_131_3 VPWR VGND VPWR VGND sky130_ef_sc_hd__decap_12
XPHY_EDGE_ROW_73_1_Right_659 VGND VGND VPWR VPWR sky130_fd_sc_hd__decap_3
XFILLER_36_1282 VPWR VGND VPWR VGND sky130_ef_sc_hd__decap_12
XFILLER_200_669 VPWR VGND VPWR VGND sky130_ef_sc_hd__decap_12
XFILLER_196_197 VPWR VGND VPWR VGND sky130_ef_sc_hd__decap_12
XFILLER_201_1449 VGND VGND VPWR VPWR sky130_fd_sc_hd__decap_6
XFILLER_165_573 VPWR VGND VPWR VGND sky130_ef_sc_hd__decap_12
XFILLER_123_1274 VPWR VGND VPWR VGND sky130_ef_sc_hd__decap_12
XFILLER_6_29 VPWR VGND VPWR VGND sky130_ef_sc_hd__decap_12
XFILLER_158_1326 VPWR VGND VPWR VGND sky130_ef_sc_hd__decap_12
XFILLER_14_1580 VGND VGND VPWR VPWR sky130_fd_sc_hd__fill_1
XTAP_TAPCELL_ROW_210_2730 VGND VPWR sky130_fd_sc_hd__tapvpwrvgnd_1
XFILLER_193_55 VGND VGND VPWR VPWR sky130_fd_sc_hd__fill_1
XFILLER_136_1602 VGND VGND VPWR VPWR sky130_fd_sc_hd__decap_3
XFILLER_180_587 VGND VGND VPWR VPWR sky130_fd_sc_hd__fill_1
XTAP_TAPCELL_ROW_151_2_3961 VGND VPWR sky130_fd_sc_hd__tapvpwrvgnd_1
XFILLER_112_109 VPWR VGND VPWR VGND sky130_ef_sc_hd__decap_12
XFILLER_10_60 VPWR VGND VPWR VGND sky130_ef_sc_hd__decap_12
XPHY_EDGE_ROW_186_Right_31 VGND VGND VPWR VPWR sky130_fd_sc_hd__decap_3
XFILLER_171_1537 VPWR VGND VPWR VGND sky130_ef_sc_hd__decap_12
XFILLER_10_93 VGND VGND VPWR VPWR sky130_fd_sc_hd__fill_1
XFILLER_86_53 VPWR VGND VPWR VGND sky130_ef_sc_hd__decap_12
XTAP_TAPCELL_ROW_7_1006 VGND VPWR sky130_fd_sc_hd__tapvpwrvgnd_1
XFILLER_134_1370 VPWR VGND VPWR VGND sky130_ef_sc_hd__decap_12
XFILLER_86_97 VPWR VGND VPWR VGND sky130_ef_sc_hd__decap_12
XTAP_TAPCELL_ROW_7_1017 VGND VPWR sky130_fd_sc_hd__tapvpwrvgnd_1
XTAP_TAPCELL_ROW_7_1028 VGND VPWR sky130_fd_sc_hd__tapvpwrvgnd_1
XFILLER_212_1589 VGND VGND VPWR VPWR sky130_fd_sc_hd__decap_6
XFILLER_212_29 VPWR VGND VPWR VGND sky130_ef_sc_hd__decap_12
XTAP_TAPCELL_ROW_208_2681 VGND VPWR sky130_fd_sc_hd__tapvpwrvgnd_1
XTAP_TAPCELL_ROW_208_2670 VGND VPWR sky130_fd_sc_hd__tapvpwrvgnd_1
XFILLER_208_725 VPWR VGND VPWR VGND sky130_ef_sc_hd__decap_12
XTAP_TAPCELL_ROW_24_1_1065 VGND VPWR sky130_fd_sc_hd__tapvpwrvgnd_1
XFILLER_43_1286 VPWR VGND VPWR VGND sky130_ef_sc_hd__decap_12
XFILLER_208_769 VPWR VGND VPWR VGND sky130_ef_sc_hd__decap_12
XTAP_TAPCELL_ROW_204_2567 VGND VPWR sky130_fd_sc_hd__tapvpwrvgnd_1
XTAP_TAPCELL_ROW_204_2556 VGND VPWR sky130_fd_sc_hd__tapvpwrvgnd_1
XTAP_TAPCELL_ROW_204_2545 VGND VPWR sky130_fd_sc_hd__tapvpwrvgnd_1
XFILLER_169_1455 VGND VGND VPWR VPWR sky130_fd_sc_hd__fill_1
XTAP_TAPCELL_ROW_143_2_3909 VGND VPWR sky130_fd_sc_hd__tapvpwrvgnd_1
XFILLER_78_1338 VPWR VGND VPWR VGND sky130_ef_sc_hd__decap_12
XANTENNA__629__CLK clknet_3_3_0_clk VGND VGND VPWR VPWR sky130_fd_sc_hd__diode_2
XFILLER_34_104 VGND VGND VPWR VPWR sky130_fd_sc_hd__decap_4
XFILLER_207_279 VGND VGND VPWR VPWR sky130_fd_sc_hd__fill_1
XTAP_TAPCELL_ROW_196_2324 VGND VPWR sky130_fd_sc_hd__tapvpwrvgnd_1
XTAP_TAPCELL_ROW_196_2313 VGND VPWR sky130_fd_sc_hd__tapvpwrvgnd_1
XFILLER_203_441 VGND VGND VPWR VPWR sky130_fd_sc_hd__decap_6
XPHY_EDGE_ROW_195_Right_40 VGND VGND VPWR VPWR sky130_fd_sc_hd__decap_3
XTAP_TAPCELL_ROW_196_2335 VGND VPWR sky130_fd_sc_hd__tapvpwrvgnd_1
XFILLER_188_643 VGND VGND VPWR VPWR sky130_fd_sc_hd__fill_1
XFILLER_176_805 VGND VGND VPWR VPWR sky130_fd_sc_hd__decap_6
XFILLER_163_1065 VPWR VGND VPWR VGND sky130_ef_sc_hd__decap_12
XTAP_TAPCELL_ROW_217_2928 VGND VPWR sky130_fd_sc_hd__tapvpwrvgnd_1
XTAP_TAPCELL_ROW_217_2917 VGND VPWR sky130_fd_sc_hd__tapvpwrvgnd_1
XFILLER_203_485 VPWR VGND VPWR VGND sky130_ef_sc_hd__decap_12
XFILLER_176_849 VPWR VGND VPWR VGND sky130_ef_sc_hd__decap_12
XFILLER_15_1322 VGND VGND VPWR VPWR sky130_fd_sc_hd__decap_6
XFILLER_204_1073 VPWR VGND VPWR VGND sky130_ef_sc_hd__decap_12
XFILLER_198_1117 VPWR VGND VPWR VGND sky130_ef_sc_hd__decap_12
XFILLER_175_337 VPWR VGND VPWR VGND sky130_ef_sc_hd__decap_12
XFILLER_141_1330 VPWR VGND VPWR VGND sky130_ef_sc_hd__decap_12
XFILLER_106_1450 VPWR VGND VPWR VGND sky130_ef_sc_hd__decap_12
XFILLER_54_1382 VPWR VGND VPWR VGND sky130_ef_sc_hd__decap_12
XFILLER_190_307 VGND VGND VPWR VPWR sky130_fd_sc_hd__fill_1
XFILLER_106_1494 VPWR VGND VPWR VGND sky130_ef_sc_hd__decap_12
XFILLER_102_1314 VPWR VGND VPWR VGND sky130_ef_sc_hd__decap_12
XFILLER_89_1434 VGND VGND VPWR VPWR sky130_fd_sc_hd__decap_6
XFILLER_15_1366 VPWR VGND VPWR VGND sky130_ef_sc_hd__decap_12
XFILLER_50_1246 VPWR VGND VPWR VGND sky130_ef_sc_hd__decap_12
XTAP_TAPCELL_ROW_60_2_3365 VGND VPWR sky130_fd_sc_hd__tapvpwrvgnd_1
XFILLER_184_893 VPWR VGND VPWR VGND sky130_ef_sc_hd__decap_12
XFILLER_102_1358 VPWR VGND VPWR VGND sky130_ef_sc_hd__decap_12
XPHY_EDGE_ROW_100_2_Left_532 VGND VGND VPWR VPWR sky130_fd_sc_hd__decap_3
XFILLER_89_1478 VPWR VGND VPWR VGND sky130_ef_sc_hd__decap_12
XFILLER_7_561 VPWR VGND VPWR VGND sky130_ef_sc_hd__decap_12
XTAP_TAPCELL_ROW_59_2_3359 VGND VPWR sky130_fd_sc_hd__tapvpwrvgnd_1
XFILLER_217_1401 VPWR VGND VPWR VGND sky130_ef_sc_hd__decap_12
XTAP_TAPCELL_ROW_40_2_3241 VGND VPWR sky130_fd_sc_hd__tapvpwrvgnd_1
XFILLER_174_1161 VPWR VGND VPWR VGND sky130_ef_sc_hd__decap_12
XPHY_EDGE_ROW_35_1_Right_621 VGND VGND VPWR VPWR sky130_fd_sc_hd__decap_3
XFILLER_211_1033 VPWR VGND VPWR VGND sky130_ef_sc_hd__decap_12
XTAP_TAPCELL_ROW_181_1903 VGND VPWR sky130_fd_sc_hd__tapvpwrvgnd_1
XFILLER_152_1470 VPWR VGND VPWR VGND sky130_ef_sc_hd__decap_12
XFILLER_117_1590 VPWR VGND VPWR VGND sky130_ef_sc_hd__decap_12
XFILLER_113_1410 VPWR VGND VPWR VGND sky130_ef_sc_hd__decap_12
XTAP_TAPCELL_ROW_19_2_3100 VGND VPWR sky130_fd_sc_hd__tapvpwrvgnd_1
XFILLER_22_1326 VPWR VGND VPWR VGND sky130_ef_sc_hd__decap_12
XFILLER_26_1462 VGND VGND VPWR VPWR sky130_fd_sc_hd__decap_6
XFILLER_61_1342 VPWR VGND VPWR VGND sky130_ef_sc_hd__decap_12
XFILLER_187_1511 VGND VGND VPWR VPWR sky130_fd_sc_hd__fill_1
XTAP_TAPCELL_ROW_166_1482 VGND VPWR sky130_fd_sc_hd__tapvpwrvgnd_1
XTAP_TAPCELL_ROW_166_1471 VGND VPWR sky130_fd_sc_hd__tapvpwrvgnd_1
XTAP_TAPCELL_ROW_166_1460 VGND VPWR sky130_fd_sc_hd__tapvpwrvgnd_1
XFILLER_122_29 VPWR VGND VPWR VGND sky130_ef_sc_hd__decap_12
XFILLER_113_1454 VPWR VGND VPWR VGND sky130_ef_sc_hd__decap_12
XFILLER_2_1409 VPWR VGND VPWR VGND sky130_ef_sc_hd__decap_12
XFILLER_6_1589 VGND VGND VPWR VPWR sky130_fd_sc_hd__decap_6
XFILLER_61_1386 VPWR VGND VPWR VGND sky130_ef_sc_hd__decap_12
XFILLER_211_1077 VPWR VGND VPWR VGND sky130_ef_sc_hd__decap_12
XFILLER_148_1506 VPWR VGND VPWR VGND sky130_ef_sc_hd__decap_12
XFILLER_113_1498 VPWR VGND VPWR VGND sky130_ef_sc_hd__decap_12
XFILLER_96_1438 VPWR VGND VPWR VGND sky130_ef_sc_hd__decap_12
XFILLER_213_205 VPWR VGND VPWR VGND sky130_ef_sc_hd__decap_12
XFILLER_0_1133 VPWR VGND VPWR VGND sky130_ef_sc_hd__decap_12
XFILLER_213_249 VPWR VGND VPWR VGND sky130_ef_sc_hd__decap_12
XFILLER_181_1121 VPWR VGND VPWR VGND sky130_ef_sc_hd__decap_12
XFILLER_0_1177 VPWR VGND VPWR VGND sky130_ef_sc_hd__decap_12
XFILLER_15_27 VPWR VGND VPWR VGND sky130_ef_sc_hd__decap_12
XFILLER_210_923 VGND VGND VPWR VPWR sky130_fd_sc_hd__fill_1
XTAP_TAPCELL_ROW_179_1854 VGND VPWR sky130_fd_sc_hd__tapvpwrvgnd_1
XTAP_TAPCELL_ROW_179_1843 VGND VPWR sky130_fd_sc_hd__tapvpwrvgnd_1
XFILLER_179_665 VGND VGND VPWR VPWR sky130_fd_sc_hd__decap_6
XTAP_TAPCELL_ROW_179_1832 VGND VPWR sky130_fd_sc_hd__tapvpwrvgnd_1
XTAP_TAPCELL_ROW_49_1_1116 VGND VPWR sky130_fd_sc_hd__tapvpwrvgnd_1
XFILLER_194_613 VPWR VGND VPWR VGND sky130_ef_sc_hd__decap_12
XFILLER_178_153 VPWR VGND VPWR VGND sky130_ef_sc_hd__decap_12
XTAP_TAPCELL_ROW_175_1729 VGND VPWR sky130_fd_sc_hd__tapvpwrvgnd_1
XTAP_TAPCELL_ROW_175_1718 VGND VPWR sky130_fd_sc_hd__tapvpwrvgnd_1
XFILLER_194_657 VPWR VGND VPWR VGND sky130_ef_sc_hd__decap_12
XFILLER_178_197 VPWR VGND VPWR VGND sky130_ef_sc_hd__decap_12
XFILLER_124_1550 VPWR VGND VPWR VGND sky130_ef_sc_hd__decap_12
XFILLER_72_1482 VPWR VGND VPWR VGND sky130_ef_sc_hd__decap_12
XFILLER_31_15 VPWR VGND VPWR VGND sky130_ef_sc_hd__decap_12
XFILLER_33_1422 VPWR VGND VPWR VGND sky130_ef_sc_hd__decap_12
XFILLER_193_167 VGND VGND VPWR VPWR sky130_fd_sc_hd__fill_1
XFILLER_159_1602 VGND VGND VPWR VPWR sky130_fd_sc_hd__decap_3
XFILLER_147_15 VPWR VGND VPWR VGND sky130_ef_sc_hd__decap_12
XFILLER_124_1594 VGND VGND VPWR VPWR sky130_fd_sc_hd__decap_8
XFILLER_120_1414 VPWR VGND VPWR VGND sky130_ef_sc_hd__decap_12
XPHY_EDGE_ROW_32_2_Left_464 VGND VGND VPWR VPWR sky130_fd_sc_hd__decap_3
XFILLER_33_1466 VPWR VGND VPWR VGND sky130_ef_sc_hd__decap_12
XFILLER_181_329 VGND VGND VPWR VPWR sky130_fd_sc_hd__decap_6
XFILLER_68_1518 VGND VGND VPWR VPWR sky130_fd_sc_hd__decap_6
XTAP_TAPCELL_ROW_136_2_3863 VGND VPWR sky130_fd_sc_hd__tapvpwrvgnd_1
XPHY_EDGE_ROW_1_Right_1 VGND VGND VPWR VPWR sky130_fd_sc_hd__decap_3
XPHY_EDGE_ROW_116_2_Right_173 VGND VGND VPWR VPWR sky130_fd_sc_hd__decap_3
XFILLER_66_1220 VPWR VGND VPWR VGND sky130_ef_sc_hd__decap_12
Xoutput48 net149 VGND VGND VPWR VPWR bist_fail sky130_fd_sc_hd__buf_2
XFILLER_1_704 VPWR VGND VPWR VGND sky130_ef_sc_hd__decap_12
XFILLER_192_1261 VPWR VGND VPWR VGND sky130_ef_sc_hd__decap_12
XFILLER_153_1223 VPWR VGND VPWR VGND sky130_ef_sc_hd__decap_12
XFILLER_0_225 VGND VGND VPWR VPWR sky130_fd_sc_hd__decap_6
Xoutput59 net59 VGND VGND VPWR VPWR bist_fail_bits[11] sky130_fd_sc_hd__buf_2
XFILLER_163_69 VPWR VGND VPWR VGND sky130_ef_sc_hd__decap_12
XFILLER_131_1510 VPWR VGND VPWR VGND sky130_ef_sc_hd__decap_12
XFILLER_44_1562 VPWR VGND VPWR VGND sky130_ef_sc_hd__decap_12
XFILLER_131_1554 VPWR VGND VPWR VGND sky130_ef_sc_hd__decap_12
XFILLER_5_1033 VPWR VGND VPWR VGND sky130_ef_sc_hd__decap_12
XFILLER_40_1426 VPWR VGND VPWR VGND sky130_ef_sc_hd__decap_12
XFILLER_179_3 VPWR VGND VPWR VGND sky130_ef_sc_hd__decap_12
X_571_ clknet_3_2_0_clk _009_ VGND VGND VPWR VPWR u_ctrl.cmp_addr\[3\] sky130_fd_sc_hd__dfxtp_1
XFILLER_5_1077 VPWR VGND VPWR VGND sky130_ef_sc_hd__decap_12
XFILLER_16_126 VGND VGND VPWR VPWR sky130_fd_sc_hd__fill_1
XFILLER_38_1300 VGND VGND VPWR VPWR sky130_fd_sc_hd__fill_1
XFILLER_189_429 VPWR VGND VPWR VGND sky130_ef_sc_hd__decap_12
XTAP_TAPCELL_ROW_0_792 VGND VPWR sky130_fd_sc_hd__tapvpwrvgnd_1
XTAP_TAPCELL_ROW_0_781 VGND VPWR sky130_fd_sc_hd__tapvpwrvgnd_1
XANTENNA__555__A net136 VGND VGND VPWR VPWR sky130_fd_sc_hd__diode_2
XTAP_TAPCELL_ROW_0_770 VGND VPWR sky130_fd_sc_hd__tapvpwrvgnd_1
XFILLER_164_1341 VPWR VGND VPWR VGND sky130_ef_sc_hd__decap_12
XFILLER_72_77 VGND VGND VPWR VPWR sky130_fd_sc_hd__decap_6
XFILLER_31_118 VGND VGND VPWR VPWR sky130_fd_sc_hd__decap_4
XFILLER_213_783 VGND VGND VPWR VPWR sky130_fd_sc_hd__fill_1
XFILLER_201_945 VGND VGND VPWR VPWR sky130_fd_sc_hd__decap_6
XFILLER_197_473 VPWR VGND VPWR VGND sky130_ef_sc_hd__decap_12
XFILLER_188_77 VGND VGND VPWR VPWR sky130_fd_sc_hd__decap_6
XFILLER_164_1385 VPWR VGND VPWR VGND sky130_ef_sc_hd__decap_12
XFILLER_73_1268 VGND VGND VPWR VPWR sky130_fd_sc_hd__decap_4
XFILLER_201_989 VPWR VGND VPWR VGND sky130_ef_sc_hd__decap_12
XFILLER_200_433 VPWR VGND VPWR VGND sky130_ef_sc_hd__decap_12
XFILLER_199_1437 VPWR VGND VPWR VGND sky130_ef_sc_hd__decap_12
XFILLER_90_1582 VPWR VGND VPWR VGND sky130_ef_sc_hd__decap_12
XFILLER_51_1522 VPWR VGND VPWR VGND sky130_ef_sc_hd__decap_12
XFILLER_205_1393 VGND VGND VPWR VPWR sky130_fd_sc_hd__decap_6
XFILLER_201_1213 VPWR VGND VPWR VGND sky130_ef_sc_hd__decap_12
XFILLER_200_477 VPWR VGND VPWR VGND sky130_ef_sc_hd__decap_12
XFILLER_172_307 VGND VGND VPWR VPWR sky130_fd_sc_hd__fill_1
XFILLER_12_1506 VPWR VGND VPWR VGND sky130_ef_sc_hd__decap_12
XFILLER_51_1566 VPWR VGND VPWR VGND sky130_ef_sc_hd__decap_12
XFILLER_201_1257 VPWR VGND VPWR VGND sky130_ef_sc_hd__decap_12
XFILLER_184_189 VGND VGND VPWR VPWR sky130_fd_sc_hd__decap_6
XFILLER_166_893 VPWR VGND VPWR VGND sky130_ef_sc_hd__decap_12
XFILLER_181_841 VPWR VGND VPWR VGND sky130_ef_sc_hd__decap_12
XFILLER_4_531 VGND VGND VPWR VPWR sky130_fd_sc_hd__fill_1
XTAP_TAPCELL_ROW_185_2003 VGND VPWR sky130_fd_sc_hd__tapvpwrvgnd_1
XFILLER_137_81 VPWR VGND VPWR VGND sky130_ef_sc_hd__decap_12
XTAP_TAPCELL_ROW_25_2_3143 VGND VPWR sky130_fd_sc_hd__tapvpwrvgnd_1
XFILLER_49_1440 VGND VGND VPWR VPWR sky130_fd_sc_hd__fill_1
XTAP_TAPCELL_ROW_185_2025 VGND VPWR sky130_fd_sc_hd__tapvpwrvgnd_1
XTAP_TAPCELL_ROW_185_2014 VGND VPWR sky130_fd_sc_hd__tapvpwrvgnd_1
XFILLER_175_1481 VPWR VGND VPWR VGND sky130_ef_sc_hd__decap_12
XFILLER_171_1301 VPWR VGND VPWR VGND sky130_ef_sc_hd__decap_12
XFILLER_171_1345 VPWR VGND VPWR VGND sky130_ef_sc_hd__decap_12
XTAP_TAPCELL_ROW_206_2618 VGND VPWR sky130_fd_sc_hd__tapvpwrvgnd_1
XTAP_TAPCELL_ROW_206_2607 VGND VPWR sky130_fd_sc_hd__tapvpwrvgnd_1
XFILLER_0_781 VGND VGND VPWR VPWR sky130_fd_sc_hd__decap_3
XFILLER_23_1602 VGND VGND VPWR VPWR sky130_fd_sc_hd__decap_3
XFILLER_212_1353 VPWR VGND VPWR VGND sky130_ef_sc_hd__decap_12
XFILLER_208_533 VPWR VGND VPWR VGND sky130_ef_sc_hd__decap_12
XFILLER_212_1397 VPWR VGND VPWR VGND sky130_ef_sc_hd__decap_12
XPHY_EDGE_ROW_28_1_Left_247 VGND VGND VPWR VPWR sky130_fd_sc_hd__decap_3
Xu_sram.u_mem s_wdata\[0\] s_wdata\[1\] s_wdata\[2\] s_wdata\[3\] s_wdata\[4\] s_wdata\[5\]
+ s_wdata\[6\] s_wdata\[7\] s_wdata\[8\] s_wdata\[9\] s_wdata\[10\] s_wdata\[11\]
+ s_wdata\[12\] s_wdata\[13\] s_wdata\[14\] s_wdata\[15\] s_wdata\[16\] s_wdata\[17\]
+ s_wdata\[18\] s_wdata\[19\] s_wdata\[20\] s_wdata\[21\] s_wdata\[22\] s_wdata\[23\]
+ s_wdata\[24\] s_wdata\[25\] s_wdata\[26\] s_wdata\[27\] s_wdata\[28\] s_wdata\[29\]
+ s_wdata\[30\] s_wdata\[31\] s_addr\[0\] s_addr\[1\] s_addr\[2\] s_addr\[3\] s_addr\[4\]
+ s_addr\[5\] s_addr\[6\] s_addr\[7\] net158 net159 net160 net161 net162 net163 net164
+ net165 _004_ net166 _005_ clknet_3_2_0_clk clknet_3_7_0_clk net167 net168 net169
+ net170 net89 net100 net111 net114 net115 net116 net117 net118 net119 net120 net90
+ net91 net92 net93 net94 net95 net96 net97 net98 net99 net101 net102 net103 net104
+ net105 net106 net107 net108 net109 net110 net112 net113 u_sram.u_mem/dout1[0] u_sram.u_mem/dout1[1]
+ u_sram.u_mem/dout1[2] u_sram.u_mem/dout1[3] u_sram.u_mem/dout1[4] u_sram.u_mem/dout1[5]
+ u_sram.u_mem/dout1[6] u_sram.u_mem/dout1[7] u_sram.u_mem/dout1[8] u_sram.u_mem/dout1[9]
+ u_sram.u_mem/dout1[10] u_sram.u_mem/dout1[11] u_sram.u_mem/dout1[12] u_sram.u_mem/dout1[13]
+ u_sram.u_mem/dout1[14] u_sram.u_mem/dout1[15] u_sram.u_mem/dout1[16] u_sram.u_mem/dout1[17]
+ u_sram.u_mem/dout1[18] u_sram.u_mem/dout1[19] u_sram.u_mem/dout1[20] u_sram.u_mem/dout1[21]
+ u_sram.u_mem/dout1[22] u_sram.u_mem/dout1[23] u_sram.u_mem/dout1[24] u_sram.u_mem/dout1[25]
+ u_sram.u_mem/dout1[26] u_sram.u_mem/dout1[27] u_sram.u_mem/dout1[28] u_sram.u_mem/dout1[29]
+ u_sram.u_mem/dout1[30] u_sram.u_mem/dout1[31] VPWR VGND sky130_sram_1kbyte_1rw1r_32x256_8
XFILLER_211_709 VPWR VGND VPWR VGND sky130_ef_sc_hd__decap_12
XFILLER_182_1441 VPWR VGND VPWR VGND sky130_ef_sc_hd__decap_12
XFILLER_182_1485 VPWR VGND VPWR VGND sky130_ef_sc_hd__decap_12
XFILLER_176_613 VPWR VGND VPWR VGND sky130_ef_sc_hd__decap_12
XFILLER_94_3 VPWR VGND VPWR VGND sky130_ef_sc_hd__decap_12
XFILLER_203_293 VPWR VGND VPWR VGND sky130_ef_sc_hd__decap_12
XFILLER_176_657 VPWR VGND VPWR VGND sky130_ef_sc_hd__decap_12
XFILLER_175_167 VGND VGND VPWR VPWR sky130_fd_sc_hd__fill_1
XFILLER_89_1220 VPWR VGND VPWR VGND sky130_ef_sc_hd__decap_12
XPHY_EDGE_ROW_142_1_Left_361 VGND VGND VPWR VPWR sky130_fd_sc_hd__decap_3
XTAP_TAPCELL_ROW_122_2_3771 VGND VPWR sky130_fd_sc_hd__tapvpwrvgnd_1
XFILLER_89_1286 VPWR VGND VPWR VGND sky130_ef_sc_hd__decap_12
XFILLER_171_373 VPWR VGND VPWR VGND sky130_ef_sc_hd__decap_12
XTAP_TAPCELL_ROW_90_2_3560 VGND VPWR sky130_fd_sc_hd__tapvpwrvgnd_1
XTAP_TAPCELL_ROW_89_2_3554 VGND VPWR sky130_fd_sc_hd__tapvpwrvgnd_1
XFILLER_217_1231 VGND VGND VPWR VPWR sky130_fd_sc_hd__fill_1
XFILLER_193_1581 VPWR VGND VPWR VGND sky130_ef_sc_hd__decap_12
XFILLER_28_1524 VGND VGND VPWR VPWR sky130_fd_sc_hd__fill_1
XFILLER_219_809 VGND VGND VPWR VPWR sky130_fd_sc_hd__decap_3
XTAP_TAPCELL_ROW_168_1533 VGND VPWR sky130_fd_sc_hd__tapvpwrvgnd_1
XTAP_TAPCELL_ROW_168_1522 VGND VPWR sky130_fd_sc_hd__tapvpwrvgnd_1
XPHY_EDGE_ROW_36_1_Right_622 VGND VGND VPWR VPWR sky130_fd_sc_hd__decap_3
XTAP_TAPCELL_ROW_164_1408 VGND VPWR sky130_fd_sc_hd__tapvpwrvgnd_1
XFILLER_133_39 VPWR VGND VPWR VGND sky130_ef_sc_hd__decap_12
XTAP_TAPCELL_ROW_114_2_3719 VGND VPWR sky130_fd_sc_hd__tapvpwrvgnd_1
XTAP_TAPCELL_ROW_102_1_1221 VGND VPWR sky130_fd_sc_hd__tapvpwrvgnd_1
XTAP_TAPCELL_ROW_164_1419 VGND VPWR sky130_fd_sc_hd__tapvpwrvgnd_1
XFILLER_6_1353 VPWR VGND VPWR VGND sky130_ef_sc_hd__decap_12
XFILLER_26_1270 VPWR VGND VPWR VGND sky130_ef_sc_hd__decap_12
XTAP_TAPCELL_ROW_82_2_3508 VGND VPWR sky130_fd_sc_hd__tapvpwrvgnd_1
XFILLER_2_1217 VPWR VGND VPWR VGND sky130_ef_sc_hd__decap_12
XFILLER_6_1397 VPWR VGND VPWR VGND sky130_ef_sc_hd__decap_12
XFILLER_214_525 VGND VGND VPWR VPWR sky130_fd_sc_hd__decap_6
XFILLER_148_1314 VPWR VGND VPWR VGND sky130_ef_sc_hd__decap_12
XFILLER_96_1246 VPWR VGND VPWR VGND sky130_ef_sc_hd__decap_12
XFILLER_199_727 VGND VGND VPWR VPWR sky130_fd_sc_hd__fill_1
XFILLER_148_1358 VPWR VGND VPWR VGND sky130_ef_sc_hd__decap_12
XFILLER_214_569 VPWR VGND VPWR VGND sky130_ef_sc_hd__decap_12
XFILLER_195_933 VPWR VGND VPWR VGND sky130_ef_sc_hd__decap_12
XFILLER_179_473 VPWR VGND VPWR VGND sky130_ef_sc_hd__decap_12
XFILLER_194_421 VPWR VGND VPWR VGND sky130_ef_sc_hd__decap_12
XFILLER_202_1533 VGND VGND VPWR VPWR sky130_fd_sc_hd__decap_6
XFILLER_195_977 VPWR VGND VPWR VGND sky130_ef_sc_hd__decap_12
XPHY_EDGE_ROW_74_1_Left_293 VGND VGND VPWR VPWR sky130_fd_sc_hd__decap_3
XFILLER_202_1577 VPWR VGND VPWR VGND sky130_ef_sc_hd__decap_12
XFILLER_177_1009 VPWR VGND VPWR VGND sky130_ef_sc_hd__decap_12
XFILLER_166_189 VGND VGND VPWR VPWR sky130_fd_sc_hd__decap_6
XFILLER_159_1410 VPWR VGND VPWR VGND sky130_ef_sc_hd__decap_12
XFILLER_120_1244 VGND VGND VPWR VPWR sky130_fd_sc_hd__fill_1
XFILLER_5_328 VGND VGND VPWR VPWR sky130_fd_sc_hd__decap_8
XFILLER_33_1274 VPWR VGND VPWR VGND sky130_ef_sc_hd__decap_12
XFILLER_181_137 VPWR VGND VPWR VGND sky130_ef_sc_hd__decap_12
XFILLER_163_841 VPWR VGND VPWR VGND sky130_ef_sc_hd__decap_12
XFILLER_159_1454 VPWR VGND VPWR VGND sky130_ef_sc_hd__decap_12
XFILLER_68_1326 VPWR VGND VPWR VGND sky130_ef_sc_hd__decap_12
XTAP_TAPCELL_ROW_11_2_3051 VGND VPWR sky130_fd_sc_hd__tapvpwrvgnd_1
XFILLER_218_1017 VPWR VGND VPWR VGND sky130_ef_sc_hd__decap_12
XFILLER_46_1602 VGND VGND VPWR VPWR sky130_fd_sc_hd__decap_3
XFILLER_190_693 VGND VGND VPWR VPWR sky130_fd_sc_hd__decap_6
XFILLER_159_1498 VPWR VGND VPWR VGND sky130_ef_sc_hd__decap_12
XPHY_EDGE_ROW_117_2_Right_174 VGND VGND VPWR VPWR sky130_fd_sc_hd__decap_3
XFILLER_192_1091 VGND VGND VPWR VPWR sky130_fd_sc_hd__fill_1
XFILLER_107_51 VGND VGND VPWR VPWR sky130_fd_sc_hd__decap_4
XFILLER_7_1117 VGND VGND VPWR VPWR sky130_fd_sc_hd__decap_3
XTAP_TAPCELL_ROW_136_1_1289 VGND VPWR sky130_fd_sc_hd__tapvpwrvgnd_1
XFILLER_67_55 VGND VGND VPWR VPWR sky130_fd_sc_hd__fill_1
XFILLER_188_1105 VPWR VGND VPWR VGND sky130_ef_sc_hd__decap_12
XFILLER_40_1223 VPWR VGND VPWR VGND sky130_ef_sc_hd__decap_12
XFILLER_44_1370 VPWR VGND VPWR VGND sky130_ef_sc_hd__decap_12
XFILLER_188_1149 VPWR VGND VPWR VGND sky130_ef_sc_hd__decap_12
XFILLER_79_1422 VPWR VGND VPWR VGND sky130_ef_sc_hd__decap_12
X_623_ clknet_3_6_0_clk _057_ VGND VGND VPWR VPWR net81 sky130_fd_sc_hd__dfxtp_1
XFILLER_205_503 VGND VGND VPWR VPWR sky130_fd_sc_hd__fill_1
XFILLER_131_1384 VGND VGND VPWR VPWR sky130_fd_sc_hd__fill_1
XFILLER_79_1466 VPWR VGND VPWR VGND sky130_ef_sc_hd__decap_12
XANTENNA_input14_A func_wdata[11] VGND VGND VPWR VPWR sky130_fd_sc_hd__diode_2
XFILLER_217_385 VGND VGND VPWR VPWR sky130_fd_sc_hd__decap_6
X_554_ net52 u_ctrl.cmp_addr\[3\] net122 VGND VGND VPWR VPWR _251_ sky130_fd_sc_hd__mux2_1
XFILLER_189_237 VPWR VGND VPWR VGND sky130_ef_sc_hd__decap_12
X_485_ net135 _216_ VGND VGND VPWR VPWR _026_ sky130_fd_sc_hd__and2_1
XFILLER_207_1455 VGND VGND VPWR VPWR sky130_fd_sc_hd__fill_1
XFILLER_16_81 VGND VGND VPWR VPWR sky130_fd_sc_hd__decap_3
XFILLER_201_753 VPWR VGND VPWR VGND sky130_ef_sc_hd__decap_12
XFILLER_199_1201 VPWR VGND VPWR VGND sky130_ef_sc_hd__decap_12
XFILLER_198_793 VPWR VGND VPWR VGND sky130_ef_sc_hd__decap_12
XFILLER_197_281 VPWR VGND VPWR VGND sky130_ef_sc_hd__decap_12
XFILLER_201_797 VPWR VGND VPWR VGND sky130_ef_sc_hd__decap_12
XFILLER_199_1245 VPWR VGND VPWR VGND sky130_ef_sc_hd__decap_12
XTAP_TAPCELL_ROW_95_2_3597 VGND VPWR sky130_fd_sc_hd__tapvpwrvgnd_1
XFILLER_16_1450 VPWR VGND VPWR VGND sky130_ef_sc_hd__decap_12
XFILLER_51_1330 VPWR VGND VPWR VGND sky130_ef_sc_hd__decap_12
XFILLER_201_1021 VPWR VGND VPWR VGND sky130_ef_sc_hd__decap_12
XFILLER_199_1289 VPWR VGND VPWR VGND sky130_ef_sc_hd__decap_12
XTAP_TAPCELL_ROW_107_2_3673 VGND VPWR sky130_fd_sc_hd__tapvpwrvgnd_1
XFILLER_103_1442 VPWR VGND VPWR VGND sky130_ef_sc_hd__decap_12
XFILLER_12_1314 VPWR VGND VPWR VGND sky130_ef_sc_hd__decap_12
XFILLER_16_1494 VPWR VGND VPWR VGND sky130_ef_sc_hd__decap_12
XFILLER_201_1065 VPWR VGND VPWR VGND sky130_ef_sc_hd__decap_12
XFILLER_86_1426 VPWR VGND VPWR VGND sky130_ef_sc_hd__decap_12
XFILLER_12_1358 VPWR VGND VPWR VGND sky130_ef_sc_hd__decap_12
XFILLER_181_671 VGND VGND VPWR VPWR sky130_fd_sc_hd__fill_1
XFILLER_138_1538 VPWR VGND VPWR VGND sky130_ef_sc_hd__decap_12
XFILLER_218_1595 VGND VGND VPWR VPWR sky130_fd_sc_hd__fill_1
XFILLER_171_1175 VGND VGND VPWR VPWR sky130_fd_sc_hd__fill_1
XTAP_TAPCELL_ROW_100_2_3627 VGND VPWR sky130_fd_sc_hd__tapvpwrvgnd_1
XFILLER_94_121 VGND VGND VPWR VPWR sky130_fd_sc_hd__decap_6
XFILLER_23_1410 VPWR VGND VPWR VGND sky130_ef_sc_hd__decap_12
XFILLER_27_1590 VPWR VGND VPWR VGND sky130_ef_sc_hd__decap_12
XFILLER_62_1470 VPWR VGND VPWR VGND sky130_ef_sc_hd__decap_12
XFILLER_212_1161 VPWR VGND VPWR VGND sky130_ef_sc_hd__decap_12
XFILLER_209_853 VPWR VGND VPWR VGND sky130_ef_sc_hd__decap_12
XFILLER_114_1582 VPWR VGND VPWR VGND sky130_ef_sc_hd__decap_12
XFILLER_97_1522 VPWR VGND VPWR VGND sky130_ef_sc_hd__decap_12
XFILLER_3_1537 VPWR VGND VPWR VGND sky130_ef_sc_hd__decap_12
XFILLER_23_1454 VPWR VGND VPWR VGND sky130_ef_sc_hd__decap_12
XFILLER_209_897 VPWR VGND VPWR VGND sky130_ef_sc_hd__decap_12
XFILLER_208_363 VGND VGND VPWR VPWR sky130_fd_sc_hd__fill_1
XFILLER_97_1566 VPWR VGND VPWR VGND sky130_ef_sc_hd__decap_12
XFILLER_23_1498 VPWR VGND VPWR VGND sky130_ef_sc_hd__decap_12
XFILLER_58_1506 VPWR VGND VPWR VGND sky130_ef_sc_hd__decap_12
XFILLER_110_1468 VGND VGND VPWR VPWR sky130_fd_sc_hd__fill_1
XFILLER_211_517 VPWR VGND VPWR VGND sky130_ef_sc_hd__decap_12
XFILLER_177_933 VPWR VGND VPWR VGND sky130_ef_sc_hd__decap_12
XFILLER_176_421 VPWR VGND VPWR VGND sky130_ef_sc_hd__decap_12
XFILLER_143_1244 VPWR VGND VPWR VGND sky130_ef_sc_hd__decap_12
XFILLER_192_925 VPWR VGND VPWR VGND sky130_ef_sc_hd__decap_12
XFILLER_177_977 VPWR VGND VPWR VGND sky130_ef_sc_hd__decap_12
XFILLER_34_1550 VPWR VGND VPWR VGND sky130_ef_sc_hd__decap_12
XFILLER_178_1329 VPWR VGND VPWR VGND sky130_ef_sc_hd__decap_12
XFILLER_160_1580 VGND VGND VPWR VPWR sky130_fd_sc_hd__fill_1
XFILLER_69_1602 VGND VGND VPWR VPWR sky130_fd_sc_hd__decap_3
XFILLER_30_1414 VPWR VGND VPWR VGND sky130_ef_sc_hd__decap_12
XFILLER_34_1594 VGND VGND VPWR VPWR sky130_fd_sc_hd__decap_8
XFILLER_163_137 VGND VGND VPWR VPWR sky130_fd_sc_hd__decap_3
XFILLER_208_83 VGND VGND VPWR VPWR sky130_fd_sc_hd__fill_1
XFILLER_172_693 VGND VGND VPWR VPWR sky130_fd_sc_hd__decap_6
XFILLER_171_181 VPWR VGND VPWR VGND sky130_ef_sc_hd__decap_12
XFILLER_144_27 VGND VGND VPWR VPWR sky130_fd_sc_hd__fill_1
XFILLER_219_617 VPWR VGND VPWR VGND sky130_ef_sc_hd__decap_12
XFILLER_63_1256 VPWR VGND VPWR VGND sky130_ef_sc_hd__decap_12
XFILLER_8_1426 VPWR VGND VPWR VGND sky130_ef_sc_hd__decap_12
XANTENNA_input6_A func_addr[3] VGND VGND VPWR VPWR sky130_fd_sc_hd__diode_2
XFILLER_189_1425 VPWR VGND VPWR VGND sky130_ef_sc_hd__decap_12
XPHY_EDGE_ROW_37_1_Right_623 VGND VGND VPWR VPWR sky130_fd_sc_hd__decap_3
XFILLER_41_1510 VPWR VGND VPWR VGND sky130_ef_sc_hd__decap_12
XFILLER_160_15 VPWR VGND VPWR VGND sky130_ef_sc_hd__decap_12
XFILLER_6_1161 VPWR VGND VPWR VGND sky130_ef_sc_hd__decap_12
XFILLER_41_1554 VPWR VGND VPWR VGND sky130_ef_sc_hd__decap_12
XFILLER_189_1469 VPWR VGND VPWR VGND sky130_ef_sc_hd__decap_12
XTAP_TAPCELL_ROW_144_2_3914 VGND VPWR sky130_fd_sc_hd__tapvpwrvgnd_1
XTAP_TAPCELL_ROW_2_854 VGND VPWR sky130_fd_sc_hd__tapvpwrvgnd_1
XTAP_TAPCELL_ROW_2_843 VGND VPWR sky130_fd_sc_hd__tapvpwrvgnd_1
XFILLER_37_69 VPWR VGND VPWR VGND sky130_ef_sc_hd__decap_12
XFILLER_214_333 VPWR VGND VPWR VGND sky130_ef_sc_hd__decap_12
XFILLER_215_889 VGND VGND VPWR VPWR sky130_fd_sc_hd__decap_6
XFILLER_183_1057 VGND VGND VPWR VPWR sky130_fd_sc_hd__decap_6
XFILLER_214_377 VPWR VGND VPWR VGND sky130_ef_sc_hd__decap_12
XFILLER_53_57 VPWR VGND VPWR VGND sky130_ef_sc_hd__decap_12
XFILLER_195_741 VPWR VGND VPWR VGND sky130_ef_sc_hd__decap_12
XFILLER_179_281 VPWR VGND VPWR VGND sky130_ef_sc_hd__decap_12
XFILLER_169_57 VPWR VGND VPWR VGND sky130_ef_sc_hd__decap_12
XFILLER_161_1322 VGND VGND VPWR VPWR sky130_fd_sc_hd__decap_6
X_270_ u_ctrl.elem_idx\[2\] VGND VGND VPWR VPWR _069_ sky130_fd_sc_hd__inv_2
XFILLER_194_251 VGND VGND VPWR VPWR sky130_fd_sc_hd__fill_1
XFILLER_161_1366 VPWR VGND VPWR VGND sky130_ef_sc_hd__decap_12
XFILLER_202_1341 VPWR VGND VPWR VGND sky130_ef_sc_hd__decap_12
XFILLER_196_1429 VPWR VGND VPWR VGND sky130_ef_sc_hd__decap_12
XFILLER_195_785 VPWR VGND VPWR VGND sky130_ef_sc_hd__decap_12
XFILLER_182_413 VGND VGND VPWR VPWR sky130_fd_sc_hd__decap_6
XFILLER_211_3 VPWR VGND VPWR VGND sky130_ef_sc_hd__decap_12
XFILLER_202_1385 VPWR VGND VPWR VGND sky130_ef_sc_hd__decap_12
XFILLER_182_457 VPWR VGND VPWR VGND sky130_ef_sc_hd__decap_12
XFILLER_5_125 VPWR VGND VPWR VGND sky130_ef_sc_hd__decap_12
XANTENNA__325__A0 b_addr\[0\] VGND VGND VPWR VPWR sky130_fd_sc_hd__diode_2
XFILLER_5_169 VPWR VGND VPWR VGND sky130_ef_sc_hd__decap_12
XFILLER_190_1017 VPWR VGND VPWR VGND sky130_ef_sc_hd__decap_12
XFILLER_118_83 VGND VGND VPWR VPWR sky130_fd_sc_hd__fill_1
XFILLER_2_821 VGND VGND VPWR VPWR sky130_fd_sc_hd__fill_1
XFILLER_194_1197 VGND VGND VPWR VPWR sky130_fd_sc_hd__decap_6
XFILLER_78_65 VPWR VGND VPWR VGND sky130_ef_sc_hd__decap_12
XPHY_EDGE_ROW_118_2_Right_175 VGND VGND VPWR VPWR sky130_fd_sc_hd__decap_3
XFILLER_1_375 VGND VGND VPWR VPWR sky130_fd_sc_hd__fill_1
XFILLER_209_105 VGND VGND VPWR VPWR sky130_fd_sc_hd__decap_6
XFILLER_81_1378 VGND VGND VPWR VPWR sky130_fd_sc_hd__decap_6
XFILLER_76_121 VGND VGND VPWR VPWR sky130_fd_sc_hd__decap_6
XFILLER_213_1481 VPWR VGND VPWR VGND sky130_ef_sc_hd__decap_12
XFILLER_209_149 VPWR VGND VPWR VGND sky130_ef_sc_hd__decap_12
XFILLER_168_1509 VPWR VGND VPWR VGND sky130_ef_sc_hd__decap_12
XFILLER_94_53 VPWR VGND VPWR VGND sky130_ef_sc_hd__decap_12
XFILLER_91_113 VPWR VGND VPWR VGND sky130_ef_sc_hd__decap_12
XFILLER_217_193 VPWR VGND VPWR VGND sky130_ef_sc_hd__decap_12
XFILLER_94_97 VPWR VGND VPWR VGND sky130_ef_sc_hd__decap_12
XFILLER_79_1274 VPWR VGND VPWR VGND sky130_ef_sc_hd__decap_12
X_606_ clknet_3_6_0_clk _040_ VGND VGND VPWR VPWR net62 sky130_fd_sc_hd__dfxtp_1
XFILLER_206_867 VGND VGND VPWR VPWR sky130_fd_sc_hd__fill_1
X_537_ net151 _195_ net128 net137 _242_ VGND VGND VPWR VPWR _052_ sky130_fd_sc_hd__o311a_1
X_468_ net147 net92 VGND VGND VPWR VPWR _200_ sky130_fd_sc_hd__xor2_1
XFILLER_201_561 VPWR VGND VPWR VGND sky130_ef_sc_hd__decap_12
XFILLER_140_1406 VGND VGND VPWR VPWR sky130_fd_sc_hd__decap_6
XANTENNA__564__B1 net138 VGND VGND VPWR VPWR sky130_fd_sc_hd__diode_2
X_399_ _133_ _134_ _108_ VGND VGND VPWR VPWR _136_ sky130_fd_sc_hd__o21a_1
XFILLER_185_273 VGND VGND VPWR VPWR sky130_fd_sc_hd__decap_6
XFILLER_174_925 VPWR VGND VPWR VGND sky130_ef_sc_hd__decap_12
XFILLER_138_1302 VPWR VGND VPWR VGND sky130_ef_sc_hd__decap_12
XFILLER_103_1272 VGND VGND VPWR VPWR sky130_fd_sc_hd__fill_1
XTAP_TAPCELL_ROW_31_1_1080 VGND VPWR sky130_fd_sc_hd__tapvpwrvgnd_1
XFILLER_190_1595 VGND VGND VPWR VPWR sky130_fd_sc_hd__fill_1
XFILLER_151_1546 VGND VGND VPWR VPWR sky130_fd_sc_hd__decap_6
XTAP_TAPCELL_ROW_129_2_3816 VGND VPWR sky130_fd_sc_hd__tapvpwrvgnd_1
XTAP_TAPCELL_ROW_130_2_3822 VGND VPWR sky130_fd_sc_hd__tapvpwrvgnd_1
XFILLER_3_1301 VPWR VGND VPWR VGND sky130_ef_sc_hd__decap_12
XFILLER_7_1481 VGND VGND VPWR VPWR sky130_fd_sc_hd__decap_3
XFILLER_110_1232 VPWR VGND VPWR VGND sky130_ef_sc_hd__decap_12
XFILLER_97_1330 VPWR VGND VPWR VGND sky130_ef_sc_hd__decap_12
XFILLER_3_1345 VPWR VGND VPWR VGND sky130_ef_sc_hd__decap_12
XPHY_EDGE_ROW_41_2_Left_473 VGND VGND VPWR VPWR sky130_fd_sc_hd__decap_3
XFILLER_149_1442 VPWR VGND VPWR VGND sky130_ef_sc_hd__decap_12
XFILLER_58_1314 VPWR VGND VPWR VGND sky130_ef_sc_hd__decap_12
XFILLER_208_1005 VPWR VGND VPWR VGND sky130_ef_sc_hd__decap_12
XFILLER_130_29 VPWR VGND VPWR VGND sky130_ef_sc_hd__decap_12
XFILLER_58_1358 VPWR VGND VPWR VGND sky130_ef_sc_hd__decap_12
XFILLER_212_837 VPWR VGND VPWR VGND sky130_ef_sc_hd__decap_12
XFILLER_208_1049 VPWR VGND VPWR VGND sky130_ef_sc_hd__decap_12
XFILLER_145_1328 VGND VGND VPWR VPWR sky130_fd_sc_hd__fill_1
XFILLER_23_27 VGND VGND VPWR VPWR sky130_fd_sc_hd__decap_4
XFILLER_177_741 VPWR VGND VPWR VGND sky130_ef_sc_hd__decap_12
XFILLER_139_27 VPWR VGND VPWR VGND sky130_ef_sc_hd__decap_12
XFILLER_177_785 VPWR VGND VPWR VGND sky130_ef_sc_hd__decap_12
XFILLER_176_251 VGND VGND VPWR VPWR sky130_fd_sc_hd__fill_1
XFILLER_164_413 VGND VGND VPWR VPWR sky130_fd_sc_hd__decap_6
XFILLER_192_755 VGND VGND VPWR VPWR sky130_fd_sc_hd__fill_1
XFILLER_164_457 VPWR VGND VPWR VGND sky130_ef_sc_hd__decap_12
XFILLER_69_1410 VPWR VGND VPWR VGND sky130_ef_sc_hd__decap_12
XFILLER_30_1244 VGND VGND VPWR VPWR sky130_fd_sc_hd__fill_1
XFILLER_180_917 VGND VGND VPWR VPWR sky130_fd_sc_hd__decap_6
XFILLER_155_15 VPWR VGND VPWR VGND sky130_ef_sc_hd__decap_12
XFILLER_69_1454 VPWR VGND VPWR VGND sky130_ef_sc_hd__decap_12
XFILLER_219_1145 VGND VGND VPWR VPWR sky130_fd_sc_hd__decap_3
XFILLER_3_629 VGND VGND VPWR VPWR sky130_fd_sc_hd__decap_3
XFILLER_2_117 VGND VGND VPWR VPWR sky130_fd_sc_hd__decap_3
XFILLER_219_1189 VPWR VGND VPWR VGND sky130_ef_sc_hd__decap_12
XFILLER_215_1009 VPWR VGND VPWR VGND sky130_ef_sc_hd__decap_12
XFILLER_191_1337 VGND VGND VPWR VPWR sky130_fd_sc_hd__decap_6
XFILLER_156_1468 VGND VGND VPWR VPWR sky130_fd_sc_hd__fill_1
XPHY_EDGE_ROW_105_1_Left_324 VGND VGND VPWR VPWR sky130_fd_sc_hd__decap_3
XFILLER_69_1498 VPWR VGND VPWR VGND sky130_ef_sc_hd__decap_12
XTAP_TAPCELL_ROW_7_979 VGND VPWR sky130_fd_sc_hd__tapvpwrvgnd_1
XFILLER_58_121 VGND VGND VPWR VPWR sky130_fd_sc_hd__decap_6
XFILLER_189_1233 VPWR VGND VPWR VGND sky130_ef_sc_hd__decap_12
XFILLER_171_69 VPWR VGND VPWR VGND sky130_ef_sc_hd__decap_12
XPHY_EDGE_ROW_38_1_Right_624 VGND VGND VPWR VPWR sky130_fd_sc_hd__decap_3
XFILLER_207_609 VGND VGND VPWR VPWR sky130_fd_sc_hd__decap_6
XFILLER_104_41 VPWR VGND VPWR VGND sky130_ef_sc_hd__decap_12
XFILLER_73_113 VPWR VGND VPWR VGND sky130_ef_sc_hd__decap_12
XFILLER_185_1119 VGND VGND VPWR VPWR sky130_fd_sc_hd__fill_1
XFILLER_104_85 VPWR VGND VPWR VGND sky130_ef_sc_hd__decap_12
XFILLER_76_1414 VPWR VGND VPWR VGND sky130_ef_sc_hd__decap_12
XFILLER_41_1384 VGND VGND VPWR VPWR sky130_fd_sc_hd__fill_1
XFILLER_215_653 VPWR VGND VPWR VGND sky130_ef_sc_hd__decap_12
XFILLER_214_141 VPWR VGND VPWR VGND sky130_ef_sc_hd__decap_12
XFILLER_161_3 VPWR VGND VPWR VGND sky130_ef_sc_hd__decap_12
XFILLER_215_697 VPWR VGND VPWR VGND sky130_ef_sc_hd__decap_12
XFILLER_187_505 VPWR VGND VPWR VGND sky130_ef_sc_hd__decap_12
XFILLER_128_1526 VPWR VGND VPWR VGND sky130_ef_sc_hd__decap_12
X_322_ net33 net143 net134 VGND VGND VPWR VPWR s_wdata\[29\] sky130_fd_sc_hd__a21o_1
XANTENNA__563__A net136 VGND VGND VPWR VPWR sky130_fd_sc_hd__diode_2
XFILLER_167_273 VGND VGND VPWR VPWR sky130_fd_sc_hd__decap_6
XFILLER_126_1294 VGND VGND VPWR VPWR sky130_fd_sc_hd__decap_6
XFILLER_80_77 VGND VGND VPWR VPWR sky130_fd_sc_hd__decap_6
XFILLER_6_401 VPWR VGND VPWR VGND sky130_ef_sc_hd__decap_12
XFILLER_196_77 VGND VGND VPWR VPWR sky130_fd_sc_hd__decap_6
XFILLER_182_221 VPWR VGND VPWR VGND sky130_ef_sc_hd__decap_12
XFILLER_87_1510 VPWR VGND VPWR VGND sky130_ef_sc_hd__decap_12
XFILLER_6_445 VPWR VGND VPWR VGND sky130_ef_sc_hd__decap_12
XFILLER_13_1442 VPWR VGND VPWR VGND sky130_ef_sc_hd__decap_12
XFILLER_196_1259 VGND VGND VPWR VPWR sky130_fd_sc_hd__fill_1
XFILLER_183_777 VGND VGND VPWR VPWR sky130_fd_sc_hd__decap_6
XFILLER_182_265 VPWR VGND VPWR VGND sky130_ef_sc_hd__decap_12
XFILLER_129_93 VPWR VGND VPWR VGND sky130_ef_sc_hd__decap_12
XFILLER_100_1412 VGND VGND VPWR VPWR sky130_fd_sc_hd__fill_1
XFILLER_87_1554 VPWR VGND VPWR VGND sky130_ef_sc_hd__decap_12
XPHY_EDGE_ROW_37_1_Left_256 VGND VGND VPWR VPWR sky130_fd_sc_hd__decap_3
XFILLER_48_1538 VPWR VGND VPWR VGND sky130_ef_sc_hd__decap_12
XFILLER_145_81 VPWR VGND VPWR VGND sky130_ef_sc_hd__decap_12
XFILLER_133_1232 VPWR VGND VPWR VGND sky130_ef_sc_hd__decap_12
XPHY_EDGE_ROW_119_2_Right_176 VGND VGND VPWR VPWR sky130_fd_sc_hd__decap_3
XTAP_TAPCELL_ROW_115_2_3724 VGND VPWR sky130_fd_sc_hd__tapvpwrvgnd_1
XFILLER_219_981 VPWR VGND VPWR VGND sky130_ef_sc_hd__decap_12
XFILLER_168_1317 VPWR VGND VPWR VGND sky130_ef_sc_hd__decap_12
XFILLER_133_1298 VPWR VGND VPWR VGND sky130_ef_sc_hd__decap_12
XFILLER_24_1582 VPWR VGND VPWR VGND sky130_ef_sc_hd__decap_12
XFILLER_111_1552 VGND VGND VPWR VPWR sky130_fd_sc_hd__fill_1
XFILLER_209_1325 VPWR VGND VPWR VGND sky130_ef_sc_hd__decap_12
XPHY_EDGE_ROW_151_1_Left_370 VGND VGND VPWR VPWR sky130_fd_sc_hd__decap_3
XFILLER_20_1468 VGND VGND VPWR VPWR sky130_fd_sc_hd__fill_1
XTAP_TAPCELL_ROW_199_2399 VGND VPWR sky130_fd_sc_hd__tapvpwrvgnd_1
XFILLER_209_1369 VPWR VGND VPWR VGND sky130_ef_sc_hd__decap_12
XFILLER_166_1085 VGND VGND VPWR VPWR sky130_fd_sc_hd__decap_6
XFILLER_144_1350 VGND VGND VPWR VPWR sky130_fd_sc_hd__decap_6
XFILLER_92_1282 VPWR VGND VPWR VGND sky130_ef_sc_hd__decap_12
XFILLER_53_1244 VPWR VGND VPWR VGND sky130_ef_sc_hd__decap_12
XFILLER_202_881 VPWR VGND VPWR VGND sky130_ef_sc_hd__decap_12
XFILLER_179_1413 VPWR VGND VPWR VGND sky130_ef_sc_hd__decap_12
XFILLER_144_1394 VPWR VGND VPWR VGND sky130_ef_sc_hd__decap_12
XTAP_TAPCELL_ROW_8_2_3032 VGND VPWR sky130_fd_sc_hd__tapvpwrvgnd_1
XFILLER_201_391 VGND VGND VPWR VPWR sky130_fd_sc_hd__fill_1
XFILLER_174_755 VGND VGND VPWR VPWR sky130_fd_sc_hd__fill_1
XFILLER_140_1258 VPWR VGND VPWR VGND sky130_ef_sc_hd__decap_12
XFILLER_105_1378 VGND VGND VPWR VPWR sky130_fd_sc_hd__decap_6
XFILLER_70_1580 VGND VGND VPWR VPWR sky130_fd_sc_hd__fill_1
XFILLER_179_1457 VPWR VGND VPWR VGND sky130_ef_sc_hd__decap_12
XTAP_TAPCELL_ROW_62_1_1141 VGND VPWR sky130_fd_sc_hd__tapvpwrvgnd_1
XFILLER_173_1001 VGND VGND VPWR VPWR sky130_fd_sc_hd__decap_6
XFILLER_170_961 VPWR VGND VPWR VGND sky130_ef_sc_hd__decap_12
XFILLER_216_1329 VPWR VGND VPWR VGND sky130_ef_sc_hd__decap_12
XFILLER_173_1045 VPWR VGND VPWR VGND sky130_ef_sc_hd__decap_12
XFILLER_9_1510 VPWR VGND VPWR VGND sky130_ef_sc_hd__decap_12
XFILLER_173_1089 VPWR VGND VPWR VGND sky130_ef_sc_hd__decap_12
XFILLER_155_1490 VGND VGND VPWR VPWR sky130_fd_sc_hd__decap_6
XFILLER_151_1310 VPWR VGND VPWR VGND sky130_ef_sc_hd__decap_12
XTAP_TAPCELL_ROW_4_916 VGND VPWR sky130_fd_sc_hd__tapvpwrvgnd_1
XTAP_TAPCELL_ROW_4_905 VGND VPWR sky130_fd_sc_hd__tapvpwrvgnd_1
XFILLER_9_1554 VPWR VGND VPWR VGND sky130_ef_sc_hd__decap_12
XFILLER_205_51 VGND VGND VPWR VPWR sky130_fd_sc_hd__decap_4
XFILLER_151_1354 VPWR VGND VPWR VGND sky130_ef_sc_hd__decap_12
XTAP_TAPCELL_ROW_150_1_1317 VGND VPWR sky130_fd_sc_hd__tapvpwrvgnd_1
XTAP_TAPCELL_ROW_184_1989 VGND VPWR sky130_fd_sc_hd__tapvpwrvgnd_1
XTAP_TAPCELL_ROW_184_1978 VGND VPWR sky130_fd_sc_hd__tapvpwrvgnd_1
XFILLER_151_1398 VPWR VGND VPWR VGND sky130_ef_sc_hd__decap_12
XFILLER_112_1338 VPWR VGND VPWR VGND sky130_ef_sc_hd__decap_12
XFILLER_18_27 VGND VGND VPWR VPWR sky130_fd_sc_hd__fill_1
XFILLER_55_113 VPWR VGND VPWR VGND sky130_ef_sc_hd__decap_12
XFILLER_141_39 VPWR VGND VPWR VGND sky130_ef_sc_hd__decap_12
XFILLER_3_1175 VGND VGND VPWR VPWR sky130_fd_sc_hd__fill_1
XFILLER_212_601 VPWR VGND VPWR VGND sky130_ef_sc_hd__decap_12
XFILLER_184_1141 VGND VGND VPWR VPWR sky130_fd_sc_hd__decap_6
XFILLER_169_505 VPWR VGND VPWR VGND sky130_ef_sc_hd__decap_12
XFILLER_149_1272 VGND VGND VPWR VPWR sky130_fd_sc_hd__fill_1
XFILLER_34_15 VPWR VGND VPWR VGND sky130_ef_sc_hd__decap_12
XFILLER_212_645 VPWR VGND VPWR VGND sky130_ef_sc_hd__decap_12
XFILLER_211_111 VGND VGND VPWR VPWR sky130_fd_sc_hd__fill_1
XFILLER_184_1185 VPWR VGND VPWR VGND sky130_ef_sc_hd__decap_12
XFILLER_180_1005 VPWR VGND VPWR VGND sky130_ef_sc_hd__decap_12
XFILLER_196_357 VGND VGND VPWR VPWR sky130_fd_sc_hd__decap_6
XFILLER_180_1049 VPWR VGND VPWR VGND sky130_ef_sc_hd__decap_12
XFILLER_162_1450 VPWR VGND VPWR VGND sky130_ef_sc_hd__decap_12
XFILLER_71_1322 VGND VGND VPWR VPWR sky130_fd_sc_hd__decap_6
XANTENNA__383__A b_addr\[1\] VGND VGND VPWR VPWR sky130_fd_sc_hd__diode_2
XFILLER_162_1494 VPWR VGND VPWR VGND sky130_ef_sc_hd__decap_12
XFILLER_123_1434 VGND VGND VPWR VPWR sky130_fd_sc_hd__decap_6
XFILLER_71_1366 VPWR VGND VPWR VGND sky130_ef_sc_hd__decap_12
Xclkload3 clknet_3_4_0_clk VGND VGND VPWR VPWR clkload3/Y sky130_fd_sc_hd__inv_8
XFILLER_197_1513 VPWR VGND VPWR VGND sky130_ef_sc_hd__decap_12
XFILLER_164_221 VPWR VGND VPWR VGND sky130_ef_sc_hd__decap_12
XFILLER_123_1478 VPWR VGND VPWR VGND sky130_ef_sc_hd__decap_12
XANTENNA__543__A3 net129 VGND VGND VPWR VPWR sky130_fd_sc_hd__diode_2
XFILLER_165_777 VGND VGND VPWR VPWR sky130_fd_sc_hd__decap_6
XFILLER_164_265 VPWR VGND VPWR VGND sky130_ef_sc_hd__decap_12
XFILLER_180_725 VPWR VGND VPWR VGND sky130_ef_sc_hd__decap_12
XTAP_TAPCELL_ROW_121_2_3767 VGND VPWR sky130_fd_sc_hd__tapvpwrvgnd_1
XFILLER_195_1281 VGND VGND VPWR VPWR sky130_fd_sc_hd__decap_6
XFILLER_191_1101 VPWR VGND VPWR VGND sky130_ef_sc_hd__decap_12
XFILLER_180_769 VPWR VGND VPWR VGND sky130_ef_sc_hd__decap_12
XFILLER_156_1232 VPWR VGND VPWR VGND sky130_ef_sc_hd__decap_12
XFILLER_191_1145 VPWR VGND VPWR VGND sky130_ef_sc_hd__decap_12
XTAP_TAPCELL_ROW_101_2_3632 VGND VPWR sky130_fd_sc_hd__tapvpwrvgnd_1
XFILLER_191_1189 VPWR VGND VPWR VGND sky130_ef_sc_hd__decap_12
XFILLER_82_1462 VGND VGND VPWR VPWR sky130_fd_sc_hd__decap_6
XFILLER_134_1574 VGND VGND VPWR VPWR sky130_fd_sc_hd__decap_6
XFILLER_115_51 VGND VGND VPWR VPWR sky130_fd_sc_hd__decap_4
XFILLER_207_417 VPWR VGND VPWR VGND sky130_ef_sc_hd__decap_12
XFILLER_130_1438 VPWR VGND VPWR VGND sky130_ef_sc_hd__decap_12
XFILLER_75_55 VGND VGND VPWR VPWR sky130_fd_sc_hd__fill_1
XFILLER_219_277 VGND VGND VPWR VPWR sky130_fd_sc_hd__decap_3
XFILLER_189_1063 VGND VGND VPWR VPWR sky130_fd_sc_hd__fill_1
XPHY_EDGE_ROW_39_1_Right_625 VGND VGND VPWR VPWR sky130_fd_sc_hd__decap_3
XFILLER_216_973 VGND VGND VPWR VPWR sky130_fd_sc_hd__decap_6
XFILLER_61_105 VGND VGND VPWR VPWR sky130_fd_sc_hd__decap_6
XFILLER_215_461 VPWR VGND VPWR VGND sky130_ef_sc_hd__decap_12
XFILLER_188_825 VPWR VGND VPWR VGND sky130_ef_sc_hd__decap_12
XFILLER_76_1244 VGND VGND VPWR VPWR sky130_fd_sc_hd__fill_1
XFILLER_206_1509 VPWR VGND VPWR VGND sky130_ef_sc_hd__decap_12
XTAP_TAPCELL_ROW_202_2495 VGND VPWR sky130_fd_sc_hd__tapvpwrvgnd_1
XFILLER_202_133 VGND VGND VPWR VPWR sky130_fd_sc_hd__decap_6
XTAP_TAPCELL_ROW_202_2484 VGND VPWR sky130_fd_sc_hd__tapvpwrvgnd_1
XFILLER_187_335 VGND VGND VPWR VPWR sky130_fd_sc_hd__fill_1
XFILLER_128_1356 VGND VGND VPWR VPWR sky130_fd_sc_hd__fill_1
XTAP_TAPCELL_ROW_194_2263 VGND VPWR sky130_fd_sc_hd__tapvpwrvgnd_1
XFILLER_188_869 VPWR VGND VPWR VGND sky130_ef_sc_hd__decap_12
X_305_ net15 net142 net132 VGND VGND VPWR VPWR s_wdata\[12\] sky130_fd_sc_hd__a21o_1
XTAP_TAPCELL_ROW_219_2970 VGND VPWR sky130_fd_sc_hd__tapvpwrvgnd_1
XFILLER_202_177 VPWR VGND VPWR VGND sky130_ef_sc_hd__decap_12
XTAP_TAPCELL_ROW_194_2274 VGND VPWR sky130_fd_sc_hd__tapvpwrvgnd_1
XFILLER_141_1534 VPWR VGND VPWR VGND sky130_ef_sc_hd__decap_12
XFILLER_50_1406 VGND VGND VPWR VPWR sky130_fd_sc_hd__decap_6
XTAP_TAPCELL_ROW_219_2992 VGND VPWR sky130_fd_sc_hd__tapvpwrvgnd_1
XTAP_TAPCELL_ROW_219_2981 VGND VPWR sky130_fd_sc_hd__tapvpwrvgnd_1
XTAP_TAPCELL_ROW_190_2149 VGND VPWR sky130_fd_sc_hd__tapvpwrvgnd_1
XFILLER_183_541 VPWR VGND VPWR VGND sky130_ef_sc_hd__decap_12
XFILLER_141_1578 VPWR VGND VPWR VGND sky130_ef_sc_hd__decap_12
XFILLER_102_1518 VGND VGND VPWR VPWR sky130_fd_sc_hd__decap_6
XTAP_TAPCELL_ROW_215_2878 VGND VPWR sky130_fd_sc_hd__tapvpwrvgnd_1
XTAP_TAPCELL_ROW_215_2867 VGND VPWR sky130_fd_sc_hd__tapvpwrvgnd_1
XTAP_TAPCELL_ROW_215_2856 VGND VPWR sky130_fd_sc_hd__tapvpwrvgnd_1
XFILLER_6_231 VPWR VGND VPWR VGND sky130_ef_sc_hd__decap_12
XFILLER_6_253 VGND VGND VPWR VPWR sky130_fd_sc_hd__decap_3
XFILLER_183_585 VPWR VGND VPWR VGND sky130_ef_sc_hd__decap_12
XFILLER_100_1220 VPWR VGND VPWR VGND sky130_ef_sc_hd__decap_12
XFILLER_13_1272 VGND VGND VPWR VPWR sky130_fd_sc_hd__fill_1
XFILLER_48_1302 VPWR VGND VPWR VGND sky130_ef_sc_hd__decap_12
XFILLER_87_1384 VGND VGND VPWR VPWR sky130_fd_sc_hd__fill_1
XTAP_TAPCELL_ROW_188_2089 VGND VPWR sky130_fd_sc_hd__tapvpwrvgnd_1
XFILLER_174_1365 VGND VGND VPWR VPWR sky130_fd_sc_hd__decap_6
XFILLER_139_1496 VGND VGND VPWR VPWR sky130_fd_sc_hd__fill_1
XFILLER_170_1229 VPWR VGND VPWR VGND sky130_ef_sc_hd__decap_12
XFILLER_61_1546 VGND VGND VPWR VPWR sky130_fd_sc_hd__decap_6
XANTENNA__468__A net147 VGND VGND VPWR VPWR sky130_fd_sc_hd__diode_2
XFILLER_37_113 VGND VGND VPWR VPWR sky130_fd_sc_hd__decap_4
XFILLER_20_1232 VPWR VGND VPWR VGND sky130_ef_sc_hd__decap_12
XFILLER_207_951 VGND VGND VPWR VPWR sky130_fd_sc_hd__fill_1
XFILLER_168_1147 VGND VGND VPWR VPWR sky130_fd_sc_hd__fill_1
XFILLER_94_1300 VGND VGND VPWR VPWR sky130_fd_sc_hd__fill_1
XFILLER_209_1133 VPWR VGND VPWR VGND sky130_ef_sc_hd__decap_12
XFILLER_146_1412 VGND VGND VPWR VPWR sky130_fd_sc_hd__fill_1
XFILLER_59_1442 VPWR VGND VPWR VGND sky130_ef_sc_hd__decap_12
XFILLER_181_1325 VPWR VGND VPWR VGND sky130_ef_sc_hd__decap_12
XFILLER_55_1328 VGND VGND VPWR VPWR sky130_fd_sc_hd__fill_1
XFILLER_209_1177 VPWR VGND VPWR VGND sky130_ef_sc_hd__decap_12
XFILLER_181_1369 VPWR VGND VPWR VGND sky130_ef_sc_hd__decap_12
XFILLER_178_357 VGND VGND VPWR VPWR sky130_fd_sc_hd__decap_6
XFILLER_193_305 VPWR VGND VPWR VGND sky130_ef_sc_hd__decap_12
XTAP_TAPCELL_ROW_177_1771 VGND VPWR sky130_fd_sc_hd__tapvpwrvgnd_1
XFILLER_193_349 VPWR VGND VPWR VGND sky130_ef_sc_hd__decap_12
XTAP_TAPCELL_ROW_177_1793 VGND VPWR sky130_fd_sc_hd__tapvpwrvgnd_1
XTAP_TAPCELL_ROW_177_1782 VGND VPWR sky130_fd_sc_hd__tapvpwrvgnd_1
XTAP_TAPCELL_ROW_173_1668 VGND VPWR sky130_fd_sc_hd__tapvpwrvgnd_1
XTAP_TAPCELL_ROW_173_1657 VGND VPWR sky130_fd_sc_hd__tapvpwrvgnd_1
XTAP_TAPCELL_ROW_106_2_3669 VGND VPWR sky130_fd_sc_hd__tapvpwrvgnd_1
XFILLER_179_1287 VGND VGND VPWR VPWR sky130_fd_sc_hd__fill_1
XTAP_TAPCELL_ROW_173_1679 VGND VPWR sky130_fd_sc_hd__tapvpwrvgnd_1
XFILLER_192_1421 VGND VGND VPWR VPWR sky130_fd_sc_hd__decap_6
XFILLER_157_1552 VGND VGND VPWR VPWR sky130_fd_sc_hd__fill_1
XTAP_TAPCELL_ROW_74_2_3458 VGND VPWR sky130_fd_sc_hd__tapvpwrvgnd_1
XFILLER_192_1465 VPWR VGND VPWR VGND sky130_ef_sc_hd__decap_12
XFILLER_66_1468 VGND VGND VPWR VPWR sky130_fd_sc_hd__fill_1
XFILLER_216_83 VGND VGND VPWR VPWR sky130_fd_sc_hd__fill_1
XFILLER_29_15 VPWR VGND VPWR VGND sky130_ef_sc_hd__decap_12
XFILLER_152_27 VGND VGND VPWR VPWR sky130_fd_sc_hd__fill_1
XFILLER_9_1384 VGND VGND VPWR VPWR sky130_fd_sc_hd__fill_1
XFILLER_116_1282 VPWR VGND VPWR VGND sky130_ef_sc_hd__decap_12
XFILLER_28_102 VPWR VGND VPWR VGND sky130_ef_sc_hd__decap_12
XFILLER_186_1203 VGND VGND VPWR VPWR sky130_fd_sc_hd__fill_1
XFILLER_99_1244 VPWR VGND VPWR VGND sky130_ef_sc_hd__decap_12
XFILLER_43_105 VGND VGND VPWR VPWR sky130_fd_sc_hd__decap_6
XFILLER_213_921 VPWR VGND VPWR VGND sky130_ef_sc_hd__decap_12
XFILLER_45_69 VGND VGND VPWR VPWR sky130_fd_sc_hd__decap_8
XFILLER_213_965 VPWR VGND VPWR VGND sky130_ef_sc_hd__decap_12
XFILLER_38_1526 VPWR VGND VPWR VGND sky130_ef_sc_hd__decap_12
XFILLER_212_475 VGND VGND VPWR VPWR sky130_fd_sc_hd__fill_1
XFILLER_196_121 VPWR VGND VPWR VGND sky130_ef_sc_hd__decap_12
XFILLER_169_335 VGND VGND VPWR VPWR sky130_fd_sc_hd__fill_1
XFILLER_164_1589 VGND VGND VPWR VPWR sky130_fd_sc_hd__decap_6
XFILLER_200_637 VGND VGND VPWR VPWR sky130_fd_sc_hd__decap_6
XFILLER_196_165 VPWR VGND VPWR VGND sky130_ef_sc_hd__decap_12
XFILLER_185_839 VGND VGND VPWR VPWR sky130_fd_sc_hd__fill_1
XPHY_EDGE_ROW_129_2_Left_561 VGND VGND VPWR VPWR sky130_fd_sc_hd__decap_3
XFILLER_123_1220 VPWR VGND VPWR VGND sky130_ef_sc_hd__decap_12
XFILLER_61_57 VPWR VGND VPWR VGND sky130_ef_sc_hd__decap_12
XFILLER_177_57 VPWR VGND VPWR VGND sky130_ef_sc_hd__decap_12
XFILLER_36_1294 VGND VGND VPWR VPWR sky130_fd_sc_hd__decap_6
XFILLER_197_1343 VGND VGND VPWR VPWR sky130_fd_sc_hd__fill_1
XFILLER_165_541 VPWR VGND VPWR VGND sky130_ef_sc_hd__decap_12
XFILLER_124_3 VPWR VGND VPWR VGND sky130_ef_sc_hd__decap_12
XFILLER_123_1286 VPWR VGND VPWR VGND sky130_ef_sc_hd__decap_12
XFILLER_180_533 VPWR VGND VPWR VGND sky130_ef_sc_hd__decap_12
XFILLER_165_585 VPWR VGND VPWR VGND sky130_ef_sc_hd__decap_12
XFILLER_158_1338 VPWR VGND VPWR VGND sky130_ef_sc_hd__decap_12
XFILLER_4_735 VGND VGND VPWR VPWR sky130_fd_sc_hd__decap_8
XFILLER_10_1412 VGND VGND VPWR VPWR sky130_fd_sc_hd__fill_1
XTAP_TAPCELL_ROW_210_2731 VGND VPWR sky130_fd_sc_hd__tapvpwrvgnd_1
XTAP_TAPCELL_ROW_210_2720 VGND VPWR sky130_fd_sc_hd__tapvpwrvgnd_1
XFILLER_84_1524 VGND VGND VPWR VPWR sky130_fd_sc_hd__fill_1
XFILLER_4_757 VPWR VGND VPWR VGND sky130_ef_sc_hd__decap_12
XFILLER_171_1505 VGND VGND VPWR VPWR sky130_fd_sc_hd__decap_6
XTAP_TAPCELL_ROW_151_2_3962 VGND VPWR sky130_fd_sc_hd__tapvpwrvgnd_1
XFILLER_10_72 VPWR VGND VPWR VGND sky130_ef_sc_hd__decap_12
XFILLER_171_1549 VPWR VGND VPWR VGND sky130_ef_sc_hd__decap_12
XFILLER_120_121 VGND VGND VPWR VPWR sky130_fd_sc_hd__decap_6
XANTENNA_input44_A func_we VGND VGND VPWR VPWR sky130_fd_sc_hd__diode_2
XFILLER_126_83 VGND VGND VPWR VPWR sky130_fd_sc_hd__fill_1
XFILLER_86_65 VPWR VGND VPWR VGND sky130_ef_sc_hd__decap_12
XFILLER_82_1270 VPWR VGND VPWR VGND sky130_ef_sc_hd__decap_12
XFILLER_0_963 VPWR VGND VPWR VGND sky130_ef_sc_hd__decap_12
XTAP_TAPCELL_ROW_7_1007 VGND VPWR sky130_fd_sc_hd__tapvpwrvgnd_1
XTAP_TAPCELL_ROW_208_2660 VGND VPWR sky130_fd_sc_hd__tapvpwrvgnd_1
XFILLER_134_1382 VPWR VGND VPWR VGND sky130_ef_sc_hd__decap_12
XTAP_TAPCELL_ROW_119_1_1255 VGND VPWR sky130_fd_sc_hd__tapvpwrvgnd_1
XTAP_TAPCELL_ROW_7_1018 VGND VPWR sky130_fd_sc_hd__tapvpwrvgnd_1
XTAP_TAPCELL_ROW_7_1029 VGND VPWR sky130_fd_sc_hd__tapvpwrvgnd_1
XFILLER_19_113 VPWR VGND VPWR VGND sky130_ef_sc_hd__decap_12
XTAP_TAPCELL_ROW_208_2682 VGND VPWR sky130_fd_sc_hd__tapvpwrvgnd_1
XTAP_TAPCELL_ROW_208_2671 VGND VPWR sky130_fd_sc_hd__tapvpwrvgnd_1
XFILLER_208_737 VPWR VGND VPWR VGND sky130_ef_sc_hd__decap_12
XFILLER_207_225 VPWR VGND VPWR VGND sky130_ef_sc_hd__decap_12
XFILLER_169_1401 VPWR VGND VPWR VGND sky130_ef_sc_hd__decap_12
XFILLER_130_1246 VPWR VGND VPWR VGND sky130_ef_sc_hd__decap_12
XFILLER_19_81 VGND VGND VPWR VPWR sky130_fd_sc_hd__fill_1
XTAP_TAPCELL_ROW_24_1_1066 VGND VPWR sky130_fd_sc_hd__tapvpwrvgnd_1
XFILLER_43_1298 VPWR VGND VPWR VGND sky130_ef_sc_hd__decap_12
XTAP_TAPCELL_ROW_204_2557 VGND VPWR sky130_fd_sc_hd__tapvpwrvgnd_1
XTAP_TAPCELL_ROW_204_2546 VGND VPWR sky130_fd_sc_hd__tapvpwrvgnd_1
XFILLER_21_1552 VGND VGND VPWR VPWR sky130_fd_sc_hd__fill_1
XFILLER_216_781 VPWR VGND VPWR VGND sky130_ef_sc_hd__decap_12
XTAP_TAPCELL_ROW_204_2568 VGND VPWR sky130_fd_sc_hd__tapvpwrvgnd_1
XTAP_TAPCELL_ROW_196_2314 VGND VPWR sky130_fd_sc_hd__tapvpwrvgnd_1
XTAP_TAPCELL_ROW_196_2336 VGND VPWR sky130_fd_sc_hd__tapvpwrvgnd_1
XTAP_TAPCELL_ROW_196_2325 VGND VPWR sky130_fd_sc_hd__tapvpwrvgnd_1
XFILLER_206_1317 VPWR VGND VPWR VGND sky130_ef_sc_hd__decap_12
XTAP_TAPCELL_ROW_217_2929 VGND VPWR sky130_fd_sc_hd__tapvpwrvgnd_1
XTAP_TAPCELL_ROW_217_2918 VGND VPWR sky130_fd_sc_hd__tapvpwrvgnd_1
XFILLER_203_497 VGND VGND VPWR VPWR sky130_fd_sc_hd__decap_6
XFILLER_188_699 VGND VGND VPWR VPWR sky130_fd_sc_hd__fill_1
XFILLER_175_305 VPWR VGND VPWR VGND sky130_ef_sc_hd__decap_12
XFILLER_163_1077 VPWR VGND VPWR VGND sky130_ef_sc_hd__decap_12
XFILLER_54_1350 VGND VGND VPWR VPWR sky130_fd_sc_hd__decap_6
XFILLER_198_1129 VPWR VGND VPWR VGND sky130_ef_sc_hd__decap_12
XFILLER_191_809 VPWR VGND VPWR VGND sky130_ef_sc_hd__decap_12
XFILLER_175_349 VPWR VGND VPWR VGND sky130_ef_sc_hd__decap_12
XFILLER_141_1342 VPWR VGND VPWR VGND sky130_ef_sc_hd__decap_12
XFILLER_106_1462 VGND VGND VPWR VPWR sky130_fd_sc_hd__decap_6
XFILLER_54_1394 VPWR VGND VPWR VGND sky130_ef_sc_hd__decap_12
XFILLER_204_1085 VGND VGND VPWR VPWR sky130_fd_sc_hd__decap_6
XFILLER_184_861 VGND VGND VPWR VPWR sky130_fd_sc_hd__decap_6
XFILLER_141_1386 VPWR VGND VPWR VGND sky130_ef_sc_hd__decap_12
XFILLER_102_1326 VPWR VGND VPWR VGND sky130_ef_sc_hd__decap_12
XFILLER_15_1378 VGND VGND VPWR VPWR sky130_fd_sc_hd__decap_6
XFILLER_50_1258 VPWR VGND VPWR VGND sky130_ef_sc_hd__decap_12
XFILLER_176_1427 VGND VGND VPWR VPWR sky130_fd_sc_hd__fill_1
XFILLER_7_573 VPWR VGND VPWR VGND sky130_ef_sc_hd__decap_12
XTAP_TAPCELL_ROW_60_2_3366 VGND VPWR sky130_fd_sc_hd__tapvpwrvgnd_1
XFILLER_183_393 VPWR VGND VPWR VGND sky130_ef_sc_hd__decap_12
XPHY_EDGE_ROW_50_2_Left_482 VGND VGND VPWR VPWR sky130_fd_sc_hd__decap_3
XFILLER_217_1413 VPWR VGND VPWR VGND sky130_ef_sc_hd__decap_12
XFILLER_217_1457 VPWR VGND VPWR VGND sky130_ef_sc_hd__decap_12
XFILLER_174_1173 VPWR VGND VPWR VGND sky130_ef_sc_hd__decap_12
XFILLER_170_1037 VPWR VGND VPWR VGND sky130_ef_sc_hd__decap_12
XFILLER_65_1490 VGND VGND VPWR VPWR sky130_fd_sc_hd__decap_6
XFILLER_61_1310 VPWR VGND VPWR VGND sky130_ef_sc_hd__decap_12
XFILLER_211_1001 VGND VGND VPWR VPWR sky130_fd_sc_hd__decap_6
XTAP_TAPCELL_ROW_181_1904 VGND VPWR sky130_fd_sc_hd__tapvpwrvgnd_1
XFILLER_152_1482 VPWR VGND VPWR VGND sky130_ef_sc_hd__decap_12
XFILLER_113_1422 VPWR VGND VPWR VGND sky130_ef_sc_hd__decap_12
XTAP_TAPCELL_ROW_19_2_3101 VGND VPWR sky130_fd_sc_hd__tapvpwrvgnd_1
XFILLER_61_1354 VPWR VGND VPWR VGND sky130_ef_sc_hd__decap_12
XFILLER_211_1045 VPWR VGND VPWR VGND sky130_ef_sc_hd__decap_12
XTAP_TAPCELL_ROW_166_1483 VGND VPWR sky130_fd_sc_hd__tapvpwrvgnd_1
XTAP_TAPCELL_ROW_166_1472 VGND VPWR sky130_fd_sc_hd__tapvpwrvgnd_1
XTAP_TAPCELL_ROW_166_1461 VGND VPWR sky130_fd_sc_hd__tapvpwrvgnd_1
XFILLER_113_1466 VPWR VGND VPWR VGND sky130_ef_sc_hd__decap_12
XFILLER_96_1406 VGND VGND VPWR VPWR sky130_fd_sc_hd__decap_6
XFILLER_22_1338 VPWR VGND VPWR VGND sky130_ef_sc_hd__decap_12
XFILLER_61_1398 VPWR VGND VPWR VGND sky130_ef_sc_hd__decap_12
XFILLER_211_1089 VPWR VGND VPWR VGND sky130_ef_sc_hd__decap_12
XFILLER_199_909 VPWR VGND VPWR VGND sky130_ef_sc_hd__decap_12
XFILLER_213_217 VGND VGND VPWR VPWR sky130_fd_sc_hd__decap_6
XFILLER_202_41 VPWR VGND VPWR VGND sky130_ef_sc_hd__decap_12
XFILLER_198_419 VGND VGND VPWR VPWR sky130_fd_sc_hd__fill_1
XFILLER_187_1567 VGND VGND VPWR VPWR sky130_fd_sc_hd__fill_1
XFILLER_148_1518 VGND VGND VPWR VPWR sky130_fd_sc_hd__decap_6
XFILLER_0_1145 VGND VGND VPWR VPWR sky130_fd_sc_hd__decap_3
XFILLER_202_85 VPWR VGND VPWR VGND sky130_ef_sc_hd__decap_12
XFILLER_146_1220 VPWR VGND VPWR VGND sky130_ef_sc_hd__decap_12
XFILLER_15_39 VPWR VGND VPWR VGND sky130_ef_sc_hd__decap_12
XFILLER_59_1272 VGND VGND VPWR VPWR sky130_fd_sc_hd__fill_1
XFILLER_181_1133 VPWR VGND VPWR VGND sky130_ef_sc_hd__decap_12
XTAP_TAPCELL_ROW_179_1855 VGND VPWR sky130_fd_sc_hd__tapvpwrvgnd_1
XTAP_TAPCELL_ROW_179_1844 VGND VPWR sky130_fd_sc_hd__tapvpwrvgnd_1
XTAP_TAPCELL_ROW_179_1833 VGND VPWR sky130_fd_sc_hd__tapvpwrvgnd_1
XFILLER_178_121 VPWR VGND VPWR VGND sky130_ef_sc_hd__decap_12
XFILLER_0_1189 VPWR VGND VPWR VGND sky130_ef_sc_hd__decap_12
XFILLER_194_625 VPWR VGND VPWR VGND sky130_ef_sc_hd__decap_12
XFILLER_181_1177 VPWR VGND VPWR VGND sky130_ef_sc_hd__decap_12
XFILLER_178_165 VPWR VGND VPWR VGND sky130_ef_sc_hd__decap_12
XTAP_TAPCELL_ROW_175_1719 VGND VPWR sky130_fd_sc_hd__tapvpwrvgnd_1
XFILLER_167_839 VGND VGND VPWR VPWR sky130_fd_sc_hd__fill_1
XPHY_EDGE_ROW_114_1_Left_333 VGND VGND VPWR VPWR sky130_fd_sc_hd__decap_3
XFILLER_72_1450 VPWR VGND VPWR VGND sky130_ef_sc_hd__decap_12
XFILLER_210_979 VGND VGND VPWR VPWR sky130_fd_sc_hd__fill_1
XFILLER_193_113 VPWR VGND VPWR VGND sky130_ef_sc_hd__decap_12
XFILLER_124_1562 VPWR VGND VPWR VGND sky130_ef_sc_hd__decap_12
XFILLER_72_1494 VPWR VGND VPWR VGND sky130_ef_sc_hd__decap_12
XFILLER_33_1434 VGND VGND VPWR VPWR sky130_fd_sc_hd__decap_6
XFILLER_194_669 VPWR VGND VPWR VGND sky130_ef_sc_hd__decap_12
XFILLER_120_1426 VPWR VGND VPWR VGND sky130_ef_sc_hd__decap_12
XFILLER_31_27 VPWR VGND VPWR VGND sky130_ef_sc_hd__decap_12
XFILLER_33_1478 VPWR VGND VPWR VGND sky130_ef_sc_hd__decap_12
XFILLER_147_27 VPWR VGND VPWR VGND sky130_ef_sc_hd__decap_12
XFILLER_200_1483 VGND VGND VPWR VPWR sky130_fd_sc_hd__fill_1
XTAP_TAPCELL_ROW_136_2_3864 VGND VPWR sky130_fd_sc_hd__tapvpwrvgnd_1
XFILLER_118_1300 VGND VGND VPWR VPWR sky130_fd_sc_hd__fill_1
XFILLER_66_1232 VPWR VGND VPWR VGND sky130_ef_sc_hd__decap_12
Xoutput49 net49 VGND VGND VPWR VPWR bist_fail_addr[0] sky130_fd_sc_hd__buf_2
XFILLER_1_716 VGND VGND VPWR VPWR sky130_fd_sc_hd__decap_8
XFILLER_192_1273 VPWR VGND VPWR VGND sky130_ef_sc_hd__decap_12
XFILLER_163_15 VPWR VGND VPWR VGND sky130_ef_sc_hd__decap_12
XFILLER_153_1235 VPWR VGND VPWR VGND sky130_ef_sc_hd__decap_12
XFILLER_1_738 VPWR VGND VPWR VGND sky130_ef_sc_hd__decap_12
XFILLER_102_121 VGND VGND VPWR VPWR sky130_fd_sc_hd__decap_6
XFILLER_83_1590 VPWR VGND VPWR VGND sky130_ef_sc_hd__decap_12
XFILLER_188_1309 VGND VGND VPWR VPWR sky130_fd_sc_hd__decap_6
XFILLER_131_1522 VPWR VGND VPWR VGND sky130_ef_sc_hd__decap_12
XFILLER_5_1001 VGND VGND VPWR VPWR sky130_fd_sc_hd__decap_6
XFILLER_44_1574 VGND VGND VPWR VPWR sky130_fd_sc_hd__decap_6
XFILLER_5_1045 VPWR VGND VPWR VGND sky130_ef_sc_hd__decap_12
XFILLER_40_1438 VPWR VGND VPWR VGND sky130_ef_sc_hd__decap_12
XFILLER_131_1566 VPWR VGND VPWR VGND sky130_ef_sc_hd__decap_12
X_570_ clknet_3_1_0_clk _008_ VGND VGND VPWR VPWR u_ctrl.cmp_addr\[2\] sky130_fd_sc_hd__dfxtp_1
XFILLER_5_1089 VPWR VGND VPWR VGND sky130_ef_sc_hd__decap_12
XFILLER_205_729 VPWR VGND VPWR VGND sky130_ef_sc_hd__decap_12
XFILLER_112_41 VPWR VGND VPWR VGND sky130_ef_sc_hd__decap_12
XFILLER_129_1440 VGND VGND VPWR VPWR sky130_fd_sc_hd__fill_1
XFILLER_112_85 VPWR VGND VPWR VGND sky130_ef_sc_hd__decap_12
XTAP_TAPCELL_ROW_0_782 VGND VPWR sky130_fd_sc_hd__tapvpwrvgnd_1
XTAP_TAPCELL_ROW_0_760 VGND VPWR sky130_fd_sc_hd__tapvpwrvgnd_1
XTAP_TAPCELL_ROW_0_771 VGND VPWR sky130_fd_sc_hd__tapvpwrvgnd_1
XFILLER_197_441 VGND VGND VPWR VPWR sky130_fd_sc_hd__decap_6
XFILLER_164_1353 VPWR VGND VPWR VGND sky130_ef_sc_hd__decap_12
XTAP_TAPCELL_ROW_0_793 VGND VPWR sky130_fd_sc_hd__tapvpwrvgnd_1
XFILLER_38_1356 VGND VGND VPWR VPWR sky130_fd_sc_hd__fill_1
XPHY_EDGE_ROW_46_1_Left_265 VGND VGND VPWR VPWR sky130_fd_sc_hd__decap_3
XFILLER_200_401 VPWR VGND VPWR VGND sky130_ef_sc_hd__decap_12
XFILLER_197_485 VPWR VGND VPWR VGND sky130_ef_sc_hd__decap_12
XFILLER_164_1397 VPWR VGND VPWR VGND sky130_ef_sc_hd__decap_12
XFILLER_90_1550 VPWR VGND VPWR VGND sky130_ef_sc_hd__decap_12
XFILLER_200_445 VPWR VGND VPWR VGND sky130_ef_sc_hd__decap_12
XFILLER_103_1602 VGND VGND VPWR VPWR sky130_fd_sc_hd__decap_3
XFILLER_51_1534 VPWR VGND VPWR VGND sky130_ef_sc_hd__decap_12
XFILLER_201_1225 VGND VGND VPWR VPWR sky130_fd_sc_hd__decap_6
XFILLER_200_489 VPWR VGND VPWR VGND sky130_ef_sc_hd__decap_12
XFILLER_199_1449 VGND VGND VPWR VPWR sky130_fd_sc_hd__decap_6
XFILLER_173_809 VPWR VGND VPWR VGND sky130_ef_sc_hd__decap_12
XFILLER_166_861 VGND VGND VPWR VPWR sky130_fd_sc_hd__decap_6
XFILLER_90_1594 VGND VGND VPWR VPWR sky130_fd_sc_hd__decap_8
XFILLER_12_1518 VGND VGND VPWR VPWR sky130_fd_sc_hd__decap_6
XTAP_TAPCELL_ROW_45_2_3268 VGND VPWR sky130_fd_sc_hd__tapvpwrvgnd_1
XFILLER_51_1578 VPWR VGND VPWR VGND sky130_ef_sc_hd__decap_12
XFILLER_201_1269 VPWR VGND VPWR VGND sky130_ef_sc_hd__decap_12
XFILLER_181_853 VPWR VGND VPWR VGND sky130_ef_sc_hd__decap_12
XFILLER_165_393 VPWR VGND VPWR VGND sky130_ef_sc_hd__decap_12
XFILLER_10_1220 VPWR VGND VPWR VGND sky130_ef_sc_hd__decap_12
XTAP_TAPCELL_ROW_189_2140 VGND VPWR sky130_fd_sc_hd__tapvpwrvgnd_1
XFILLER_181_897 VPWR VGND VPWR VGND sky130_ef_sc_hd__decap_12
XFILLER_180_363 VGND VGND VPWR VPWR sky130_fd_sc_hd__fill_1
XTAP_TAPCELL_ROW_185_2026 VGND VPWR sky130_fd_sc_hd__tapvpwrvgnd_1
XTAP_TAPCELL_ROW_185_2015 VGND VPWR sky130_fd_sc_hd__tapvpwrvgnd_1
XTAP_TAPCELL_ROW_185_2004 VGND VPWR sky130_fd_sc_hd__tapvpwrvgnd_1
XFILLER_175_1493 VPWR VGND VPWR VGND sky130_ef_sc_hd__decap_12
XFILLER_171_1313 VPWR VGND VPWR VGND sky130_ef_sc_hd__decap_12
XFILLER_137_93 VPWR VGND VPWR VGND sky130_ef_sc_hd__decap_12
XFILLER_49_1496 VGND VGND VPWR VPWR sky130_fd_sc_hd__fill_1
XFILLER_171_1357 VPWR VGND VPWR VGND sky130_ef_sc_hd__decap_12
XTAP_TAPCELL_ROW_206_2619 VGND VPWR sky130_fd_sc_hd__tapvpwrvgnd_1
XTAP_TAPCELL_ROW_206_2608 VGND VPWR sky130_fd_sc_hd__tapvpwrvgnd_1
XFILLER_212_1365 VGND VGND VPWR VPWR sky130_fd_sc_hd__decap_6
XFILLER_208_501 VPWR VGND VPWR VGND sky130_ef_sc_hd__decap_12
XFILLER_153_81 VPWR VGND VPWR VGND sky130_ef_sc_hd__decap_12
XTAP_TAPCELL_ROW_55_1_1127 VGND VPWR sky130_fd_sc_hd__tapvpwrvgnd_1
XFILLER_208_545 VPWR VGND VPWR VGND sky130_ef_sc_hd__decap_12
XFILLER_169_1231 VGND VGND VPWR VPWR sky130_fd_sc_hd__fill_1
XFILLER_208_589 VPWR VGND VPWR VGND sky130_ef_sc_hd__decap_12
XFILLER_56_1412 VGND VGND VPWR VPWR sky130_fd_sc_hd__fill_1
XFILLER_210_209 VPWR VGND VPWR VGND sky130_ef_sc_hd__decap_12
XFILLER_189_953 VPWR VGND VPWR VGND sky130_ef_sc_hd__decap_12
XFILLER_182_1453 VPWR VGND VPWR VGND sky130_ef_sc_hd__decap_12
XFILLER_108_1524 VGND VGND VPWR VPWR sky130_fd_sc_hd__fill_1
XFILLER_206_1147 VGND VGND VPWR VPWR sky130_fd_sc_hd__fill_1
XFILLER_203_261 VPWR VGND VPWR VGND sky130_ef_sc_hd__decap_12
Xclkbuf_0_clk clk VGND VGND VPWR VPWR clknet_0_clk sky130_fd_sc_hd__clkbuf_16
XFILLER_182_1497 VPWR VGND VPWR VGND sky130_ef_sc_hd__decap_12
XFILLER_176_625 VPWR VGND VPWR VGND sky130_ef_sc_hd__decap_12
XFILLER_175_113 VPWR VGND VPWR VGND sky130_ef_sc_hd__decap_12
XFILLER_87_3 VPWR VGND VPWR VGND sky130_ef_sc_hd__decap_12
XFILLER_191_617 VPWR VGND VPWR VGND sky130_ef_sc_hd__decap_12
XFILLER_176_669 VPWR VGND VPWR VGND sky130_ef_sc_hd__decap_12
XFILLER_106_1270 VPWR VGND VPWR VGND sky130_ef_sc_hd__decap_12
XFILLER_89_1232 VPWR VGND VPWR VGND sky130_ef_sc_hd__decap_12
XTAP_TAPCELL_ROW_122_2_3772 VGND VPWR sky130_fd_sc_hd__tapvpwrvgnd_1
XTAP_TAPCELL_ROW_90_2_3561 VGND VPWR sky130_fd_sc_hd__tapvpwrvgnd_1
XTAP_TAPCELL_ROW_89_2_3555 VGND VPWR sky130_fd_sc_hd__tapvpwrvgnd_1
XFILLER_89_1298 VPWR VGND VPWR VGND sky130_ef_sc_hd__decap_12
XFILLER_67_1552 VGND VGND VPWR VPWR sky130_fd_sc_hd__fill_1
XFILLER_171_385 VGND VGND VPWR VPWR sky130_fd_sc_hd__decap_6
XFILLER_217_1287 VGND VGND VPWR VPWR sky130_fd_sc_hd__fill_1
XFILLER_193_1593 VPWR VGND VPWR VGND sky130_ef_sc_hd__decap_12
XTAP_TAPCELL_ROW_168_1534 VGND VPWR sky130_fd_sc_hd__tapvpwrvgnd_1
XTAP_TAPCELL_ROW_168_1523 VGND VPWR sky130_fd_sc_hd__tapvpwrvgnd_1
XFILLER_218_309 VPWR VGND VPWR VGND sky130_ef_sc_hd__decap_12
XTAP_TAPCELL_ROW_164_1409 VGND VPWR sky130_fd_sc_hd__tapvpwrvgnd_1
XTAP_TAPCELL_ROW_102_1_1222 VGND VPWR sky130_fd_sc_hd__tapvpwrvgnd_1
XFILLER_6_1365 VGND VGND VPWR VPWR sky130_fd_sc_hd__decap_6
XFILLER_26_1282 VPWR VGND VPWR VGND sky130_ef_sc_hd__decap_12
XFILLER_213_51 VGND VGND VPWR VPWR sky130_fd_sc_hd__decap_4
XFILLER_113_1274 VPWR VGND VPWR VGND sky130_ef_sc_hd__decap_12
XTAP_TAPCELL_ROW_82_2_3509 VGND VPWR sky130_fd_sc_hd__tapvpwrvgnd_1
XFILLER_2_1229 VPWR VGND VPWR VGND sky130_ef_sc_hd__decap_12
XFILLER_96_1258 VPWR VGND VPWR VGND sky130_ef_sc_hd__decap_12
XFILLER_148_1326 VPWR VGND VPWR VGND sky130_ef_sc_hd__decap_12
XFILLER_179_441 VGND VGND VPWR VPWR sky130_fd_sc_hd__decap_6
XFILLER_126_1602 VGND VGND VPWR VPWR sky130_fd_sc_hd__decap_3
XFILLER_42_15 VPWR VGND VPWR VGND sky130_ef_sc_hd__decap_12
XFILLER_195_945 VGND VGND VPWR VPWR sky130_fd_sc_hd__decap_6
XFILLER_194_433 VPWR VGND VPWR VGND sky130_ef_sc_hd__decap_12
XFILLER_179_485 VPWR VGND VPWR VGND sky130_ef_sc_hd__decap_12
XFILLER_158_15 VPWR VGND VPWR VGND sky130_ef_sc_hd__decap_12
XFILLER_33_1220 VPWR VGND VPWR VGND sky130_ef_sc_hd__decap_12
XFILLER_195_989 VPWR VGND VPWR VGND sky130_ef_sc_hd__decap_12
XFILLER_124_1370 VPWR VGND VPWR VGND sky130_ef_sc_hd__decap_12
XFILLER_194_477 VPWR VGND VPWR VGND sky130_ef_sc_hd__decap_12
XFILLER_181_105 VGND VGND VPWR VPWR sky130_fd_sc_hd__decap_6
XFILLER_33_1286 VPWR VGND VPWR VGND sky130_ef_sc_hd__decap_12
XFILLER_202_1589 VGND VGND VPWR VPWR sky130_fd_sc_hd__decap_6
XFILLER_181_149 VPWR VGND VPWR VGND sky130_ef_sc_hd__decap_12
XFILLER_163_853 VPWR VGND VPWR VGND sky130_ef_sc_hd__decap_12
XFILLER_159_1422 VPWR VGND VPWR VGND sky130_ef_sc_hd__decap_12
XFILLER_68_1338 VPWR VGND VPWR VGND sky130_ef_sc_hd__decap_12
XTAP_TAPCELL_ROW_11_2_3052 VGND VPWR sky130_fd_sc_hd__tapvpwrvgnd_1
XANTENNA__352__A1 b_addr\[7\] VGND VGND VPWR VPWR sky130_fd_sc_hd__diode_2
XFILLER_218_1029 VGND VGND VPWR VPWR sky130_fd_sc_hd__decap_6
XFILLER_163_897 VPWR VGND VPWR VGND sky130_ef_sc_hd__decap_12
XFILLER_159_1466 VPWR VGND VPWR VGND sky130_ef_sc_hd__decap_12
XANTENNA__619__CLK clknet_3_6_0_clk VGND VGND VPWR VPWR sky130_fd_sc_hd__diode_2
XFILLER_1_513 VGND VGND VPWR VPWR sky130_fd_sc_hd__decap_3
XANTENNA__330__S net140 VGND VGND VPWR VPWR sky130_fd_sc_hd__diode_2
XFILLER_191_3 VPWR VGND VPWR VGND sky130_ef_sc_hd__decap_12
XFILLER_188_1117 VPWR VGND VPWR VGND sky130_ef_sc_hd__decap_12
XFILLER_131_1330 VPWR VGND VPWR VGND sky130_ef_sc_hd__decap_12
XFILLER_44_1382 VPWR VGND VPWR VGND sky130_ef_sc_hd__decap_12
XFILLER_123_51 VGND VGND VPWR VPWR sky130_fd_sc_hd__decap_4
X_622_ clknet_3_6_0_clk _056_ VGND VGND VPWR VPWR net80 sky130_fd_sc_hd__dfxtp_1
XFILLER_40_1246 VPWR VGND VPWR VGND sky130_ef_sc_hd__decap_12
XFILLER_40_1235 VGND VGND VPWR VPWR sky130_fd_sc_hd__decap_8
XFILLER_79_1434 VGND VGND VPWR VPWR sky130_fd_sc_hd__decap_6
XFILLER_189_205 VPWR VGND VPWR VGND sky130_ef_sc_hd__decap_12
XFILLER_83_55 VGND VGND VPWR VPWR sky130_fd_sc_hd__fill_1
XFILLER_79_1478 VPWR VGND VPWR VGND sky130_ef_sc_hd__decap_12
X_553_ net136 _250_ VGND VGND VPWR VPWR _060_ sky130_fd_sc_hd__and2_1
XFILLER_207_1401 VPWR VGND VPWR VGND sky130_ef_sc_hd__decap_12
XFILLER_205_559 VGND VGND VPWR VPWR sky130_fd_sc_hd__fill_1
XFILLER_199_55 VGND VGND VPWR VPWR sky130_fd_sc_hd__fill_1
XFILLER_189_249 VPWR VGND VPWR VGND sky130_ef_sc_hd__decap_12
X_484_ net57 _169_ net121 VGND VGND VPWR VPWR _216_ sky130_fd_sc_hd__mux2_1
XFILLER_201_721 VGND VGND VPWR VPWR sky130_fd_sc_hd__decap_6
XFILLER_186_923 VGND VGND VPWR VPWR sky130_fd_sc_hd__fill_1
XFILLER_164_1161 VPWR VGND VPWR VGND sky130_ef_sc_hd__decap_12
XFILLER_16_93 VGND VGND VPWR VPWR sky130_fd_sc_hd__fill_1
XFILLER_199_1213 VPWR VGND VPWR VGND sky130_ef_sc_hd__decap_12
XFILLER_197_293 VPWR VGND VPWR VGND sky130_ef_sc_hd__decap_12
XFILLER_157_113 VPWR VGND VPWR VGND sky130_ef_sc_hd__decap_12
XFILLER_8_112 VPWR VGND VPWR VGND sky130_ef_sc_hd__decap_12
XFILLER_201_765 VPWR VGND VPWR VGND sky130_ef_sc_hd__decap_12
XFILLER_200_253 VPWR VGND VPWR VGND sky130_ef_sc_hd__decap_12
XFILLER_103_1410 VPWR VGND VPWR VGND sky130_ef_sc_hd__decap_12
XTAP_TAPCELL_ROW_95_2_3598 VGND VPWR sky130_fd_sc_hd__tapvpwrvgnd_1
XFILLER_16_1462 VGND VGND VPWR VPWR sky130_fd_sc_hd__decap_6
XFILLER_51_1342 VPWR VGND VPWR VGND sky130_ef_sc_hd__decap_12
XFILLER_201_1033 VPWR VGND VPWR VGND sky130_ef_sc_hd__decap_12
XFILLER_199_1257 VPWR VGND VPWR VGND sky130_ef_sc_hd__decap_12
XFILLER_173_617 VPWR VGND VPWR VGND sky130_ef_sc_hd__decap_12
XFILLER_142_1470 VPWR VGND VPWR VGND sky130_ef_sc_hd__decap_12
XFILLER_107_1590 VPWR VGND VPWR VGND sky130_ef_sc_hd__decap_12
XTAP_TAPCELL_ROW_107_2_3674 VGND VPWR sky130_fd_sc_hd__tapvpwrvgnd_1
XFILLER_103_1454 VPWR VGND VPWR VGND sky130_ef_sc_hd__decap_12
XFILLER_12_1326 VPWR VGND VPWR VGND sky130_ef_sc_hd__decap_12
XFILLER_51_1386 VPWR VGND VPWR VGND sky130_ef_sc_hd__decap_12
XFILLER_218_29 VPWR VGND VPWR VGND sky130_ef_sc_hd__decap_12
XFILLER_201_1077 VPWR VGND VPWR VGND sky130_ef_sc_hd__decap_12
XFILLER_177_1511 VGND VGND VPWR VPWR sky130_fd_sc_hd__fill_1
XTAP_TAPCELL_ROW_75_2_3463 VGND VPWR sky130_fd_sc_hd__tapvpwrvgnd_1
XFILLER_5_841 VGND VGND VPWR VPWR sky130_fd_sc_hd__decap_4
XFILLER_138_1506 VPWR VGND VPWR VGND sky130_ef_sc_hd__decap_12
XFILLER_103_1498 VPWR VGND VPWR VGND sky130_ef_sc_hd__decap_12
XFILLER_86_1438 VPWR VGND VPWR VGND sky130_ef_sc_hd__decap_12
XFILLER_218_1541 VPWR VGND VPWR VGND sky130_ef_sc_hd__decap_12
XFILLER_171_1121 VPWR VGND VPWR VGND sky130_ef_sc_hd__decap_12
XFILLER_4_395 VGND VGND VPWR VPWR sky130_fd_sc_hd__fill_1
XFILLER_214_1427 VGND VGND VPWR VPWR sky130_fd_sc_hd__fill_1
XTAP_TAPCELL_ROW_100_2_3628 VGND VPWR sky130_fd_sc_hd__tapvpwrvgnd_1
XFILLER_209_821 VPWR VGND VPWR VGND sky130_ef_sc_hd__decap_12
XFILLER_114_1550 VPWR VGND VPWR VGND sky130_ef_sc_hd__decap_12
XFILLER_23_1422 VPWR VGND VPWR VGND sky130_ef_sc_hd__decap_12
XFILLER_62_1482 VPWR VGND VPWR VGND sky130_ef_sc_hd__decap_12
XFILLER_212_1173 VPWR VGND VPWR VGND sky130_ef_sc_hd__decap_12
XFILLER_209_865 VPWR VGND VPWR VGND sky130_ef_sc_hd__decap_12
XFILLER_110_1414 VPWR VGND VPWR VGND sky130_ef_sc_hd__decap_12
XFILLER_3_1505 VGND VGND VPWR VPWR sky130_fd_sc_hd__decap_6
XFILLER_23_1466 VPWR VGND VPWR VGND sky130_ef_sc_hd__decap_12
XFILLER_149_1602 VGND VGND VPWR VPWR sky130_fd_sc_hd__decap_3
XFILLER_114_1594 VGND VGND VPWR VPWR sky130_fd_sc_hd__decap_8
XFILLER_97_1534 VPWR VGND VPWR VGND sky130_ef_sc_hd__decap_12
XFILLER_3_1549 VPWR VGND VPWR VGND sky130_ef_sc_hd__decap_12
XANTENNA__476__A _169_ VGND VGND VPWR VPWR sky130_fd_sc_hd__diode_2
XFILLER_97_1578 VPWR VGND VPWR VGND sky130_ef_sc_hd__decap_12
XFILLER_58_1518 VGND VGND VPWR VPWR sky130_fd_sc_hd__decap_6
XFILLER_56_1220 VPWR VGND VPWR VGND sky130_ef_sc_hd__decap_12
XFILLER_211_529 VPWR VGND VPWR VGND sky130_ef_sc_hd__decap_12
XFILLER_204_581 VGND VGND VPWR VPWR sky130_fd_sc_hd__decap_6
XFILLER_189_783 VGND VGND VPWR VPWR sky130_fd_sc_hd__fill_1
XFILLER_182_1261 VPWR VGND VPWR VGND sky130_ef_sc_hd__decap_12
XFILLER_177_945 VGND VGND VPWR VPWR sky130_fd_sc_hd__decap_6
XFILLER_176_433 VPWR VGND VPWR VGND sky130_ef_sc_hd__decap_12
XFILLER_177_989 VPWR VGND VPWR VGND sky130_ef_sc_hd__decap_12
XFILLER_143_1256 VPWR VGND VPWR VGND sky130_ef_sc_hd__decap_12
XFILLER_121_1510 VPWR VGND VPWR VGND sky130_ef_sc_hd__decap_12
XFILLER_34_1562 VPWR VGND VPWR VGND sky130_ef_sc_hd__decap_12
XFILLER_192_937 VPWR VGND VPWR VGND sky130_ef_sc_hd__decap_12
XFILLER_176_477 VPWR VGND VPWR VGND sky130_ef_sc_hd__decap_12
XFILLER_12_29 VGND VGND VPWR VPWR sky130_fd_sc_hd__decap_8
XFILLER_30_1426 VPWR VGND VPWR VGND sky130_ef_sc_hd__decap_12
XFILLER_191_447 VGND VGND VPWR VPWR sky130_fd_sc_hd__fill_1
XFILLER_128_29 VPWR VGND VPWR VGND sky130_ef_sc_hd__decap_12
XFILLER_121_1554 VPWR VGND VPWR VGND sky130_ef_sc_hd__decap_12
XFILLER_28_1300 VGND VGND VPWR VPWR sky130_fd_sc_hd__fill_1
XFILLER_171_193 VPWR VGND VPWR VGND sky130_ef_sc_hd__decap_12
XFILLER_63_1268 VGND VGND VPWR VPWR sky130_fd_sc_hd__decap_4
XFILLER_8_1438 VPWR VGND VPWR VGND sky130_ef_sc_hd__decap_12
XPHY_EDGE_ROW_13_2_Left_445 VGND VGND VPWR VPWR sky130_fd_sc_hd__decap_3
XFILLER_219_629 VPWR VGND VPWR VGND sky130_ef_sc_hd__decap_12
XFILLER_85_111 VGND VGND VPWR VPWR sky130_fd_sc_hd__fill_1
XFILLER_37_15 VPWR VGND VPWR VGND sky130_ef_sc_hd__decap_12
XFILLER_41_1522 VPWR VGND VPWR VGND sky130_ef_sc_hd__decap_12
XFILLER_218_139 VGND VGND VPWR VPWR sky130_fd_sc_hd__fill_1
XFILLER_189_1437 VPWR VGND VPWR VGND sky130_ef_sc_hd__decap_12
XPHY_EDGE_ROW_138_2_Left_570 VGND VGND VPWR VPWR sky130_fd_sc_hd__decap_3
XFILLER_80_1582 VPWR VGND VPWR VGND sky130_ef_sc_hd__decap_12
XFILLER_6_1173 VPWR VGND VPWR VGND sky130_ef_sc_hd__decap_12
XFILLER_160_27 VGND VGND VPWR VPWR sky130_fd_sc_hd__fill_1
XTAP_TAPCELL_ROW_144_2_3915 VGND VPWR sky130_fd_sc_hd__tapvpwrvgnd_1
XTAP_TAPCELL_ROW_2_855 VGND VPWR sky130_fd_sc_hd__tapvpwrvgnd_1
XFILLER_2_1037 VPWR VGND VPWR VGND sky130_ef_sc_hd__decap_12
XTAP_TAPCELL_ROW_2_844 VGND VPWR sky130_fd_sc_hd__tapvpwrvgnd_1
XFILLER_41_1566 VPWR VGND VPWR VGND sky130_ef_sc_hd__decap_12
XFILLER_214_301 VGND VGND VPWR VPWR sky130_fd_sc_hd__decap_6
XFILLER_199_503 VGND VGND VPWR VPWR sky130_fd_sc_hd__fill_1
XFILLER_214_345 VPWR VGND VPWR VGND sky130_ef_sc_hd__decap_12
XFILLER_187_709 VPWR VGND VPWR VGND sky130_ef_sc_hd__decap_12
XFILLER_39_1440 VGND VGND VPWR VPWR sky130_fd_sc_hd__fill_1
XFILLER_214_389 VPWR VGND VPWR VGND sky130_ef_sc_hd__decap_12
XFILLER_53_69 VPWR VGND VPWR VGND sky130_ef_sc_hd__decap_12
XFILLER_168_923 VGND VGND VPWR VPWR sky130_fd_sc_hd__fill_1
XFILLER_169_69 VPWR VGND VPWR VGND sky130_ef_sc_hd__decap_12
XFILLER_165_1481 VPWR VGND VPWR VGND sky130_ef_sc_hd__decap_12
XFILLER_139_113 VPWR VGND VPWR VGND sky130_ef_sc_hd__decap_12
XFILLER_195_753 VPWR VGND VPWR VGND sky130_ef_sc_hd__decap_12
XFILLER_179_293 VPWR VGND VPWR VGND sky130_ef_sc_hd__decap_12
XFILLER_161_1378 VGND VGND VPWR VPWR sky130_fd_sc_hd__decap_6
XFILLER_13_1602 VGND VGND VPWR VPWR sky130_fd_sc_hd__decap_3
XFILLER_202_1353 VPWR VGND VPWR VGND sky130_ef_sc_hd__decap_12
XFILLER_195_797 VPWR VGND VPWR VGND sky130_ef_sc_hd__decap_12
XFILLER_185_57 VPWR VGND VPWR VGND sky130_ef_sc_hd__decap_12
XTAP_TAPCELL_ROW_79_1_1175 VGND VPWR sky130_fd_sc_hd__tapvpwrvgnd_1
XFILLER_5_137 VPWR VGND VPWR VGND sky130_ef_sc_hd__decap_12
XFILLER_204_3 VPWR VGND VPWR VGND sky130_ef_sc_hd__decap_12
XFILLER_202_1397 VPWR VGND VPWR VGND sky130_ef_sc_hd__decap_12
XFILLER_182_469 VGND VGND VPWR VPWR sky130_fd_sc_hd__decap_6
XFILLER_159_1274 VPWR VGND VPWR VGND sky130_ef_sc_hd__decap_12
XANTENNA__591__CLK clknet_3_0_0_clk VGND VGND VPWR VPWR sky130_fd_sc_hd__diode_2
XFILLER_190_1029 VGND VGND VPWR VPWR sky130_fd_sc_hd__decap_6
XFILLER_172_1441 VPWR VGND VPWR VGND sky130_ef_sc_hd__decap_12
XFILLER_78_77 VGND VGND VPWR VPWR sky130_fd_sc_hd__decap_6
XFILLER_172_1485 VPWR VGND VPWR VGND sky130_ef_sc_hd__decap_12
XFILLER_134_83 VGND VGND VPWR VPWR sky130_fd_sc_hd__fill_1
XFILLER_213_1493 VPWR VGND VPWR VGND sky130_ef_sc_hd__decap_12
XFILLER_206_813 VPWR VGND VPWR VGND sky130_ef_sc_hd__decap_12
XFILLER_94_65 VPWR VGND VPWR VGND sky130_ef_sc_hd__decap_12
XFILLER_91_125 VGND VGND VPWR VPWR sky130_fd_sc_hd__fill_2
XFILLER_79_1220 VPWR VGND VPWR VGND sky130_ef_sc_hd__decap_12
XFILLER_217_161 VGND VGND VPWR VPWR sky130_fd_sc_hd__decap_6
X_605_ clknet_3_3_0_clk _039_ VGND VGND VPWR VPWR net61 sky130_fd_sc_hd__dfxtp_1
XFILLER_79_1286 VPWR VGND VPWR VGND sky130_ef_sc_hd__decap_12
X_536_ net75 net123 VGND VGND VPWR VPWR _242_ sky130_fd_sc_hd__or2_1
XFILLER_207_1231 VGND VGND VPWR VPWR sky130_fd_sc_hd__fill_1
XFILLER_18_1524 VGND VGND VPWR VPWR sky130_fd_sc_hd__fill_1
XFILLER_183_1581 VPWR VGND VPWR VGND sky130_ef_sc_hd__decap_12
X_467_ net145 net99 VGND VGND VPWR VPWR _199_ sky130_fd_sc_hd__xor2_1
XFILLER_201_573 VPWR VGND VPWR VGND sky130_ef_sc_hd__decap_12
XFILLER_199_1021 VPWR VGND VPWR VGND sky130_ef_sc_hd__decap_12
X_398_ _133_ _134_ VGND VGND VPWR VPWR _135_ sky130_fd_sc_hd__nand2_1
XFILLER_174_937 VPWR VGND VPWR VGND sky130_ef_sc_hd__decap_12
XFILLER_145_105 VGND VGND VPWR VPWR sky130_fd_sc_hd__decap_6
XFILLER_16_1270 VPWR VGND VPWR VGND sky130_ef_sc_hd__decap_12
XFILLER_199_1065 VPWR VGND VPWR VGND sky130_ef_sc_hd__decap_12
XFILLER_173_447 VGND VGND VPWR VPWR sky130_fd_sc_hd__fill_1
XTAP_TAPCELL_ROW_126_1_1270 VGND VPWR sky130_fd_sc_hd__tapvpwrvgnd_1
XFILLER_182_981 VPWR VGND VPWR VGND sky130_ef_sc_hd__decap_12
XFILLER_138_1314 VPWR VGND VPWR VGND sky130_ef_sc_hd__decap_12
XFILLER_86_1246 VPWR VGND VPWR VGND sky130_ef_sc_hd__decap_12
XFILLER_138_1358 VPWR VGND VPWR VGND sky130_ef_sc_hd__decap_12
XFILLER_4_41 VPWR VGND VPWR VGND sky130_ef_sc_hd__decap_12
XFILLER_218_1371 VGND VGND VPWR VPWR sky130_fd_sc_hd__fill_1
XFILLER_190_1541 VPWR VGND VPWR VGND sky130_ef_sc_hd__decap_12
XFILLER_4_85 VPWR VGND VPWR VGND sky130_ef_sc_hd__decap_12
XPHY_EDGE_ROW_123_1_Left_342 VGND VGND VPWR VPWR sky130_fd_sc_hd__decap_3
XFILLER_67_111 VGND VGND VPWR VPWR sky130_fd_sc_hd__fill_1
XTAP_TAPCELL_ROW_129_2_3817 VGND VPWR sky130_fd_sc_hd__tapvpwrvgnd_1
XTAP_TAPCELL_ROW_130_2_3823 VGND VPWR sky130_fd_sc_hd__tapvpwrvgnd_1
XFILLER_3_1313 VPWR VGND VPWR VGND sky130_ef_sc_hd__decap_12
XFILLER_209_673 VPWR VGND VPWR VGND sky130_ef_sc_hd__decap_12
XFILLER_167_1009 VPWR VGND VPWR VGND sky130_ef_sc_hd__decap_12
XFILLER_23_1274 VPWR VGND VPWR VGND sky130_ef_sc_hd__decap_12
XFILLER_149_1410 VPWR VGND VPWR VGND sky130_ef_sc_hd__decap_12
XFILLER_110_1244 VGND VGND VPWR VPWR sky130_fd_sc_hd__fill_1
XFILLER_97_1342 VPWR VGND VPWR VGND sky130_ef_sc_hd__decap_12
XTAP_TAPCELL_ROW_97_2_3606 VGND VPWR sky130_fd_sc_hd__tapvpwrvgnd_1
XFILLER_3_1357 VPWR VGND VPWR VGND sky130_ef_sc_hd__decap_12
XFILLER_212_805 VGND VGND VPWR VPWR sky130_fd_sc_hd__decap_6
XFILLER_208_1017 VPWR VGND VPWR VGND sky130_ef_sc_hd__decap_12
XFILLER_149_1454 VPWR VGND VPWR VGND sky130_ef_sc_hd__decap_12
XFILLER_97_1386 VPWR VGND VPWR VGND sky130_ef_sc_hd__decap_12
XFILLER_58_1326 VPWR VGND VPWR VGND sky130_ef_sc_hd__decap_12
XFILLER_212_849 VPWR VGND VPWR VGND sky130_ef_sc_hd__decap_12
XFILLER_210_41 VPWR VGND VPWR VGND sky130_ef_sc_hd__decap_12
XFILLER_169_709 VPWR VGND VPWR VGND sky130_ef_sc_hd__decap_12
XFILLER_149_1498 VPWR VGND VPWR VGND sky130_ef_sc_hd__decap_12
XFILLER_36_1602 VGND VGND VPWR VPWR sky130_fd_sc_hd__decap_3
XFILLER_211_337 VPWR VGND VPWR VGND sky130_ef_sc_hd__decap_12
XANTENNA_fanout144_A _083_ VGND VGND VPWR VPWR sky130_fd_sc_hd__diode_2
XFILLER_210_85 VPWR VGND VPWR VGND sky130_ef_sc_hd__decap_12
XFILLER_182_1091 VGND VGND VPWR VPWR sky130_fd_sc_hd__fill_1
XFILLER_177_753 VPWR VGND VPWR VGND sky130_ef_sc_hd__decap_12
XFILLER_192_701 VPWR VGND VPWR VGND sky130_ef_sc_hd__decap_12
XFILLER_178_1105 VPWR VGND VPWR VGND sky130_ef_sc_hd__decap_12
XFILLER_177_797 VPWR VGND VPWR VGND sky130_ef_sc_hd__decap_12
XFILLER_139_39 VPWR VGND VPWR VGND sky130_ef_sc_hd__decap_12
XFILLER_34_1370 VPWR VGND VPWR VGND sky130_ef_sc_hd__decap_12
XFILLER_178_1149 VPWR VGND VPWR VGND sky130_ef_sc_hd__decap_12
XFILLER_164_469 VGND VGND VPWR VPWR sky130_fd_sc_hd__decap_6
XFILLER_121_1384 VGND VGND VPWR VPWR sky130_fd_sc_hd__fill_1
XFILLER_69_1422 VPWR VGND VPWR VGND sky130_ef_sc_hd__decap_12
XFILLER_156_1414 VPWR VGND VPWR VGND sky130_ef_sc_hd__decap_12
XFILLER_155_27 VPWR VGND VPWR VGND sky130_ef_sc_hd__decap_12
XFILLER_69_1466 VPWR VGND VPWR VGND sky130_ef_sc_hd__decap_12
XPHY_EDGE_ROW_55_1_Left_274 VGND VGND VPWR VPWR sky130_fd_sc_hd__decap_3
XFILLER_171_15 VPWR VGND VPWR VGND sky130_ef_sc_hd__decap_12
XFILLER_8_1246 VPWR VGND VPWR VGND sky130_ef_sc_hd__decap_12
XFILLER_189_1201 VPWR VGND VPWR VGND sky130_ef_sc_hd__decap_12
XANTENNA__491__B1 net135 VGND VGND VPWR VPWR sky130_fd_sc_hd__diode_2
XFILLER_41_1330 VPWR VGND VPWR VGND sky130_ef_sc_hd__decap_12
XFILLER_206_109 VPWR VGND VPWR VGND sky130_ef_sc_hd__decap_12
XFILLER_189_1245 VPWR VGND VPWR VGND sky130_ef_sc_hd__decap_12
XFILLER_104_53 VPWR VGND VPWR VGND sky130_ef_sc_hd__decap_12
XFILLER_73_125 VGND VGND VPWR VPWR sky130_fd_sc_hd__fill_2
XFILLER_189_1289 VPWR VGND VPWR VGND sky130_ef_sc_hd__decap_12
XFILLER_104_97 VPWR VGND VPWR VGND sky130_ef_sc_hd__decap_12
XFILLER_215_665 VGND VGND VPWR VPWR sky130_fd_sc_hd__decap_6
XFILLER_76_1426 VPWR VGND VPWR VGND sky130_ef_sc_hd__decap_12
XFILLER_214_153 VPWR VGND VPWR VGND sky130_ef_sc_hd__decap_12
XFILLER_187_517 VPWR VGND VPWR VGND sky130_ef_sc_hd__decap_12
XFILLER_163_1429 VPWR VGND VPWR VGND sky130_ef_sc_hd__decap_12
XFILLER_154_3 VPWR VGND VPWR VGND sky130_ef_sc_hd__decap_12
XFILLER_128_1538 VPWR VGND VPWR VGND sky130_ef_sc_hd__decap_12
XFILLER_120_41 VPWR VGND VPWR VGND sky130_ef_sc_hd__decap_12
X_321_ net32 net143 net134 VGND VGND VPWR VPWR s_wdata\[28\] sky130_fd_sc_hd__a21o_1
XFILLER_214_197 VPWR VGND VPWR VGND sky130_ef_sc_hd__decap_12
XPHY_EDGE_ROW_202_Left_421 VGND VGND VPWR VPWR sky130_fd_sc_hd__decap_3
XFILLER_208_1595 VGND VGND VPWR VPWR sky130_fd_sc_hd__fill_1
XFILLER_120_85 VPWR VGND VPWR VGND sky130_ef_sc_hd__decap_12
XFILLER_195_561 VPWR VGND VPWR VGND sky130_ef_sc_hd__decap_12
XFILLER_127_105 VGND VGND VPWR VPWR sky130_fd_sc_hd__decap_6
XFILLER_7_925 VPWR VGND VPWR VGND sky130_ef_sc_hd__decap_12
XFILLER_13_1410 VPWR VGND VPWR VGND sky130_ef_sc_hd__decap_12
XFILLER_202_1161 VPWR VGND VPWR VGND sky130_ef_sc_hd__decap_12
XFILLER_196_1205 VPWR VGND VPWR VGND sky130_ef_sc_hd__decap_12
XFILLER_182_233 VPWR VGND VPWR VGND sky130_ef_sc_hd__decap_12
XFILLER_6_413 VGND VGND VPWR VPWR sky130_fd_sc_hd__decap_6
XFILLER_13_1454 VPWR VGND VPWR VGND sky130_ef_sc_hd__decap_12
XFILLER_17_1590 VPWR VGND VPWR VGND sky130_ef_sc_hd__decap_12
XFILLER_52_1470 VPWR VGND VPWR VGND sky130_ef_sc_hd__decap_12
XFILLER_104_1582 VPWR VGND VPWR VGND sky130_ef_sc_hd__decap_12
XFILLER_87_1522 VPWR VGND VPWR VGND sky130_ef_sc_hd__decap_12
XFILLER_6_457 VPWR VGND VPWR VGND sky130_ef_sc_hd__decap_12
XFILLER_182_277 VPWR VGND VPWR VGND sky130_ef_sc_hd__decap_12
XFILLER_164_981 VPWR VGND VPWR VGND sky130_ef_sc_hd__decap_12
XFILLER_100_1468 VGND VGND VPWR VPWR sky130_fd_sc_hd__fill_1
XFILLER_87_1566 VPWR VGND VPWR VGND sky130_ef_sc_hd__decap_12
XFILLER_6_479 VPWR VGND VPWR VGND sky130_ef_sc_hd__decap_12
XFILLER_13_1498 VPWR VGND VPWR VGND sky130_ef_sc_hd__decap_12
XFILLER_48_1506 VPWR VGND VPWR VGND sky130_ef_sc_hd__decap_12
XPHY_EDGE_ROW_211_Left_430 VGND VGND VPWR VPWR sky130_fd_sc_hd__decap_3
XFILLER_215_1511 VGND VGND VPWR VPWR sky130_fd_sc_hd__fill_1
XFILLER_145_93 VPWR VGND VPWR VGND sky130_ef_sc_hd__decap_12
XTAP_TAPCELL_ROW_115_2_3725 VGND VPWR sky130_fd_sc_hd__tapvpwrvgnd_1
XFILLER_2_696 VGND VGND VPWR VPWR sky130_fd_sc_hd__decap_4
XFILLER_1_184 VGND VGND VPWR VPWR sky130_fd_sc_hd__fill_1
XFILLER_133_1244 VPWR VGND VPWR VGND sky130_ef_sc_hd__decap_12
XFILLER_150_1580 VGND VGND VPWR VPWR sky130_fd_sc_hd__fill_1
XFILLER_20_1414 VPWR VGND VPWR VGND sky130_ef_sc_hd__decap_12
XFILLER_24_1550 VPWR VGND VPWR VGND sky130_ef_sc_hd__decap_12
XFILLER_219_993 VPWR VGND VPWR VGND sky130_ef_sc_hd__decap_12
XFILLER_168_1329 VPWR VGND VPWR VGND sky130_ef_sc_hd__decap_12
XFILLER_161_81 VPWR VGND VPWR VGND sky130_ef_sc_hd__decap_12
XFILLER_24_1594 VGND VGND VPWR VPWR sky130_fd_sc_hd__decap_8
XFILLER_59_1602 VGND VGND VPWR VPWR sky130_fd_sc_hd__decap_3
XFILLER_206_643 VGND VGND VPWR VPWR sky130_fd_sc_hd__fill_1
XFILLER_94_1526 VPWR VGND VPWR VGND sky130_ef_sc_hd__decap_12
XFILLER_209_1337 VGND VGND VPWR VPWR sky130_fd_sc_hd__decap_6
X_519_ net150 _197_ net128 net137 _233_ VGND VGND VPWR VPWR _043_ sky130_fd_sc_hd__o311a_1
XFILLER_92_1294 VGND VGND VPWR VPWR sky130_fd_sc_hd__decap_6
XANTENNA__537__A1 net151 VGND VGND VPWR VPWR sky130_fd_sc_hd__diode_2
XFILLER_202_893 VPWR VGND VPWR VGND sky130_ef_sc_hd__decap_12
XFILLER_174_701 VPWR VGND VPWR VGND sky130_ef_sc_hd__decap_12
XTAP_TAPCELL_ROW_8_2_3033 VGND VPWR sky130_fd_sc_hd__tapvpwrvgnd_1
XPHY_EDGE_ROW_9_2_Right_66 VGND VGND VPWR VPWR sky130_fd_sc_hd__decap_3
XFILLER_31_1510 VPWR VGND VPWR VGND sky130_ef_sc_hd__decap_12
XFILLER_53_1256 VPWR VGND VPWR VGND sky130_ef_sc_hd__decap_12
XFILLER_179_1425 VPWR VGND VPWR VGND sky130_ef_sc_hd__decap_12
XTAP_TAPCELL_ROW_157_1_1331 VGND VPWR sky130_fd_sc_hd__tapvpwrvgnd_1
XFILLER_179_1469 VPWR VGND VPWR VGND sky130_ef_sc_hd__decap_12
XFILLER_31_1554 VPWR VGND VPWR VGND sky130_ef_sc_hd__decap_12
XTAP_TAPCELL_ROW_62_1_1142 VGND VPWR sky130_fd_sc_hd__tapvpwrvgnd_1
XFILLER_173_1057 VGND VGND VPWR VPWR sky130_fd_sc_hd__decap_6
XFILLER_170_973 VGND VGND VPWR VPWR sky130_fd_sc_hd__decap_6
XFILLER_9_1522 VPWR VGND VPWR VGND sky130_ef_sc_hd__decap_12
XFILLER_190_1371 VGND VGND VPWR VPWR sky130_fd_sc_hd__fill_1
XFILLER_151_1322 VGND VGND VPWR VPWR sky130_fd_sc_hd__decap_6
XTAP_TAPCELL_ROW_4_917 VGND VPWR sky130_fd_sc_hd__tapvpwrvgnd_1
XTAP_TAPCELL_ROW_4_906 VGND VPWR sky130_fd_sc_hd__tapvpwrvgnd_1
XFILLER_9_1566 VPWR VGND VPWR VGND sky130_ef_sc_hd__decap_12
XFILLER_151_1366 VPWR VGND VPWR VGND sky130_ef_sc_hd__decap_12
XTAP_TAPCELL_ROW_150_1_1318 VGND VPWR sky130_fd_sc_hd__tapvpwrvgnd_1
XTAP_TAPCELL_ROW_184_1979 VGND VPWR sky130_fd_sc_hd__tapvpwrvgnd_1
XFILLER_3_1121 VPWR VGND VPWR VGND sky130_ef_sc_hd__decap_12
XFILLER_55_125 VGND VGND VPWR VPWR sky130_fd_sc_hd__fill_2
XFILLER_186_1429 VPWR VGND VPWR VGND sky130_ef_sc_hd__decap_12
XFILLER_212_613 VPWR VGND VPWR VGND sky130_ef_sc_hd__decap_12
XFILLER_34_27 VGND VGND VPWR VPWR sky130_fd_sc_hd__fill_1
XFILLER_212_657 VPWR VGND VPWR VGND sky130_ef_sc_hd__decap_12
XFILLER_184_1197 VGND VGND VPWR VPWR sky130_fd_sc_hd__decap_6
XFILLER_180_1017 VPWR VGND VPWR VGND sky130_ef_sc_hd__decap_12
XFILLER_169_517 VPWR VGND VPWR VGND sky130_ef_sc_hd__decap_12
XFILLER_211_167 VGND VGND VPWR VPWR sky130_fd_sc_hd__fill_1
XANTENNA_fanout147_X net147 VGND VGND VPWR VPWR sky130_fd_sc_hd__diode_2
XFILLER_177_561 VPWR VGND VPWR VGND sky130_ef_sc_hd__decap_12
XFILLER_162_1462 VGND VGND VPWR VPWR sky130_fd_sc_hd__decap_6
XFILLER_109_105 VGND VGND VPWR VPWR sky130_fd_sc_hd__decap_6
XFILLER_71_1378 VGND VGND VPWR VPWR sky130_fd_sc_hd__decap_6
Xclkload4 clknet_3_5_0_clk VGND VGND VPWR VPWR clkload4/Y sky130_fd_sc_hd__inv_8
XFILLER_197_1525 VPWR VGND VPWR VGND sky130_ef_sc_hd__decap_12
XFILLER_192_531 VGND VGND VPWR VPWR sky130_fd_sc_hd__fill_1
XFILLER_166_15 VPWR VGND VPWR VGND sky130_ef_sc_hd__decap_12
XFILLER_164_233 VPWR VGND VPWR VGND sky130_ef_sc_hd__decap_12
XFILLER_203_1481 VPWR VGND VPWR VGND sky130_ef_sc_hd__decap_12
XFILLER_197_1569 VPWR VGND VPWR VGND sky130_ef_sc_hd__decap_12
XFILLER_180_737 VPWR VGND VPWR VGND sky130_ef_sc_hd__decap_12
XFILLER_164_277 VPWR VGND VPWR VGND sky130_ef_sc_hd__decap_12
XFILLER_3_405 VPWR VGND VPWR VGND sky130_ef_sc_hd__decap_12
XFILLER_191_1113 VGND VGND VPWR VPWR sky130_fd_sc_hd__decap_6
XFILLER_156_1244 VGND VGND VPWR VPWR sky130_fd_sc_hd__fill_1
XFILLER_69_1274 VPWR VGND VPWR VGND sky130_ef_sc_hd__decap_12
XFILLER_3_449 VPWR VGND VPWR VGND sky130_ef_sc_hd__decap_12
XFILLER_191_1157 VPWR VGND VPWR VGND sky130_ef_sc_hd__decap_12
XTAP_TAPCELL_ROW_101_2_3633 VGND VPWR sky130_fd_sc_hd__tapvpwrvgnd_1
XFILLER_59_57 VPWR VGND VPWR VGND sky130_ef_sc_hd__decap_12
XFILLER_130_1406 VGND VGND VPWR VPWR sky130_fd_sc_hd__decap_6
XFILLER_210_1441 VPWR VGND VPWR VGND sky130_ef_sc_hd__decap_12
XFILLER_207_429 VPWR VGND VPWR VGND sky130_ef_sc_hd__decap_12
XFILLER_210_1485 VPWR VGND VPWR VGND sky130_ef_sc_hd__decap_12
XFILLER_131_51 VGND VGND VPWR VPWR sky130_fd_sc_hd__decap_4
XFILLER_215_473 VPWR VGND VPWR VGND sky130_ef_sc_hd__decap_12
XFILLER_128_1302 VPWR VGND VPWR VGND sky130_ef_sc_hd__decap_12
XTAP_TAPCELL_ROW_202_2496 VGND VPWR sky130_fd_sc_hd__tapvpwrvgnd_1
XTAP_TAPCELL_ROW_202_2485 VGND VPWR sky130_fd_sc_hd__tapvpwrvgnd_1
XFILLER_188_837 VPWR VGND VPWR VGND sky130_ef_sc_hd__decap_12
XFILLER_91_55 VGND VGND VPWR VPWR sky130_fd_sc_hd__fill_1
XTAP_TAPCELL_ROW_194_2264 VGND VPWR sky130_fd_sc_hd__tapvpwrvgnd_1
X_304_ net14 net142 net132 VGND VGND VPWR VPWR s_wdata\[11\] sky130_fd_sc_hd__a21o_1
XTAP_TAPCELL_ROW_219_2971 VGND VPWR sky130_fd_sc_hd__tapvpwrvgnd_1
XFILLER_202_189 VGND VGND VPWR VPWR sky130_fd_sc_hd__decap_6
XFILLER_196_881 VPWR VGND VPWR VGND sky130_ef_sc_hd__decap_12
XTAP_TAPCELL_ROW_194_2275 VGND VPWR sky130_fd_sc_hd__tapvpwrvgnd_1
XPHY_EDGE_ROW_94_1_Right_680 VGND VGND VPWR VPWR sky130_fd_sc_hd__decap_3
XPHY_EDGE_ROW_7_Left_227 VGND VGND VPWR VPWR sky130_fd_sc_hd__decap_3
XTAP_TAPCELL_ROW_219_2993 VGND VPWR sky130_fd_sc_hd__tapvpwrvgnd_1
XTAP_TAPCELL_ROW_219_2982 VGND VPWR sky130_fd_sc_hd__tapvpwrvgnd_1
XFILLER_195_391 VGND VGND VPWR VPWR sky130_fd_sc_hd__fill_1
XFILLER_180_1595 VGND VGND VPWR VPWR sky130_fd_sc_hd__fill_1
XFILLER_141_1546 VGND VGND VPWR VPWR sky130_fd_sc_hd__decap_6
XTAP_TAPCELL_ROW_215_2879 VGND VPWR sky130_fd_sc_hd__tapvpwrvgnd_1
XTAP_TAPCELL_ROW_215_2868 VGND VPWR sky130_fd_sc_hd__tapvpwrvgnd_1
XTAP_TAPCELL_ROW_215_2857 VGND VPWR sky130_fd_sc_hd__tapvpwrvgnd_1
XFILLER_196_1035 VGND VGND VPWR VPWR sky130_fd_sc_hd__fill_1
XFILLER_183_553 VGND VGND VPWR VPWR sky130_fd_sc_hd__decap_6
XFILLER_6_243 VGND VGND VPWR VPWR sky130_fd_sc_hd__decap_8
XFILLER_183_597 VPWR VGND VPWR VGND sky130_ef_sc_hd__decap_12
XFILLER_100_1232 VPWR VGND VPWR VGND sky130_ef_sc_hd__decap_12
XFILLER_87_1330 VPWR VGND VPWR VGND sky130_ef_sc_hd__decap_12
XFILLER_139_1442 VPWR VGND VPWR VGND sky130_ef_sc_hd__decap_12
XFILLER_48_1314 VPWR VGND VPWR VGND sky130_ef_sc_hd__decap_12
XFILLER_48_1358 VPWR VGND VPWR VGND sky130_ef_sc_hd__decap_12
XFILLER_135_1328 VGND VGND VPWR VPWR sky130_fd_sc_hd__fill_1
XFILLER_2_493 VGND VGND VPWR VPWR sky130_fd_sc_hd__decap_4
XTAP_TAPCELL_ROW_160_2_4015 VGND VPWR sky130_fd_sc_hd__tapvpwrvgnd_1
XTAP_TAPCELL_ROW_159_2_4009 VGND VPWR sky130_fd_sc_hd__tapvpwrvgnd_1
XTAP_TAPCELL_ROW_145_2_3920 VGND VPWR sky130_fd_sc_hd__tapvpwrvgnd_1
XFILLER_4_1441 VPWR VGND VPWR VGND sky130_ef_sc_hd__decap_12
XFILLER_98_1470 VPWR VGND VPWR VGND sky130_ef_sc_hd__decap_12
XFILLER_4_1485 VPWR VGND VPWR VGND sky130_ef_sc_hd__decap_12
XFILLER_20_1244 VGND VGND VPWR VPWR sky130_fd_sc_hd__fill_1
XFILLER_59_1410 VPWR VGND VPWR VGND sky130_ef_sc_hd__decap_12
XFILLER_209_1101 VPWR VGND VPWR VGND sky130_ef_sc_hd__decap_12
XFILLER_59_1454 VPWR VGND VPWR VGND sky130_ef_sc_hd__decap_12
XFILLER_209_1145 VPWR VGND VPWR VGND sky130_ef_sc_hd__decap_12
XFILLER_181_1337 VGND VGND VPWR VPWR sky130_fd_sc_hd__decap_6
XFILLER_94_1356 VGND VGND VPWR VPWR sky130_fd_sc_hd__fill_1
XFILLER_59_1498 VPWR VGND VPWR VGND sky130_ef_sc_hd__decap_12
XFILLER_209_1189 VPWR VGND VPWR VGND sky130_ef_sc_hd__decap_12
XFILLER_205_1009 VPWR VGND VPWR VGND sky130_ef_sc_hd__decap_12
XFILLER_146_1468 VGND VGND VPWR VPWR sky130_fd_sc_hd__fill_1
XFILLER_193_317 VPWR VGND VPWR VGND sky130_ef_sc_hd__decap_12
XPHY_EDGE_ROW_22_2_Left_454 VGND VGND VPWR VPWR sky130_fd_sc_hd__decap_3
XTAP_TAPCELL_ROW_177_1794 VGND VPWR sky130_fd_sc_hd__tapvpwrvgnd_1
XTAP_TAPCELL_ROW_177_1783 VGND VPWR sky130_fd_sc_hd__tapvpwrvgnd_1
XTAP_TAPCELL_ROW_177_1772 VGND VPWR sky130_fd_sc_hd__tapvpwrvgnd_1
XFILLER_174_531 VGND VGND VPWR VPWR sky130_fd_sc_hd__fill_1
XFILLER_179_1233 VPWR VGND VPWR VGND sky130_ef_sc_hd__decap_12
XTAP_TAPCELL_ROW_173_1669 VGND VPWR sky130_fd_sc_hd__tapvpwrvgnd_1
XTAP_TAPCELL_ROW_173_1658 VGND VPWR sky130_fd_sc_hd__tapvpwrvgnd_1
XFILLER_175_1119 VGND VGND VPWR VPWR sky130_fd_sc_hd__fill_1
XTAP_TAPCELL_ROW_93_1_1203 VGND VPWR sky130_fd_sc_hd__tapvpwrvgnd_1
XFILLER_20_29 VPWR VGND VPWR VGND sky130_ef_sc_hd__decap_12
XFILLER_31_1384 VGND VGND VPWR VPWR sky130_fd_sc_hd__fill_1
XFILLER_136_29 VPWR VGND VPWR VGND sky130_ef_sc_hd__decap_12
XTAP_TAPCELL_ROW_74_2_3459 VGND VPWR sky130_fd_sc_hd__tapvpwrvgnd_1
XFILLER_66_1414 VPWR VGND VPWR VGND sky130_ef_sc_hd__decap_12
XFILLER_216_1105 VPWR VGND VPWR VGND sky130_ef_sc_hd__decap_12
XFILLER_170_781 VPWR VGND VPWR VGND sky130_ef_sc_hd__decap_12
XFILLER_118_1526 VPWR VGND VPWR VGND sky130_ef_sc_hd__decap_12
XFILLER_216_1149 VPWR VGND VPWR VGND sky130_ef_sc_hd__decap_12
XFILLER_192_1477 VGND VGND VPWR VPWR sky130_fd_sc_hd__decap_6
XFILLER_9_1330 VPWR VGND VPWR VGND sky130_ef_sc_hd__decap_12
XFILLER_29_38 VGND VGND VPWR VPWR sky130_fd_sc_hd__fill_1
XFILLER_29_27 VGND VGND VPWR VPWR sky130_fd_sc_hd__fill_1
XFILLER_116_1294 VGND VGND VPWR VPWR sky130_fd_sc_hd__decap_6
XFILLER_28_114 VPWR VGND VPWR VGND sky130_ef_sc_hd__decap_12
XFILLER_217_727 VGND VGND VPWR VPWR sky130_fd_sc_hd__fill_1
XFILLER_99_1256 VPWR VGND VPWR VGND sky130_ef_sc_hd__decap_12
XTAP_TAPCELL_ROW_34_2_3200 VGND VPWR sky130_fd_sc_hd__tapvpwrvgnd_1
XFILLER_77_1510 VPWR VGND VPWR VGND sky130_ef_sc_hd__decap_12
XFILLER_45_15 VPWR VGND VPWR VGND sky130_ef_sc_hd__decap_12
XFILLER_186_1259 VGND VGND VPWR VPWR sky130_fd_sc_hd__fill_1
XFILLER_77_1554 VPWR VGND VPWR VGND sky130_ef_sc_hd__decap_12
XFILLER_213_933 VPWR VGND VPWR VGND sky130_ef_sc_hd__decap_12
XFILLER_212_421 VPWR VGND VPWR VGND sky130_ef_sc_hd__decap_12
XANTENNA__394__A b_addr\[2\] VGND VGND VPWR VPWR sky130_fd_sc_hd__diode_2
XFILLER_38_1538 VPWR VGND VPWR VGND sky130_ef_sc_hd__decap_12
XFILLER_213_977 VPWR VGND VPWR VGND sky130_ef_sc_hd__decap_12
XFILLER_196_133 VGND VGND VPWR VPWR sky130_fd_sc_hd__decap_6
XFILLER_196_177 VPWR VGND VPWR VGND sky130_ef_sc_hd__decap_12
XFILLER_178_881 VPWR VGND VPWR VGND sky130_ef_sc_hd__decap_12
XFILLER_162_1270 VPWR VGND VPWR VGND sky130_ef_sc_hd__decap_12
XFILLER_177_391 VGND VGND VPWR VPWR sky130_fd_sc_hd__fill_1
XFILLER_123_1232 VPWR VGND VPWR VGND sky130_ef_sc_hd__decap_12
XFILLER_61_69 VPWR VGND VPWR VGND sky130_ef_sc_hd__decap_12
XFILLER_177_69 VPWR VGND VPWR VGND sky130_ef_sc_hd__decap_12
XFILLER_165_553 VGND VGND VPWR VPWR sky130_fd_sc_hd__decap_6
XFILLER_193_895 VGND VGND VPWR VPWR sky130_fd_sc_hd__fill_1
XFILLER_180_501 VPWR VGND VPWR VGND sky130_ef_sc_hd__decap_12
XFILLER_165_597 VPWR VGND VPWR VGND sky130_ef_sc_hd__decap_12
XFILLER_123_1298 VPWR VGND VPWR VGND sky130_ef_sc_hd__decap_12
XFILLER_117_3 VPWR VGND VPWR VGND sky130_ef_sc_hd__decap_12
XFILLER_101_1552 VGND VGND VPWR VPWR sky130_fd_sc_hd__fill_1
XFILLER_14_1582 VPWR VGND VPWR VGND sky130_ef_sc_hd__decap_12
XTAP_TAPCELL_ROW_210_2732 VGND VPWR sky130_fd_sc_hd__tapvpwrvgnd_1
XTAP_TAPCELL_ROW_210_2721 VGND VPWR sky130_fd_sc_hd__tapvpwrvgnd_1
XFILLER_197_1399 VGND VGND VPWR VPWR sky130_fd_sc_hd__fill_1
XFILLER_180_545 VPWR VGND VPWR VGND sky130_ef_sc_hd__decap_12
XFILLER_10_1468 VGND VGND VPWR VPWR sky130_fd_sc_hd__fill_1
XFILLER_193_57 VPWR VGND VPWR VGND sky130_ef_sc_hd__decap_12
XFILLER_180_589 VPWR VGND VPWR VGND sky130_ef_sc_hd__decap_12
XFILLER_4_769 VGND VGND VPWR VPWR sky130_fd_sc_hd__fill_1
XFILLER_3_279 VGND VGND VPWR VPWR sky130_fd_sc_hd__fill_1
XFILLER_134_1350 VGND VGND VPWR VPWR sky130_fd_sc_hd__decap_6
XFILLER_82_1282 VPWR VGND VPWR VGND sky130_ef_sc_hd__decap_12
XFILLER_0_975 VGND VGND VPWR VPWR sky130_fd_sc_hd__decap_4
XFILLER_0_942 VGND VGND VPWR VPWR sky130_fd_sc_hd__decap_3
XANTENNA_input37_A func_wdata[3] VGND VGND VPWR VPWR sky130_fd_sc_hd__diode_2
XTAP_TAPCELL_ROW_119_1_1256 VGND VPWR sky130_fd_sc_hd__tapvpwrvgnd_1
XFILLER_86_77 VGND VGND VPWR VPWR sky130_fd_sc_hd__decap_6
XTAP_TAPCELL_ROW_7_1008 VGND VPWR sky130_fd_sc_hd__tapvpwrvgnd_1
XTAP_TAPCELL_ROW_7_1019 VGND VPWR sky130_fd_sc_hd__tapvpwrvgnd_1
XTAP_TAPCELL_ROW_208_2672 VGND VPWR sky130_fd_sc_hd__tapvpwrvgnd_1
XFILLER_208_749 VGND VGND VPWR VPWR sky130_fd_sc_hd__decap_6
XTAP_TAPCELL_ROW_208_2661 VGND VPWR sky130_fd_sc_hd__tapvpwrvgnd_1
XFILLER_169_1413 VPWR VGND VPWR VGND sky130_ef_sc_hd__decap_12
XFILLER_134_1394 VPWR VGND VPWR VGND sky130_ef_sc_hd__decap_12
XPHY_EDGE_ROW_18_1_Left_237 VGND VGND VPWR VPWR sky130_fd_sc_hd__decap_3
XFILLER_19_125 VGND VGND VPWR VPWR sky130_fd_sc_hd__fill_2
XFILLER_60_1580 VGND VGND VPWR VPWR sky130_fd_sc_hd__fill_1
XFILLER_207_237 VPWR VGND VPWR VGND sky130_ef_sc_hd__decap_12
XTAP_TAPCELL_ROW_204_2558 VGND VPWR sky130_fd_sc_hd__tapvpwrvgnd_1
XTAP_TAPCELL_ROW_204_2547 VGND VPWR sky130_fd_sc_hd__tapvpwrvgnd_1
XFILLER_169_1457 VPWR VGND VPWR VGND sky130_ef_sc_hd__decap_12
XFILLER_142_83 VGND VGND VPWR VPWR sky130_fd_sc_hd__fill_1
XFILLER_130_1258 VPWR VGND VPWR VGND sky130_ef_sc_hd__decap_12
XTAP_TAPCELL_ROW_196_2315 VGND VPWR sky130_fd_sc_hd__tapvpwrvgnd_1
XFILLER_216_793 VPWR VGND VPWR VGND sky130_ef_sc_hd__decap_12
XFILLER_215_281 VPWR VGND VPWR VGND sky130_ef_sc_hd__decap_12
XTAP_TAPCELL_ROW_196_2337 VGND VPWR sky130_fd_sc_hd__tapvpwrvgnd_1
XTAP_TAPCELL_ROW_196_2326 VGND VPWR sky130_fd_sc_hd__tapvpwrvgnd_1
XFILLER_188_601 VPWR VGND VPWR VGND sky130_ef_sc_hd__decap_12
XTAP_TAPCELL_ROW_86_1_1190 VGND VPWR sky130_fd_sc_hd__tapvpwrvgnd_1
XFILLER_206_1329 VPWR VGND VPWR VGND sky130_ef_sc_hd__decap_12
XFILLER_188_645 VPWR VGND VPWR VGND sky130_ef_sc_hd__decap_12
XFILLER_187_111 VGND VGND VPWR VPWR sky130_fd_sc_hd__fill_1
XFILLER_35_81 VGND VGND VPWR VPWR sky130_fd_sc_hd__decap_4
XTAP_TAPCELL_ROW_217_2919 VGND VPWR sky130_fd_sc_hd__tapvpwrvgnd_1
XFILLER_175_317 VPWR VGND VPWR VGND sky130_ef_sc_hd__decap_12
XFILLER_163_1089 VGND VGND VPWR VPWR sky130_fd_sc_hd__decap_3
XFILLER_141_1310 VPWR VGND VPWR VGND sky130_ef_sc_hd__decap_12
XFILLER_145_1490 VGND VGND VPWR VPWR sky130_fd_sc_hd__decap_6
XPHY_EDGE_ROW_95_1_Right_681 VGND VGND VPWR VPWR sky130_fd_sc_hd__decap_3
XFILLER_190_309 VPWR VGND VPWR VGND sky130_ef_sc_hd__decap_12
XFILLER_141_1354 VPWR VGND VPWR VGND sky130_ef_sc_hd__decap_12
XPHY_EDGE_ROW_132_1_Left_351 VGND VGND VPWR VPWR sky130_fd_sc_hd__decap_3
XFILLER_102_1338 VPWR VGND VPWR VGND sky130_ef_sc_hd__decap_12
XFILLER_183_361 VPWR VGND VPWR VGND sky130_ef_sc_hd__decap_12
XFILLER_141_1398 VPWR VGND VPWR VGND sky130_ef_sc_hd__decap_12
XFILLER_7_585 VGND VGND VPWR VPWR sky130_fd_sc_hd__fill_1
XTAP_TAPCELL_ROW_60_2_3367 VGND VPWR sky130_fd_sc_hd__tapvpwrvgnd_1
XFILLER_217_1425 VPWR VGND VPWR VGND sky130_ef_sc_hd__decap_12
XFILLER_174_1141 VGND VGND VPWR VPWR sky130_fd_sc_hd__decap_6
XFILLER_217_1469 VPWR VGND VPWR VGND sky130_ef_sc_hd__decap_12
XFILLER_174_1185 VPWR VGND VPWR VGND sky130_ef_sc_hd__decap_12
XFILLER_170_1005 VPWR VGND VPWR VGND sky130_ef_sc_hd__decap_12
XFILLER_139_1272 VGND VGND VPWR VPWR sky130_fd_sc_hd__fill_1
XFILLER_111_111 VGND VGND VPWR VPWR sky130_fd_sc_hd__fill_1
XFILLER_32_3 VPWR VGND VPWR VGND sky130_ef_sc_hd__decap_12
XFILLER_170_1049 VPWR VGND VPWR VGND sky130_ef_sc_hd__decap_12
XFILLER_61_1322 VGND VGND VPWR VPWR sky130_fd_sc_hd__decap_6
XFILLER_152_1450 VPWR VGND VPWR VGND sky130_ef_sc_hd__decap_12
XFILLER_61_1366 VPWR VGND VPWR VGND sky130_ef_sc_hd__decap_12
XFILLER_211_1057 VGND VGND VPWR VPWR sky130_fd_sc_hd__decap_6
XFILLER_187_1513 VPWR VGND VPWR VGND sky130_ef_sc_hd__decap_12
XTAP_TAPCELL_ROW_181_1905 VGND VPWR sky130_fd_sc_hd__tapvpwrvgnd_1
XTAP_TAPCELL_ROW_166_1484 VGND VPWR sky130_fd_sc_hd__tapvpwrvgnd_1
XTAP_TAPCELL_ROW_166_1473 VGND VPWR sky130_fd_sc_hd__tapvpwrvgnd_1
XTAP_TAPCELL_ROW_166_1462 VGND VPWR sky130_fd_sc_hd__tapvpwrvgnd_1
XFILLER_152_1494 VPWR VGND VPWR VGND sky130_ef_sc_hd__decap_12
XFILLER_113_1434 VGND VGND VPWR VPWR sky130_fd_sc_hd__decap_6
XTAP_TAPCELL_ROW_19_2_3102 VGND VPWR sky130_fd_sc_hd__tapvpwrvgnd_1
XFILLER_113_1478 VPWR VGND VPWR VGND sky130_ef_sc_hd__decap_12
XFILLER_202_53 VPWR VGND VPWR VGND sky130_ef_sc_hd__decap_12
XPHY_EDGE_ROW_171_Left_390 VGND VGND VPWR VPWR sky130_fd_sc_hd__decap_3
XFILLER_181_1101 VPWR VGND VPWR VGND sky130_ef_sc_hd__decap_12
XFILLER_202_97 VPWR VGND VPWR VGND sky130_ef_sc_hd__decap_12
XFILLER_185_1281 VGND VGND VPWR VPWR sky130_fd_sc_hd__decap_6
XFILLER_181_1145 VPWR VGND VPWR VGND sky130_ef_sc_hd__decap_12
XTAP_TAPCELL_ROW_179_1845 VGND VPWR sky130_fd_sc_hd__tapvpwrvgnd_1
XTAP_TAPCELL_ROW_179_1834 VGND VPWR sky130_fd_sc_hd__tapvpwrvgnd_1
XFILLER_178_133 VGND VGND VPWR VPWR sky130_fd_sc_hd__decap_6
XFILLER_146_1232 VPWR VGND VPWR VGND sky130_ef_sc_hd__decap_12
XFILLER_40_109 VPWR VGND VPWR VGND sky130_ef_sc_hd__decap_12
XFILLER_210_925 VPWR VGND VPWR VGND sky130_ef_sc_hd__decap_12
XFILLER_194_637 VGND VGND VPWR VPWR sky130_fd_sc_hd__decap_6
XFILLER_193_125 VPWR VGND VPWR VGND sky130_ef_sc_hd__decap_12
XFILLER_181_1189 VPWR VGND VPWR VGND sky130_ef_sc_hd__decap_12
XFILLER_178_177 VPWR VGND VPWR VGND sky130_ef_sc_hd__decap_12
XFILLER_72_1462 VGND VGND VPWR VPWR sky130_fd_sc_hd__decap_6
XPHY_EDGE_ROW_64_1_Left_283 VGND VGND VPWR VPWR sky130_fd_sc_hd__decap_3
XFILLER_193_169 VPWR VGND VPWR VGND sky130_ef_sc_hd__decap_12
XTAP_TAPCELL_ROW_156_2_3989 VGND VPWR sky130_fd_sc_hd__tapvpwrvgnd_1
XFILLER_124_1574 VGND VGND VPWR VPWR sky130_fd_sc_hd__decap_6
XFILLER_31_39 VGND VGND VPWR VPWR sky130_fd_sc_hd__fill_1
XFILLER_179_1063 VGND VGND VPWR VPWR sky130_fd_sc_hd__fill_1
XFILLER_175_895 VGND VGND VPWR VPWR sky130_fd_sc_hd__fill_1
XFILLER_147_39 VPWR VGND VPWR VGND sky130_ef_sc_hd__decap_12
XFILLER_120_1438 VPWR VGND VPWR VGND sky130_ef_sc_hd__decap_12
XFILLER_194_1539 VGND VGND VPWR VPWR sky130_fd_sc_hd__fill_1
XTAP_TAPCELL_ROW_30_1_1077 VGND VPWR sky130_fd_sc_hd__tapvpwrvgnd_1
XFILLER_192_1241 VPWR VGND VPWR VGND sky130_ef_sc_hd__decap_12
XTAP_TAPCELL_ROW_136_2_3865 VGND VPWR sky130_fd_sc_hd__tapvpwrvgnd_1
XFILLER_66_1244 VGND VGND VPWR VPWR sky130_fd_sc_hd__fill_1
XFILLER_163_27 VGND VGND VPWR VPWR sky130_fd_sc_hd__fill_1
XFILLER_192_1285 VPWR VGND VPWR VGND sky130_ef_sc_hd__decap_12
XFILLER_153_1247 VPWR VGND VPWR VGND sky130_ef_sc_hd__decap_12
XFILLER_118_1356 VGND VGND VPWR VPWR sky130_fd_sc_hd__fill_1
XTAP_TAPCELL_ROW_116_2_3730 VGND VPWR sky130_fd_sc_hd__tapvpwrvgnd_1
XANTENNA__389__A b_addr\[2\] VGND VGND VPWR VPWR sky130_fd_sc_hd__diode_2
XFILLER_40_1406 VGND VGND VPWR VPWR sky130_fd_sc_hd__decap_6
XFILLER_131_1534 VPWR VGND VPWR VGND sky130_ef_sc_hd__decap_12
XFILLER_5_1057 VGND VGND VPWR VPWR sky130_fd_sc_hd__decap_6
XFILLER_131_1578 VPWR VGND VPWR VGND sky130_ef_sc_hd__decap_12
XFILLER_112_53 VPWR VGND VPWR VGND sky130_ef_sc_hd__decap_12
XTAP_TAPCELL_ROW_0_783 VGND VPWR sky130_fd_sc_hd__tapvpwrvgnd_1
XTAP_TAPCELL_ROW_0_750 VGND VPWR sky130_fd_sc_hd__tapvpwrvgnd_1
XTAP_TAPCELL_ROW_0_761 VGND VPWR sky130_fd_sc_hd__tapvpwrvgnd_1
XTAP_TAPCELL_ROW_0_772 VGND VPWR sky130_fd_sc_hd__tapvpwrvgnd_1
XFILLER_38_1302 VPWR VGND VPWR VGND sky130_ef_sc_hd__decap_12
XANTENNA__328__S net140 VGND VGND VPWR VPWR sky130_fd_sc_hd__diode_2
XFILLER_213_741 VPWR VGND VPWR VGND sky130_ef_sc_hd__decap_12
XFILLER_169_111 VGND VGND VPWR VPWR sky130_fd_sc_hd__fill_1
XFILLER_112_97 VPWR VGND VPWR VGND sky130_ef_sc_hd__decap_12
XFILLER_77_1384 VGND VGND VPWR VPWR sky130_fd_sc_hd__fill_1
XTAP_TAPCELL_ROW_0_794 VGND VPWR sky130_fd_sc_hd__tapvpwrvgnd_1
XFILLER_31_109 VGND VGND VPWR VPWR sky130_fd_sc_hd__fill_1
XFILLER_213_785 VPWR VGND VPWR VGND sky130_ef_sc_hd__decap_12
XFILLER_212_251 VGND VGND VPWR VPWR sky130_fd_sc_hd__fill_1
XFILLER_200_413 VGND VGND VPWR VPWR sky130_fd_sc_hd__decap_6
XFILLER_185_615 VGND VGND VPWR VPWR sky130_fd_sc_hd__fill_1
XFILLER_164_1365 VGND VGND VPWR VPWR sky130_fd_sc_hd__decap_6
XFILLER_129_1496 VGND VGND VPWR VPWR sky130_fd_sc_hd__fill_1
XFILLER_200_457 VPWR VGND VPWR VGND sky130_ef_sc_hd__decap_12
XFILLER_197_497 VGND VGND VPWR VPWR sky130_fd_sc_hd__decap_6
XFILLER_90_1562 VPWR VGND VPWR VGND sky130_ef_sc_hd__decap_12
XFILLER_172_309 VPWR VGND VPWR VGND sky130_ef_sc_hd__decap_12
XTAP_TAPCELL_ROW_45_2_3269 VGND VPWR sky130_fd_sc_hd__tapvpwrvgnd_1
XFILLER_51_1546 VGND VGND VPWR VPWR sky130_fd_sc_hd__decap_6
XFILLER_181_821 VPWR VGND VPWR VGND sky130_ef_sc_hd__decap_12
XFILLER_165_361 VPWR VGND VPWR VGND sky130_ef_sc_hd__decap_12
XFILLER_181_865 VPWR VGND VPWR VGND sky130_ef_sc_hd__decap_12
XFILLER_84_1300 VGND VGND VPWR VPWR sky130_fd_sc_hd__fill_1
XFILLER_4_533 VGND VGND VPWR VPWR sky130_fd_sc_hd__decap_6
XFILLER_10_1232 VPWR VGND VPWR VGND sky130_ef_sc_hd__decap_12
XFILLER_21_72 VGND VGND VPWR VPWR sky130_fd_sc_hd__decap_8
XTAP_TAPCELL_ROW_189_2130 VGND VPWR sky130_fd_sc_hd__tapvpwrvgnd_1
XFILLER_98_109 VPWR VGND VPWR VGND sky130_ef_sc_hd__decap_12
XFILLER_49_1442 VPWR VGND VPWR VGND sky130_ef_sc_hd__decap_12
XTAP_TAPCELL_ROW_185_2016 VGND VPWR sky130_fd_sc_hd__tapvpwrvgnd_1
XTAP_TAPCELL_ROW_185_2005 VGND VPWR sky130_fd_sc_hd__tapvpwrvgnd_1
XFILLER_136_1412 VGND VGND VPWR VPWR sky130_fd_sc_hd__fill_1
XFILLER_171_1325 VPWR VGND VPWR VGND sky130_ef_sc_hd__decap_12
XFILLER_45_1328 VGND VGND VPWR VPWR sky130_fd_sc_hd__fill_1
XTAP_TAPCELL_ROW_206_2609 VGND VPWR sky130_fd_sc_hd__tapvpwrvgnd_1
XFILLER_171_1369 VPWR VGND VPWR VGND sky130_ef_sc_hd__decap_12
XFILLER_0_761 VGND VGND VPWR VPWR sky130_fd_sc_hd__fill_2
XFILLER_208_513 VPWR VGND VPWR VGND sky130_ef_sc_hd__decap_12
XFILLER_153_93 VPWR VGND VPWR VGND sky130_ef_sc_hd__decap_12
XTAP_TAPCELL_ROW_55_1_1128 VGND VPWR sky130_fd_sc_hd__tapvpwrvgnd_1
XFILLER_208_557 VPWR VGND VPWR VGND sky130_ef_sc_hd__decap_12
XANTENNA_clkload2_A clknet_3_2_0_clk VGND VGND VPWR VPWR sky130_fd_sc_hd__diode_2
XFILLER_189_921 VPWR VGND VPWR VGND sky130_ef_sc_hd__decap_12
XFILLER_169_1287 VGND VGND VPWR VPWR sky130_fd_sc_hd__fill_1
XFILLER_95_1440 VGND VGND VPWR VPWR sky130_fd_sc_hd__fill_1
XFILLER_1_1455 VGND VGND VPWR VPWR sky130_fd_sc_hd__fill_1
XFILLER_189_965 VPWR VGND VPWR VGND sky130_ef_sc_hd__decap_12
XFILLER_182_1421 VGND VGND VPWR VPWR sky130_fd_sc_hd__decap_6
XFILLER_147_1552 VGND VGND VPWR VPWR sky130_fd_sc_hd__fill_1
XFILLER_22_109 VGND VGND VPWR VPWR sky130_fd_sc_hd__decap_4
XFILLER_203_273 VGND VGND VPWR VPWR sky130_fd_sc_hd__decap_6
XFILLER_188_475 VGND VGND VPWR VPWR sky130_fd_sc_hd__fill_1
XFILLER_182_1465 VPWR VGND VPWR VGND sky130_ef_sc_hd__decap_12
XFILLER_56_1468 VGND VGND VPWR VPWR sky130_fd_sc_hd__fill_1
XFILLER_176_637 VGND VGND VPWR VPWR sky130_fd_sc_hd__decap_6
XFILLER_175_125 VPWR VGND VPWR VGND sky130_ef_sc_hd__decap_12
XFILLER_191_629 VPWR VGND VPWR VGND sky130_ef_sc_hd__decap_12
XFILLER_184_681 VPWR VGND VPWR VGND sky130_ef_sc_hd__decap_12
XFILLER_176_1203 VGND VGND VPWR VPWR sky130_fd_sc_hd__fill_1
XFILLER_175_169 VPWR VGND VPWR VGND sky130_ef_sc_hd__decap_12
XFILLER_163_309 VPWR VGND VPWR VGND sky130_ef_sc_hd__decap_12
XFILLER_106_1282 VPWR VGND VPWR VGND sky130_ef_sc_hd__decap_12
XPHY_EDGE_ROW_96_1_Right_682 VGND VGND VPWR VPWR sky130_fd_sc_hd__decap_3
XFILLER_89_1244 VPWR VGND VPWR VGND sky130_ef_sc_hd__decap_12
XFILLER_7_41 VPWR VGND VPWR VGND sky130_ef_sc_hd__decap_12
XFILLER_219_1509 VGND VGND VPWR VPWR sky130_fd_sc_hd__decap_3
XFILLER_190_139 VGND VGND VPWR VPWR sky130_fd_sc_hd__fill_1
XTAP_TAPCELL_ROW_122_2_3773 VGND VPWR sky130_fd_sc_hd__tapvpwrvgnd_1
XFILLER_7_85 VPWR VGND VPWR VGND sky130_ef_sc_hd__decap_12
XFILLER_7_393 VPWR VGND VPWR VGND sky130_ef_sc_hd__decap_12
XTAP_TAPCELL_ROW_90_2_3562 VGND VPWR sky130_fd_sc_hd__tapvpwrvgnd_1
XTAP_TAPCELL_ROW_89_2_3556 VGND VPWR sky130_fd_sc_hd__tapvpwrvgnd_1
XFILLER_217_1233 VPWR VGND VPWR VGND sky130_ef_sc_hd__decap_12
XFILLER_193_1561 VGND VGND VPWR VPWR sky130_fd_sc_hd__decap_6
XFILLER_28_1526 VPWR VGND VPWR VGND sky130_ef_sc_hd__decap_12
XTAP_TAPCELL_ROW_168_1535 VGND VPWR sky130_fd_sc_hd__tapvpwrvgnd_1
XTAP_TAPCELL_ROW_168_1524 VGND VPWR sky130_fd_sc_hd__tapvpwrvgnd_1
XFILLER_213_1119 VGND VGND VPWR VPWR sky130_fd_sc_hd__fill_1
XFILLER_113_1220 VPWR VGND VPWR VGND sky130_ef_sc_hd__decap_12
XFILLER_26_1294 VGND VGND VPWR VPWR sky130_fd_sc_hd__decap_6
XFILLER_187_1343 VGND VGND VPWR VPWR sky130_fd_sc_hd__fill_1
XFILLER_113_1286 VPWR VGND VPWR VGND sky130_ef_sc_hd__decap_12
XFILLER_199_729 VPWR VGND VPWR VGND sky130_ef_sc_hd__decap_12
XFILLER_148_1338 VPWR VGND VPWR VGND sky130_ef_sc_hd__decap_12
XFILLER_74_1524 VGND VGND VPWR VPWR sky130_fd_sc_hd__fill_1
XFILLER_167_615 VGND VGND VPWR VPWR sky130_fd_sc_hd__fill_1
XFILLER_210_755 VGND VGND VPWR VPWR sky130_fd_sc_hd__fill_1
XFILLER_194_401 VPWR VGND VPWR VGND sky130_ef_sc_hd__decap_12
XFILLER_179_497 VGND VGND VPWR VPWR sky130_fd_sc_hd__decap_6
XFILLER_158_27 VGND VGND VPWR VPWR sky130_fd_sc_hd__fill_1
XTAP_TAPCELL_ROW_31_2_3177 VGND VPWR sky130_fd_sc_hd__tapvpwrvgnd_1
XFILLER_42_27 VGND VGND VPWR VPWR sky130_fd_sc_hd__fill_1
XFILLER_194_445 VPWR VGND VPWR VGND sky130_ef_sc_hd__decap_12
XFILLER_72_1270 VPWR VGND VPWR VGND sky130_ef_sc_hd__decap_12
XFILLER_33_1232 VPWR VGND VPWR VGND sky130_ef_sc_hd__decap_12
XFILLER_194_489 VPWR VGND VPWR VGND sky130_ef_sc_hd__decap_12
XFILLER_124_1382 VPWR VGND VPWR VGND sky130_ef_sc_hd__decap_12
XFILLER_198_1483 VGND VGND VPWR VPWR sky130_fd_sc_hd__fill_1
XFILLER_159_1434 VGND VGND VPWR VPWR sky130_fd_sc_hd__decap_6
XFILLER_120_1246 VPWR VGND VPWR VGND sky130_ef_sc_hd__decap_12
XFILLER_33_1298 VPWR VGND VPWR VGND sky130_ef_sc_hd__decap_12
XFILLER_174_15 VPWR VGND VPWR VGND sky130_ef_sc_hd__decap_12
XFILLER_163_865 VGND VGND VPWR VPWR sky130_fd_sc_hd__decap_3
XFILLER_159_1478 VPWR VGND VPWR VGND sky130_ef_sc_hd__decap_12
XFILLER_11_1552 VGND VGND VPWR VPWR sky130_fd_sc_hd__fill_1
XFILLER_192_1093 VPWR VGND VPWR VGND sky130_ef_sc_hd__decap_12
XFILLER_67_57 VPWR VGND VPWR VGND sky130_ef_sc_hd__decap_12
XFILLER_44_1350 VGND VGND VPWR VPWR sky130_fd_sc_hd__decap_6
XFILLER_218_811 VGND VGND VPWR VPWR sky130_fd_sc_hd__fill_1
XFILLER_188_1129 VPWR VGND VPWR VGND sky130_ef_sc_hd__decap_12
XFILLER_184_3 VPWR VGND VPWR VGND sky130_ef_sc_hd__decap_12
XFILLER_131_1342 VPWR VGND VPWR VGND sky130_ef_sc_hd__decap_12
X_621_ clknet_3_6_0_clk _055_ VGND VGND VPWR VPWR net78 sky130_fd_sc_hd__dfxtp_1
XFILLER_44_1394 VPWR VGND VPWR VGND sky130_ef_sc_hd__decap_12
XFILLER_205_505 VPWR VGND VPWR VGND sky130_ef_sc_hd__decap_12
XFILLER_131_1386 VPWR VGND VPWR VGND sky130_ef_sc_hd__decap_12
XFILLER_40_1258 VPWR VGND VPWR VGND sky130_ef_sc_hd__decap_12
XFILLER_189_217 VGND VGND VPWR VPWR sky130_fd_sc_hd__decap_6
XFILLER_166_1427 VGND VGND VPWR VPWR sky130_fd_sc_hd__fill_1
XFILLER_92_1602 VGND VGND VPWR VPWR sky130_fd_sc_hd__decap_3
X_552_ net51 u_ctrl.cmp_addr\[2\] net122 VGND VGND VPWR VPWR _250_ sky130_fd_sc_hd__mux2_1
XFILLER_207_1413 VPWR VGND VPWR VGND sky130_ef_sc_hd__decap_12
X_483_ net156 _076_ VGND VGND VPWR VPWR _215_ sky130_fd_sc_hd__and2_1
XFILLER_207_1457 VPWR VGND VPWR VGND sky130_ef_sc_hd__decap_12
XFILLER_200_221 VPWR VGND VPWR VGND sky130_ef_sc_hd__decap_12
XFILLER_197_261 VPWR VGND VPWR VGND sky130_ef_sc_hd__decap_12
XFILLER_164_1173 VPWR VGND VPWR VGND sky130_ef_sc_hd__decap_12
XFILLER_51_1310 VPWR VGND VPWR VGND sky130_ef_sc_hd__decap_12
XFILLER_201_1001 VGND VGND VPWR VPWR sky130_fd_sc_hd__decap_6
XFILLER_201_777 VGND VGND VPWR VPWR sky130_fd_sc_hd__decap_6
XFILLER_200_265 VPWR VGND VPWR VGND sky130_ef_sc_hd__decap_12
XFILLER_199_1225 VGND VGND VPWR VPWR sky130_fd_sc_hd__decap_6
XFILLER_186_979 VGND VGND VPWR VPWR sky130_fd_sc_hd__fill_1
XFILLER_157_125 VGND VGND VPWR VPWR sky130_fd_sc_hd__fill_2
XFILLER_90_1370 VPWR VGND VPWR VGND sky130_ef_sc_hd__decap_12
XFILLER_8_124 VGND VGND VPWR VPWR sky130_fd_sc_hd__decap_3
XFILLER_55_1490 VGND VGND VPWR VPWR sky130_fd_sc_hd__decap_6
XFILLER_201_1045 VPWR VGND VPWR VGND sky130_ef_sc_hd__decap_12
XFILLER_199_1269 VPWR VGND VPWR VGND sky130_ef_sc_hd__decap_12
XFILLER_173_629 VPWR VGND VPWR VGND sky130_ef_sc_hd__decap_12
XFILLER_142_1482 VPWR VGND VPWR VGND sky130_ef_sc_hd__decap_12
XTAP_TAPCELL_ROW_107_2_3675 VGND VPWR sky130_fd_sc_hd__tapvpwrvgnd_1
XFILLER_103_1422 VPWR VGND VPWR VGND sky130_ef_sc_hd__decap_12
XFILLER_51_1354 VPWR VGND VPWR VGND sky130_ef_sc_hd__decap_12
XFILLER_172_139 VGND VGND VPWR VPWR sky130_fd_sc_hd__fill_1
XFILLER_166_681 VPWR VGND VPWR VGND sky130_ef_sc_hd__decap_12
XFILLER_103_1466 VPWR VGND VPWR VGND sky130_ef_sc_hd__decap_12
XFILLER_86_1406 VGND VGND VPWR VPWR sky130_fd_sc_hd__decap_6
XFILLER_12_1338 VPWR VGND VPWR VGND sky130_ef_sc_hd__decap_12
XFILLER_51_1398 VPWR VGND VPWR VGND sky130_ef_sc_hd__decap_12
XFILLER_201_1089 VPWR VGND VPWR VGND sky130_ef_sc_hd__decap_12
XFILLER_181_673 VPWR VGND VPWR VGND sky130_ef_sc_hd__decap_12
XFILLER_177_1567 VGND VGND VPWR VPWR sky130_fd_sc_hd__fill_1
XFILLER_138_1518 VGND VGND VPWR VPWR sky130_fd_sc_hd__decap_6
XTAP_TAPCELL_ROW_75_2_3464 VGND VPWR sky130_fd_sc_hd__tapvpwrvgnd_1
XFILLER_4_352 VPWR VGND VPWR VGND sky130_ef_sc_hd__decap_12
XFILLER_5_897 VPWR VGND VPWR VGND sky130_ef_sc_hd__decap_12
XFILLER_218_1553 VPWR VGND VPWR VGND sky130_ef_sc_hd__decap_12
XFILLER_171_1133 VPWR VGND VPWR VGND sky130_ef_sc_hd__decap_12
XFILLER_136_1220 VPWR VGND VPWR VGND sky130_ef_sc_hd__decap_12
XFILLER_49_1272 VGND VGND VPWR VPWR sky130_fd_sc_hd__fill_1
XFILLER_218_1597 VGND VGND VPWR VPWR sky130_fd_sc_hd__decap_8
XTAP_TAPCELL_ROW_100_2_3629 VGND VPWR sky130_fd_sc_hd__tapvpwrvgnd_1
XFILLER_171_1177 VPWR VGND VPWR VGND sky130_ef_sc_hd__decap_12
XFILLER_62_1450 VPWR VGND VPWR VGND sky130_ef_sc_hd__decap_12
XFILLER_212_1141 VGND VGND VPWR VPWR sky130_fd_sc_hd__decap_6
XFILLER_209_833 VGND VGND VPWR VPWR sky130_fd_sc_hd__decap_6
XFILLER_208_321 VPWR VGND VPWR VGND sky130_ef_sc_hd__decap_12
XFILLER_114_1562 VPWR VGND VPWR VGND sky130_ef_sc_hd__decap_12
XFILLER_23_1434 VGND VGND VPWR VPWR sky130_fd_sc_hd__decap_6
XPHY_EDGE_ROW_31_2_Left_463 VGND VGND VPWR VPWR sky130_fd_sc_hd__decap_3
XFILLER_62_1494 VPWR VGND VPWR VGND sky130_ef_sc_hd__decap_12
XFILLER_212_1185 VPWR VGND VPWR VGND sky130_ef_sc_hd__decap_12
XFILLER_209_877 VPWR VGND VPWR VGND sky130_ef_sc_hd__decap_12
XFILLER_208_365 VPWR VGND VPWR VGND sky130_ef_sc_hd__decap_12
XFILLER_110_1426 VPWR VGND VPWR VGND sky130_ef_sc_hd__decap_12
XFILLER_97_1546 VGND VGND VPWR VPWR sky130_fd_sc_hd__decap_6
XFILLER_23_1478 VPWR VGND VPWR VGND sky130_ef_sc_hd__decap_12
XANTENNA__476__B _180_ VGND VGND VPWR VPWR sky130_fd_sc_hd__diode_2
XFILLER_108_1300 VGND VGND VPWR VPWR sky130_fd_sc_hd__fill_1
XTAP_TAPCELL_ROW_16_2_3079 VGND VPWR sky130_fd_sc_hd__tapvpwrvgnd_1
XFILLER_56_1232 VPWR VGND VPWR VGND sky130_ef_sc_hd__decap_12
XFILLER_182_1273 VPWR VGND VPWR VGND sky130_ef_sc_hd__decap_12
XFILLER_176_401 VPWR VGND VPWR VGND sky130_ef_sc_hd__decap_12
XFILLER_192_905 VPWR VGND VPWR VGND sky130_ef_sc_hd__decap_12
XFILLER_176_445 VPWR VGND VPWR VGND sky130_ef_sc_hd__decap_12
XFILLER_143_1268 VGND VGND VPWR VPWR sky130_fd_sc_hd__decap_4
XFILLER_73_1590 VPWR VGND VPWR VGND sky130_ef_sc_hd__decap_12
XFILLER_192_949 VPWR VGND VPWR VGND sky130_ef_sc_hd__decap_12
XFILLER_178_1309 VGND VGND VPWR VPWR sky130_fd_sc_hd__decap_6
XFILLER_176_489 VPWR VGND VPWR VGND sky130_ef_sc_hd__decap_12
XFILLER_160_1582 VPWR VGND VPWR VGND sky130_ef_sc_hd__decap_12
XFILLER_121_1522 VPWR VGND VPWR VGND sky130_ef_sc_hd__decap_12
XFILLER_12_19 VGND VGND VPWR VPWR sky130_fd_sc_hd__decap_8
XFILLER_34_1574 VGND VGND VPWR VPWR sky130_fd_sc_hd__decap_6
XFILLER_121_1566 VPWR VGND VPWR VGND sky130_ef_sc_hd__decap_12
XPHY_EDGE_ROW_97_1_Right_683 VGND VGND VPWR VPWR sky130_fd_sc_hd__decap_3
XFILLER_30_1438 VPWR VGND VPWR VGND sky130_ef_sc_hd__decap_12
XFILLER_219_1317 VPWR VGND VPWR VGND sky130_ef_sc_hd__decap_12
XFILLER_208_41 VPWR VGND VPWR VGND sky130_ef_sc_hd__decap_12
XFILLER_208_85 VPWR VGND VPWR VGND sky130_ef_sc_hd__decap_12
XFILLER_171_161 VGND VGND VPWR VPWR sky130_fd_sc_hd__decap_6
XFILLER_144_29 VPWR VGND VPWR VGND sky130_ef_sc_hd__decap_12
XFILLER_119_1440 VGND VGND VPWR VPWR sky130_fd_sc_hd__fill_1
XFILLER_8_1406 VGND VGND VPWR VPWR sky130_fd_sc_hd__decap_6
XFILLER_217_1063 VGND VGND VPWR VPWR sky130_fd_sc_hd__fill_1
XFILLER_28_1356 VGND VGND VPWR VPWR sky130_fd_sc_hd__fill_1
XPHY_EDGE_ROW_42_2_Right_99 VGND VGND VPWR VPWR sky130_fd_sc_hd__decap_3
XFILLER_80_1550 VPWR VGND VPWR VGND sky130_ef_sc_hd__decap_12
XFILLER_189_1449 VGND VGND VPWR VPWR sky130_fd_sc_hd__decap_6
XFILLER_80_1594 VGND VGND VPWR VPWR sky130_fd_sc_hd__decap_8
XFILLER_2_1005 VPWR VGND VPWR VGND sky130_ef_sc_hd__decap_12
XFILLER_6_1141 VGND VGND VPWR VPWR sky130_fd_sc_hd__decap_6
XFILLER_37_27 VPWR VGND VPWR VGND sky130_ef_sc_hd__decap_12
XFILLER_41_1534 VPWR VGND VPWR VGND sky130_ef_sc_hd__decap_12
XTAP_TAPCELL_ROW_144_2_3916 VGND VPWR sky130_fd_sc_hd__tapvpwrvgnd_1
XTAP_TAPCELL_ROW_2_856 VGND VPWR sky130_fd_sc_hd__tapvpwrvgnd_1
XTAP_TAPCELL_ROW_2_845 VGND VPWR sky130_fd_sc_hd__tapvpwrvgnd_1
XFILLER_6_1185 VPWR VGND VPWR VGND sky130_ef_sc_hd__decap_12
XFILLER_41_1578 VPWR VGND VPWR VGND sky130_ef_sc_hd__decap_12
XFILLER_2_1049 VPWR VGND VPWR VGND sky130_ef_sc_hd__decap_12
XFILLER_214_357 VGND VGND VPWR VPWR sky130_fd_sc_hd__decap_6
XFILLER_199_559 VGND VGND VPWR VPWR sky130_fd_sc_hd__fill_1
XFILLER_53_15 VPWR VGND VPWR VGND sky130_ef_sc_hd__decap_12
XFILLER_186_209 VPWR VGND VPWR VGND sky130_ef_sc_hd__decap_12
XFILLER_169_15 VPWR VGND VPWR VGND sky130_ef_sc_hd__decap_12
XFILLER_195_721 VGND VGND VPWR VPWR sky130_fd_sc_hd__decap_6
XFILLER_179_261 VPWR VGND VPWR VGND sky130_ef_sc_hd__decap_12
XFILLER_165_1493 VPWR VGND VPWR VGND sky130_ef_sc_hd__decap_12
XFILLER_39_1496 VGND VGND VPWR VPWR sky130_fd_sc_hd__fill_1
XFILLER_195_765 VPWR VGND VPWR VGND sky130_ef_sc_hd__decap_12
XFILLER_168_979 VGND VGND VPWR VPWR sky130_fd_sc_hd__fill_1
XFILLER_139_125 VGND VGND VPWR VPWR sky130_fd_sc_hd__fill_2
XFILLER_196_1409 VPWR VGND VPWR VGND sky130_ef_sc_hd__decap_12
XFILLER_194_253 VPWR VGND VPWR VGND sky130_ef_sc_hd__decap_12
XFILLER_202_1365 VGND VGND VPWR VPWR sky130_fd_sc_hd__decap_6
XFILLER_159_1220 VPWR VGND VPWR VGND sky130_ef_sc_hd__decap_12
XTAP_TAPCELL_ROW_61_2_3372 VGND VPWR sky130_fd_sc_hd__tapvpwrvgnd_1
XPHY_EDGE_ROW_205_Right_50 VGND VGND VPWR VPWR sky130_fd_sc_hd__decap_3
XFILLER_185_69 VPWR VGND VPWR VGND sky130_ef_sc_hd__decap_12
XFILLER_118_41 VPWR VGND VPWR VGND sky130_ef_sc_hd__decap_12
XTAP_TAPCELL_ROW_79_1_1176 VGND VPWR sky130_fd_sc_hd__tapvpwrvgnd_1
XFILLER_5_149 VPWR VGND VPWR VGND sky130_ef_sc_hd__decap_12
XPHY_EDGE_ROW_27_1_Left_246 VGND VGND VPWR VPWR sky130_fd_sc_hd__decap_3
XFILLER_163_673 VPWR VGND VPWR VGND sky130_ef_sc_hd__decap_12
XFILLER_159_1286 VPWR VGND VPWR VGND sky130_ef_sc_hd__decap_12
XFILLER_118_85 VPWR VGND VPWR VGND sky130_ef_sc_hd__decap_12
XFILLER_46_1412 VGND VGND VPWR VPWR sky130_fd_sc_hd__fill_1
XFILLER_172_1453 VPWR VGND VPWR VGND sky130_ef_sc_hd__decap_12
XFILLER_172_1497 VPWR VGND VPWR VGND sky130_ef_sc_hd__decap_12
XPHY_EDGE_ROW_141_1_Left_360 VGND VGND VPWR VPWR sky130_fd_sc_hd__decap_3
XFILLER_94_77 VGND VGND VPWR VPWR sky130_fd_sc_hd__decap_6
XFILLER_79_1232 VPWR VGND VPWR VGND sky130_ef_sc_hd__decap_12
XFILLER_206_825 VPWR VGND VPWR VGND sky130_ef_sc_hd__decap_12
X_604_ clknet_3_4_0_clk _038_ VGND VGND VPWR VPWR net60 sky130_fd_sc_hd__dfxtp_1
XFILLER_206_869 VPWR VGND VPWR VGND sky130_ef_sc_hd__decap_12
XFILLER_205_335 VGND VGND VPWR VPWR sky130_fd_sc_hd__fill_1
XFILLER_150_83 VGND VGND VPWR VPWR sky130_fd_sc_hd__fill_1
XFILLER_79_1298 VPWR VGND VPWR VGND sky130_ef_sc_hd__decap_12
X_535_ net48 _180_ net127 net136 _241_ VGND VGND VPWR VPWR _051_ sky130_fd_sc_hd__o311a_1
XFILLER_57_1552 VGND VGND VPWR VPWR sky130_fd_sc_hd__fill_1
XFILLER_198_581 VGND VGND VPWR VPWR sky130_fd_sc_hd__decap_6
XFILLER_183_1593 VPWR VGND VPWR VGND sky130_ef_sc_hd__decap_12
X_466_ net145 net110 VGND VGND VPWR VPWR _198_ sky130_fd_sc_hd__xor2_2
XFILLER_207_1287 VGND VGND VPWR VPWR sky130_fd_sc_hd__fill_1
XFILLER_201_541 VPWR VGND VPWR VGND sky130_ef_sc_hd__decap_12
XFILLER_174_905 VPWR VGND VPWR VGND sky130_ef_sc_hd__decap_12
X_397_ b_addr\[3\] _104_ VGND VGND VPWR VPWR _134_ sky130_fd_sc_hd__xnor2_1
XFILLER_43_81 VPWR VGND VPWR VGND sky130_ef_sc_hd__decap_12
XFILLER_201_585 VPWR VGND VPWR VGND sky130_ef_sc_hd__decap_12
XFILLER_199_1033 VPWR VGND VPWR VGND sky130_ef_sc_hd__decap_12
XFILLER_159_81 VPWR VGND VPWR VGND sky130_ef_sc_hd__decap_12
XFILLER_199_1077 VPWR VGND VPWR VGND sky130_ef_sc_hd__decap_12
XFILLER_174_949 VPWR VGND VPWR VGND sky130_ef_sc_hd__decap_12
XFILLER_16_1282 VPWR VGND VPWR VGND sky130_ef_sc_hd__decap_12
XFILLER_160_109 VPWR VGND VPWR VGND sky130_ef_sc_hd__decap_12
XTAP_TAPCELL_ROW_137_2_3870 VGND VPWR sky130_fd_sc_hd__tapvpwrvgnd_1
XFILLER_103_1274 VPWR VGND VPWR VGND sky130_ef_sc_hd__decap_12
XFILLER_182_993 VPWR VGND VPWR VGND sky130_ef_sc_hd__decap_12
XFILLER_138_1326 VPWR VGND VPWR VGND sky130_ef_sc_hd__decap_12
XFILLER_86_1258 VPWR VGND VPWR VGND sky130_ef_sc_hd__decap_12
XFILLER_5_661 VGND VGND VPWR VPWR sky130_fd_sc_hd__fill_1
XFILLER_5_683 VGND VGND VPWR VPWR sky130_fd_sc_hd__fill_1
XFILLER_214_1203 VGND VGND VPWR VPWR sky130_fd_sc_hd__fill_1
XFILLER_190_1553 VPWR VGND VPWR VGND sky130_ef_sc_hd__decap_12
XFILLER_116_1602 VGND VGND VPWR VPWR sky130_fd_sc_hd__decap_3
XFILLER_4_53 VPWR VGND VPWR VGND sky130_ef_sc_hd__decap_12
XFILLER_190_1597 VGND VGND VPWR VPWR sky130_fd_sc_hd__decap_8
XFILLER_4_97 VGND VGND VPWR VPWR sky130_fd_sc_hd__decap_6
XTAP_TAPCELL_ROW_130_2_3824 VGND VPWR sky130_fd_sc_hd__tapvpwrvgnd_1
XPHY_EDGE_ROW_73_1_Left_292 VGND VGND VPWR VPWR sky130_fd_sc_hd__decap_3
XFILLER_23_1220 VPWR VGND VPWR VGND sky130_ef_sc_hd__decap_12
XFILLER_209_641 VPWR VGND VPWR VGND sky130_ef_sc_hd__decap_12
XTAP_TAPCELL_ROW_129_2_3818 VGND VPWR sky130_fd_sc_hd__tapvpwrvgnd_1
XFILLER_114_1370 VPWR VGND VPWR VGND sky130_ef_sc_hd__decap_12
XFILLER_97_1310 VPWR VGND VPWR VGND sky130_ef_sc_hd__decap_12
XFILLER_3_1325 VPWR VGND VPWR VGND sky130_ef_sc_hd__decap_12
XFILLER_209_685 VPWR VGND VPWR VGND sky130_ef_sc_hd__decap_12
XFILLER_149_1422 VPWR VGND VPWR VGND sky130_ef_sc_hd__decap_12
XFILLER_97_1354 VPWR VGND VPWR VGND sky130_ef_sc_hd__decap_12
XTAP_TAPCELL_ROW_97_2_3607 VGND VPWR sky130_fd_sc_hd__tapvpwrvgnd_1
XFILLER_3_1369 VPWR VGND VPWR VGND sky130_ef_sc_hd__decap_12
XFILLER_23_1286 VPWR VGND VPWR VGND sky130_ef_sc_hd__decap_12
XFILLER_208_195 VGND VGND VPWR VPWR sky130_fd_sc_hd__fill_1
XFILLER_149_1466 VPWR VGND VPWR VGND sky130_ef_sc_hd__decap_12
XFILLER_97_1398 VPWR VGND VPWR VGND sky130_ef_sc_hd__decap_12
XANTENNA__609__CLK clknet_3_7_0_clk VGND VGND VPWR VPWR sky130_fd_sc_hd__diode_2
XFILLER_58_1338 VPWR VGND VPWR VGND sky130_ef_sc_hd__decap_12
XFILLER_211_305 VPWR VGND VPWR VGND sky130_ef_sc_hd__decap_12
XFILLER_208_1029 VGND VGND VPWR VPWR sky130_fd_sc_hd__decap_6
XFILLER_168_209 VPWR VGND VPWR VGND sky130_ef_sc_hd__decap_12
XFILLER_211_349 VPWR VGND VPWR VGND sky130_ef_sc_hd__decap_12
XFILLER_210_53 VPWR VGND VPWR VGND sky130_ef_sc_hd__decap_12
XFILLER_177_721 VGND VGND VPWR VPWR sky130_fd_sc_hd__decap_6
XFILLER_210_97 VPWR VGND VPWR VGND sky130_ef_sc_hd__decap_12
XFILLER_177_765 VPWR VGND VPWR VGND sky130_ef_sc_hd__decap_12
XFILLER_192_713 VPWR VGND VPWR VGND sky130_ef_sc_hd__decap_12
XFILLER_176_253 VPWR VGND VPWR VGND sky130_ef_sc_hd__decap_12
XANTENNA_fanout137_A net138 VGND VGND VPWR VPWR sky130_fd_sc_hd__diode_2
XTAP_TAPCELL_ROW_46_2_3274 VGND VPWR sky130_fd_sc_hd__tapvpwrvgnd_1
XFILLER_192_757 VPWR VGND VPWR VGND sky130_ef_sc_hd__decap_12
XFILLER_191_223 VGND VGND VPWR VPWR sky130_fd_sc_hd__fill_1
XFILLER_178_1117 VPWR VGND VPWR VGND sky130_ef_sc_hd__decap_12
XFILLER_121_1330 VPWR VGND VPWR VGND sky130_ef_sc_hd__decap_12
XFILLER_34_1382 VPWR VGND VPWR VGND sky130_ef_sc_hd__decap_12
XFILLER_69_1434 VGND VGND VPWR VPWR sky130_fd_sc_hd__decap_6
XFILLER_30_1246 VPWR VGND VPWR VGND sky130_ef_sc_hd__decap_12
XFILLER_156_1426 VPWR VGND VPWR VGND sky130_ef_sc_hd__decap_12
XFILLER_155_39 VPWR VGND VPWR VGND sky130_ef_sc_hd__decap_12
XPHY_EDGE_ROW_98_1_Right_684 VGND VGND VPWR VPWR sky130_fd_sc_hd__decap_3
XFILLER_69_1478 VPWR VGND VPWR VGND sky130_ef_sc_hd__decap_12
XTAP_TAPCELL_ROW_26_2_3150 VGND VPWR sky130_fd_sc_hd__tapvpwrvgnd_1
XFILLER_48_15 VPWR VGND VPWR VGND sky130_ef_sc_hd__decap_12
XFILLER_219_405 VPWR VGND VPWR VGND sky130_ef_sc_hd__decap_12
XFILLER_171_27 VPWR VGND VPWR VGND sky130_ef_sc_hd__decap_12
XFILLER_8_1258 VPWR VGND VPWR VGND sky130_ef_sc_hd__decap_12
XFILLER_219_449 VPWR VGND VPWR VGND sky130_ef_sc_hd__decap_12
XFILLER_189_1213 VPWR VGND VPWR VGND sky130_ef_sc_hd__decap_12
XANTENNA__491__A1 net149 VGND VGND VPWR VPWR sky130_fd_sc_hd__diode_2
XANTENNA__397__A b_addr\[3\] VGND VGND VPWR VPWR sky130_fd_sc_hd__diode_2
XFILLER_189_1257 VPWR VGND VPWR VGND sky130_ef_sc_hd__decap_12
XFILLER_132_1470 VPWR VGND VPWR VGND sky130_ef_sc_hd__decap_12
XFILLER_41_1342 VPWR VGND VPWR VGND sky130_ef_sc_hd__decap_12
XFILLER_167_1511 VGND VGND VPWR VPWR sky130_fd_sc_hd__fill_1
XFILLER_104_65 VPWR VGND VPWR VGND sky130_ef_sc_hd__decap_12
XFILLER_41_1386 VPWR VGND VPWR VGND sky130_ef_sc_hd__decap_12
XFILLER_214_121 VPWR VGND VPWR VGND sky130_ef_sc_hd__decap_12
XTAP_TAPCELL_ROW_132_1_1281 VGND VPWR sky130_fd_sc_hd__tapvpwrvgnd_1
XFILLER_128_1506 VPWR VGND VPWR VGND sky130_ef_sc_hd__decap_12
XFILLER_76_1438 VPWR VGND VPWR VGND sky130_ef_sc_hd__decap_12
XFILLER_214_165 VPWR VGND VPWR VGND sky130_ef_sc_hd__decap_12
XFILLER_203_839 VGND VGND VPWR VPWR sky130_fd_sc_hd__fill_1
X_320_ net31 net143 net133 VGND VGND VPWR VPWR s_wdata\[27\] sky130_fd_sc_hd__a21o_1
XFILLER_208_1541 VPWR VGND VPWR VGND sky130_ef_sc_hd__decap_12
XFILLER_187_529 VPWR VGND VPWR VGND sky130_ef_sc_hd__decap_12
XFILLER_147_3 VPWR VGND VPWR VGND sky130_ef_sc_hd__decap_12
XFILLER_120_53 VPWR VGND VPWR VGND sky130_ef_sc_hd__decap_12
XFILLER_204_1427 VGND VGND VPWR VPWR sky130_fd_sc_hd__fill_1
XFILLER_120_97 VPWR VGND VPWR VGND sky130_ef_sc_hd__decap_12
XFILLER_195_573 VPWR VGND VPWR VGND sky130_ef_sc_hd__decap_12
XANTENNA__633__Q u_ctrl.cmp_valid VGND VGND VPWR VPWR sky130_fd_sc_hd__diode_2
XFILLER_196_1217 VPWR VGND VPWR VGND sky130_ef_sc_hd__decap_12
XFILLER_129_51 VGND VGND VPWR VPWR sky130_fd_sc_hd__decap_4
XFILLER_104_1550 VPWR VGND VPWR VGND sky130_ef_sc_hd__decap_12
XFILLER_7_937 VPWR VGND VPWR VGND sky130_ef_sc_hd__decap_12
XFILLER_13_1422 VPWR VGND VPWR VGND sky130_ef_sc_hd__decap_12
XFILLER_52_1482 VPWR VGND VPWR VGND sky130_ef_sc_hd__decap_12
XFILLER_202_1173 VPWR VGND VPWR VGND sky130_ef_sc_hd__decap_12
XFILLER_182_245 VGND VGND VPWR VPWR sky130_fd_sc_hd__decap_6
XFILLER_139_1602 VGND VGND VPWR VPWR sky130_fd_sc_hd__decap_3
XFILLER_104_1594 VGND VGND VPWR VPWR sky130_fd_sc_hd__decap_8
XFILLER_100_1414 VPWR VGND VPWR VGND sky130_ef_sc_hd__decap_12
XFILLER_87_1534 VPWR VGND VPWR VGND sky130_ef_sc_hd__decap_12
XFILLER_13_1466 VPWR VGND VPWR VGND sky130_ef_sc_hd__decap_12
XFILLER_182_289 VPWR VGND VPWR VGND sky130_ef_sc_hd__decap_12
XFILLER_164_993 VPWR VGND VPWR VGND sky130_ef_sc_hd__decap_12
XFILLER_142_109 VPWR VGND VPWR VGND sky130_ef_sc_hd__decap_12
XFILLER_89_55 VGND VGND VPWR VPWR sky130_fd_sc_hd__fill_1
XFILLER_48_1518 VGND VGND VPWR VPWR sky130_fd_sc_hd__decap_6
XFILLER_87_1578 VPWR VGND VPWR VGND sky130_ef_sc_hd__decap_12
XFILLER_46_1220 VPWR VGND VPWR VGND sky130_ef_sc_hd__decap_12
XFILLER_215_1567 VGND VGND VPWR VPWR sky130_fd_sc_hd__fill_1
XFILLER_172_1261 VPWR VGND VPWR VGND sky130_ef_sc_hd__decap_12
XFILLER_133_1256 VPWR VGND VPWR VGND sky130_ef_sc_hd__decap_12
XTAP_TAPCELL_ROW_115_2_3726 VGND VPWR sky130_fd_sc_hd__tapvpwrvgnd_1
XTAP_TAPCELL_ROW_6_970 VGND VPWR sky130_fd_sc_hd__tapvpwrvgnd_1
XFILLER_111_1510 VPWR VGND VPWR VGND sky130_ef_sc_hd__decap_12
XTAP_TAPCELL_ROW_83_2_3515 VGND VPWR sky130_fd_sc_hd__tapvpwrvgnd_1
XFILLER_24_1562 VPWR VGND VPWR VGND sky130_ef_sc_hd__decap_12
XFILLER_111_1554 VPWR VGND VPWR VGND sky130_ef_sc_hd__decap_12
XFILLER_0_1509 VGND VGND VPWR VPWR sky130_fd_sc_hd__decap_3
XFILLER_20_1426 VPWR VGND VPWR VGND sky130_ef_sc_hd__decap_12
XFILLER_161_93 VPWR VGND VPWR VGND sky130_ef_sc_hd__decap_12
XFILLER_94_1538 VPWR VGND VPWR VGND sky130_ef_sc_hd__decap_12
XFILLER_206_699 VGND VGND VPWR VPWR sky130_fd_sc_hd__fill_1
X_518_ net65 net123 VGND VGND VPWR VPWR _233_ sky130_fd_sc_hd__or2_1
XFILLER_18_1300 VGND VGND VPWR VPWR sky130_fd_sc_hd__fill_1
XFILLER_202_861 VGND VGND VPWR VPWR sky130_fd_sc_hd__decap_6
X_449_ net146 net120 VGND VGND VPWR VPWR _181_ sky130_fd_sc_hd__xor2_1
XFILLER_174_713 VPWR VGND VPWR VGND sky130_ef_sc_hd__decap_12
XFILLER_53_1268 VGND VGND VPWR VPWR sky130_fd_sc_hd__decap_4
XFILLER_201_393 VPWR VGND VPWR VGND sky130_ef_sc_hd__decap_12
XFILLER_179_1437 VPWR VGND VPWR VGND sky130_ef_sc_hd__decap_12
XFILLER_174_757 VPWR VGND VPWR VGND sky130_ef_sc_hd__decap_12
XFILLER_173_223 VGND VGND VPWR VPWR sky130_fd_sc_hd__fill_1
XTAP_TAPCELL_ROW_157_1_1332 VGND VPWR sky130_fd_sc_hd__tapvpwrvgnd_1
XFILLER_70_1582 VPWR VGND VPWR VGND sky130_ef_sc_hd__decap_12
XFILLER_31_1522 VPWR VGND VPWR VGND sky130_ef_sc_hd__decap_12
XFILLER_31_1566 VPWR VGND VPWR VGND sky130_ef_sc_hd__decap_12
XFILLER_62_3 VPWR VGND VPWR VGND sky130_ef_sc_hd__decap_12
XFILLER_6_981 VPWR VGND VPWR VGND sky130_ef_sc_hd__decap_12
XFILLER_216_1309 VGND VGND VPWR VPWR sky130_fd_sc_hd__decap_6
XFILLER_29_1440 VGND VGND VPWR VPWR sky130_fd_sc_hd__fill_1
XTAP_TAPCELL_ROW_4_907 VGND VPWR sky130_fd_sc_hd__tapvpwrvgnd_1
XFILLER_9_1534 VPWR VGND VPWR VGND sky130_ef_sc_hd__decap_12
XTAP_TAPCELL_ROW_4_918 VGND VPWR sky130_fd_sc_hd__tapvpwrvgnd_1
XFILLER_9_1578 VPWR VGND VPWR VGND sky130_ef_sc_hd__decap_12
XFILLER_217_909 VPWR VGND VPWR VGND sky130_ef_sc_hd__decap_12
XFILLER_151_1378 VGND VGND VPWR VPWR sky130_fd_sc_hd__decap_6
XFILLER_18_29 VPWR VGND VPWR VGND sky130_ef_sc_hd__decap_12
XFILLER_216_419 VGND VGND VPWR VPWR sky130_fd_sc_hd__fill_1
XFILLER_3_1133 VPWR VGND VPWR VGND sky130_ef_sc_hd__decap_12
XFILLER_3_1177 VPWR VGND VPWR VGND sky130_ef_sc_hd__decap_12
XFILLER_149_1274 VPWR VGND VPWR VGND sky130_ef_sc_hd__decap_12
XFILLER_212_625 VPWR VGND VPWR VGND sky130_ef_sc_hd__decap_12
XFILLER_211_113 VPWR VGND VPWR VGND sky130_ef_sc_hd__decap_12
XFILLER_180_1029 VGND VGND VPWR VPWR sky130_fd_sc_hd__decap_6
XFILLER_169_529 VPWR VGND VPWR VGND sky130_ef_sc_hd__decap_12
XANTENNA__581__CLK clknet_3_3_0_clk VGND VGND VPWR VPWR sky130_fd_sc_hd__diode_2
XFILLER_212_669 VPWR VGND VPWR VGND sky130_ef_sc_hd__decap_12
XPHY_EDGE_ROW_119_2_Left_551 VGND VGND VPWR VPWR sky130_fd_sc_hd__decap_3
XPHY_EDGE_ROW_199_Left_418 VGND VGND VPWR VPWR sky130_fd_sc_hd__decap_3
XFILLER_177_573 VPWR VGND VPWR VGND sky130_ef_sc_hd__decap_12
Xclkload5 clknet_3_6_0_clk VGND VGND VPWR VPWR clkload5/Y sky130_fd_sc_hd__clkinvlp_4
XTAP_TAPCELL_ROW_108_2_3680 VGND VPWR sky130_fd_sc_hd__tapvpwrvgnd_1
XFILLER_203_1493 VPWR VGND VPWR VGND sky130_ef_sc_hd__decap_12
XFILLER_197_1537 VPWR VGND VPWR VGND sky130_ef_sc_hd__decap_12
XFILLER_166_27 VGND VGND VPWR VPWR sky130_fd_sc_hd__fill_1
XFILLER_164_245 VGND VGND VPWR VPWR sky130_fd_sc_hd__decap_6
XFILLER_69_1220 VPWR VGND VPWR VGND sky130_ef_sc_hd__decap_12
XFILLER_192_587 VGND VGND VPWR VPWR sky130_fd_sc_hd__fill_1
XFILLER_180_749 VGND VGND VPWR VPWR sky130_fd_sc_hd__decap_6
XFILLER_164_289 VPWR VGND VPWR VGND sky130_ef_sc_hd__decap_12
XFILLER_124_109 VPWR VGND VPWR VGND sky130_ef_sc_hd__decap_12
XFILLER_3_417 VGND VGND VPWR VPWR sky130_fd_sc_hd__decap_4
XTAP_TAPCELL_ROW_13_1_1043 VGND VPWR sky130_fd_sc_hd__tapvpwrvgnd_1
XPHY_EDGE_ROW_99_1_Right_685 VGND VGND VPWR VPWR sky130_fd_sc_hd__decap_3
XFILLER_69_1286 VPWR VGND VPWR VGND sky130_ef_sc_hd__decap_12
XFILLER_182_15 VPWR VGND VPWR VGND sky130_ef_sc_hd__decap_12
XFILLER_191_1169 VGND VGND VPWR VPWR sky130_fd_sc_hd__decap_6
XFILLER_173_1581 VPWR VGND VPWR VGND sky130_ef_sc_hd__decap_12
XTAP_TAPCELL_ROW_101_2_3634 VGND VPWR sky130_fd_sc_hd__tapvpwrvgnd_1
XFILLER_59_69 VPWR VGND VPWR VGND sky130_ef_sc_hd__decap_12
XTAP_TAPCELL_ROW_68_2_3417 VGND VPWR sky130_fd_sc_hd__tapvpwrvgnd_1
XFILLER_189_1021 VPWR VGND VPWR VGND sky130_ef_sc_hd__decap_12
XTAP_TAPCELL_ROW_101_1_1219 VGND VPWR sky130_fd_sc_hd__tapvpwrvgnd_1
XFILLER_210_1453 VPWR VGND VPWR VGND sky130_ef_sc_hd__decap_12
XFILLER_189_1065 VPWR VGND VPWR VGND sky130_ef_sc_hd__decap_12
XFILLER_75_57 VPWR VGND VPWR VGND sky130_ef_sc_hd__decap_12
XFILLER_210_1497 VPWR VGND VPWR VGND sky130_ef_sc_hd__decap_12
XFILLER_215_441 VGND VGND VPWR VPWR sky130_fd_sc_hd__decap_6
XFILLER_188_805 VGND VGND VPWR VPWR sky130_fd_sc_hd__decap_6
XFILLER_163_1205 VPWR VGND VPWR VGND sky130_ef_sc_hd__decap_12
XFILLER_128_1314 VPWR VGND VPWR VGND sky130_ef_sc_hd__decap_12
XFILLER_76_1246 VPWR VGND VPWR VGND sky130_ef_sc_hd__decap_12
XFILLER_215_485 VPWR VGND VPWR VGND sky130_ef_sc_hd__decap_12
XTAP_TAPCELL_ROW_202_2497 VGND VPWR sky130_fd_sc_hd__tapvpwrvgnd_1
XTAP_TAPCELL_ROW_202_2486 VGND VPWR sky130_fd_sc_hd__tapvpwrvgnd_1
XTAP_TAPCELL_ROW_198_2390 VGND VPWR sky130_fd_sc_hd__tapvpwrvgnd_1
XFILLER_188_849 VPWR VGND VPWR VGND sky130_ef_sc_hd__decap_12
XFILLER_128_1358 VPWR VGND VPWR VGND sky130_ef_sc_hd__decap_12
XFILLER_208_1371 VGND VGND VPWR VPWR sky130_fd_sc_hd__fill_1
XFILLER_187_337 VPWR VGND VPWR VGND sky130_ef_sc_hd__decap_12
XFILLER_180_1541 VPWR VGND VPWR VGND sky130_ef_sc_hd__decap_12
X_303_ net13 net142 net132 VGND VGND VPWR VPWR s_wdata\[10\] sky130_fd_sc_hd__a21o_1
XTAP_TAPCELL_ROW_194_2276 VGND VPWR sky130_fd_sc_hd__tapvpwrvgnd_1
XTAP_TAPCELL_ROW_194_2265 VGND VPWR sky130_fd_sc_hd__tapvpwrvgnd_1
XTAP_TAPCELL_ROW_219_2994 VGND VPWR sky130_fd_sc_hd__tapvpwrvgnd_1
XTAP_TAPCELL_ROW_219_2983 VGND VPWR sky130_fd_sc_hd__tapvpwrvgnd_1
XTAP_TAPCELL_ROW_219_2972 VGND VPWR sky130_fd_sc_hd__tapvpwrvgnd_1
XFILLER_196_893 VPWR VGND VPWR VGND sky130_ef_sc_hd__decap_12
XFILLER_7_701 VPWR VGND VPWR VGND sky130_ef_sc_hd__decap_12
XTAP_TAPCELL_ROW_215_2869 VGND VPWR sky130_fd_sc_hd__tapvpwrvgnd_1
XTAP_TAPCELL_ROW_215_2858 VGND VPWR sky130_fd_sc_hd__tapvpwrvgnd_1
XPHY_EDGE_ROW_40_2_Left_472 VGND VGND VPWR VPWR sky130_fd_sc_hd__decap_3
XFILLER_171_727 VGND VGND VPWR VPWR sky130_fd_sc_hd__fill_1
XFILLER_139_1410 VPWR VGND VPWR VGND sky130_ef_sc_hd__decap_12
XFILLER_100_1244 VGND VGND VPWR VPWR sky130_fd_sc_hd__fill_1
XFILLER_87_1342 VPWR VGND VPWR VGND sky130_ef_sc_hd__decap_12
XFILLER_6_277 VPWR VGND VPWR VGND sky130_ef_sc_hd__decap_12
XFILLER_13_1274 VPWR VGND VPWR VGND sky130_ef_sc_hd__decap_12
XFILLER_139_1454 VPWR VGND VPWR VGND sky130_ef_sc_hd__decap_12
XFILLER_87_1386 VPWR VGND VPWR VGND sky130_ef_sc_hd__decap_12
XFILLER_48_1326 VPWR VGND VPWR VGND sky130_ef_sc_hd__decap_12
XFILLER_139_1498 VPWR VGND VPWR VGND sky130_ef_sc_hd__decap_12
XFILLER_26_1602 VGND VGND VPWR VPWR sky130_fd_sc_hd__decap_3
XFILLER_172_1091 VGND VGND VPWR VPWR sky130_fd_sc_hd__fill_1
XFILLER_168_1105 VPWR VGND VPWR VGND sky130_ef_sc_hd__decap_12
XTAP_TAPCELL_ROW_160_2_4016 VGND VPWR sky130_fd_sc_hd__tapvpwrvgnd_1
XTAP_TAPCELL_ROW_145_2_3921 VGND VPWR sky130_fd_sc_hd__tapvpwrvgnd_1
XFILLER_4_1453 VPWR VGND VPWR VGND sky130_ef_sc_hd__decap_12
XFILLER_24_1370 VPWR VGND VPWR VGND sky130_ef_sc_hd__decap_12
XFILLER_207_953 VPWR VGND VPWR VGND sky130_ef_sc_hd__decap_12
XFILLER_168_1149 VPWR VGND VPWR VGND sky130_ef_sc_hd__decap_12
XFILLER_94_1302 VPWR VGND VPWR VGND sky130_ef_sc_hd__decap_12
XFILLER_0_1317 VPWR VGND VPWR VGND sky130_ef_sc_hd__decap_12
XFILLER_59_1422 VPWR VGND VPWR VGND sky130_ef_sc_hd__decap_12
XFILLER_209_1113 VGND VGND VPWR VPWR sky130_fd_sc_hd__decap_6
XFILLER_146_1414 VPWR VGND VPWR VGND sky130_ef_sc_hd__decap_12
XFILLER_111_1384 VGND VGND VPWR VPWR sky130_fd_sc_hd__fill_1
XFILLER_98_1482 VPWR VGND VPWR VGND sky130_ef_sc_hd__decap_12
XFILLER_4_1497 VPWR VGND VPWR VGND sky130_ef_sc_hd__decap_12
XFILLER_59_1466 VPWR VGND VPWR VGND sky130_ef_sc_hd__decap_12
XFILLER_209_1157 VPWR VGND VPWR VGND sky130_ef_sc_hd__decap_12
XPHY_EDGE_ROW_104_1_Left_323 VGND VGND VPWR VPWR sky130_fd_sc_hd__decap_3
XFILLER_193_329 VGND VGND VPWR VPWR sky130_fd_sc_hd__decap_6
XFILLER_179_1201 VPWR VGND VPWR VGND sky130_ef_sc_hd__decap_12
XTAP_TAPCELL_ROW_177_1795 VGND VPWR sky130_fd_sc_hd__tapvpwrvgnd_1
XTAP_TAPCELL_ROW_177_1784 VGND VPWR sky130_fd_sc_hd__tapvpwrvgnd_1
XTAP_TAPCELL_ROW_177_1773 VGND VPWR sky130_fd_sc_hd__tapvpwrvgnd_1
XFILLER_179_1245 VPWR VGND VPWR VGND sky130_ef_sc_hd__decap_12
XTAP_TAPCELL_ROW_173_1659 VGND VPWR sky130_fd_sc_hd__tapvpwrvgnd_1
XFILLER_31_1330 VPWR VGND VPWR VGND sky130_ef_sc_hd__decap_12
XFILLER_174_587 VGND VGND VPWR VPWR sky130_fd_sc_hd__fill_1
XFILLER_157_1510 VPWR VGND VPWR VGND sky130_ef_sc_hd__decap_12
XFILLER_106_109 VPWR VGND VPWR VGND sky130_ef_sc_hd__decap_12
XTAP_TAPCELL_ROW_93_1_1204 VGND VPWR sky130_fd_sc_hd__tapvpwrvgnd_1
XFILLER_179_1289 VPWR VGND VPWR VGND sky130_ef_sc_hd__decap_12
XFILLER_66_1426 VPWR VGND VPWR VGND sky130_ef_sc_hd__decap_12
XFILLER_216_1117 VPWR VGND VPWR VGND sky130_ef_sc_hd__decap_12
XFILLER_157_1554 VPWR VGND VPWR VGND sky130_ef_sc_hd__decap_12
XFILLER_0_409 VGND VGND VPWR VPWR sky130_fd_sc_hd__fill_2
XFILLER_216_41 VPWR VGND VPWR VGND sky130_ef_sc_hd__decap_12
XFILLER_170_793 VPWR VGND VPWR VGND sky130_ef_sc_hd__decap_12
XFILLER_118_1538 VPWR VGND VPWR VGND sky130_ef_sc_hd__decap_12
XFILLER_216_85 VPWR VGND VPWR VGND sky130_ef_sc_hd__decap_12
XFILLER_9_1342 VPWR VGND VPWR VGND sky130_ef_sc_hd__decap_12
XFILLER_152_29 VPWR VGND VPWR VGND sky130_ef_sc_hd__decap_12
XFILLER_9_1386 VPWR VGND VPWR VGND sky130_ef_sc_hd__decap_12
XFILLER_186_1205 VPWR VGND VPWR VGND sky130_ef_sc_hd__decap_12
XFILLER_28_126 VGND VGND VPWR VPWR sky130_fd_sc_hd__fill_1
XTAP_TAPCELL_ROW_34_2_3201 VGND VPWR sky130_fd_sc_hd__tapvpwrvgnd_1
XFILLER_42_1470 VPWR VGND VPWR VGND sky130_ef_sc_hd__decap_12
XFILLER_99_1268 VGND VGND VPWR VPWR sky130_fd_sc_hd__decap_4
XFILLER_77_1522 VPWR VGND VPWR VGND sky130_ef_sc_hd__decap_12
XFILLER_45_27 VPWR VGND VPWR VGND sky130_ef_sc_hd__decap_12
XPHY_EDGE_ROW_36_1_Left_255 VGND VGND VPWR VPWR sky130_fd_sc_hd__decap_3
XFILLER_38_1506 VPWR VGND VPWR VGND sky130_ef_sc_hd__decap_12
XFILLER_213_945 VGND VGND VPWR VPWR sky130_fd_sc_hd__decap_6
XFILLER_77_1566 VPWR VGND VPWR VGND sky130_ef_sc_hd__decap_12
XFILLER_213_989 VPWR VGND VPWR VGND sky130_ef_sc_hd__decap_12
XFILLER_212_433 VPWR VGND VPWR VGND sky130_ef_sc_hd__decap_12
XFILLER_205_1511 VGND VGND VPWR VPWR sky130_fd_sc_hd__fill_1
XFILLER_169_337 VPWR VGND VPWR VGND sky130_ef_sc_hd__decap_12
XFILLER_101_55 VGND VGND VPWR VPWR sky130_fd_sc_hd__fill_1
XFILLER_61_15 VPWR VGND VPWR VGND sky130_ef_sc_hd__decap_12
XFILLER_212_477 VPWR VGND VPWR VGND sky130_ef_sc_hd__decap_12
XFILLER_184_307 VGND VGND VPWR VPWR sky130_fd_sc_hd__fill_1
XFILLER_177_15 VPWR VGND VPWR VGND sky130_ef_sc_hd__decap_12
XFILLER_197_1301 VPWR VGND VPWR VGND sky130_ef_sc_hd__decap_12
XFILLER_196_189 VGND VGND VPWR VPWR sky130_fd_sc_hd__decap_6
XFILLER_178_893 VPWR VGND VPWR VGND sky130_ef_sc_hd__decap_12
XFILLER_162_1282 VPWR VGND VPWR VGND sky130_ef_sc_hd__decap_12
XFILLER_123_1244 VPWR VGND VPWR VGND sky130_ef_sc_hd__decap_12
XFILLER_193_841 VPWR VGND VPWR VGND sky130_ef_sc_hd__decap_12
XFILLER_14_1550 VPWR VGND VPWR VGND sky130_ef_sc_hd__decap_12
XFILLER_197_1345 VPWR VGND VPWR VGND sky130_ef_sc_hd__decap_12
XFILLER_180_513 VPWR VGND VPWR VGND sky130_ef_sc_hd__decap_12
XFILLER_140_1580 VGND VGND VPWR VPWR sky130_fd_sc_hd__fill_1
XFILLER_10_1414 VPWR VGND VPWR VGND sky130_ef_sc_hd__decap_12
XFILLER_14_1594 VGND VGND VPWR VPWR sky130_fd_sc_hd__decap_8
XFILLER_49_1602 VGND VGND VPWR VPWR sky130_fd_sc_hd__decap_3
XTAP_TAPCELL_ROW_210_2733 VGND VPWR sky130_fd_sc_hd__tapvpwrvgnd_1
XTAP_TAPCELL_ROW_210_2722 VGND VPWR sky130_fd_sc_hd__tapvpwrvgnd_1
XTAP_TAPCELL_ROW_210_2711 VGND VPWR sky130_fd_sc_hd__tapvpwrvgnd_1
XFILLER_180_557 VPWR VGND VPWR VGND sky130_ef_sc_hd__decap_12
XFILLER_3_225 VGND VGND VPWR VPWR sky130_fd_sc_hd__fill_1
XFILLER_193_69 VPWR VGND VPWR VGND sky130_ef_sc_hd__decap_12
XFILLER_84_1526 VPWR VGND VPWR VGND sky130_ef_sc_hd__decap_12
XFILLER_126_41 VPWR VGND VPWR VGND sky130_ef_sc_hd__decap_12
XFILLER_0_921 VGND VGND VPWR VPWR sky130_fd_sc_hd__decap_3
XFILLER_10_85 VGND VGND VPWR VPWR sky130_fd_sc_hd__fill_2
XTAP_TAPCELL_ROW_187_2080 VGND VPWR sky130_fd_sc_hd__tapvpwrvgnd_1
XFILLER_126_85 VPWR VGND VPWR VGND sky130_ef_sc_hd__decap_12
XFILLER_43_1223 VPWR VGND VPWR VGND sky130_ef_sc_hd__decap_12
XFILLER_82_1294 VGND VGND VPWR VPWR sky130_fd_sc_hd__decap_6
XTAP_TAPCELL_ROW_7_1009 VGND VPWR sky130_fd_sc_hd__tapvpwrvgnd_1
XTAP_TAPCELL_ROW_208_2673 VGND VPWR sky130_fd_sc_hd__tapvpwrvgnd_1
XTAP_TAPCELL_ROW_208_2662 VGND VPWR sky130_fd_sc_hd__tapvpwrvgnd_1
XFILLER_207_205 VPWR VGND VPWR VGND sky130_ef_sc_hd__decap_12
XFILLER_169_1425 VPWR VGND VPWR VGND sky130_ef_sc_hd__decap_12
XFILLER_21_1510 VPWR VGND VPWR VGND sky130_ef_sc_hd__decap_12
XFILLER_210_1261 VPWR VGND VPWR VGND sky130_ef_sc_hd__decap_12
XFILLER_207_249 VPWR VGND VPWR VGND sky130_ef_sc_hd__decap_12
XTAP_TAPCELL_ROW_204_2548 VGND VPWR sky130_fd_sc_hd__tapvpwrvgnd_1
XTAP_TAPCELL_ROW_98_2_3612 VGND VPWR sky130_fd_sc_hd__tapvpwrvgnd_1
XFILLER_21_1554 VPWR VGND VPWR VGND sky130_ef_sc_hd__decap_12
XTAP_TAPCELL_ROW_204_2559 VGND VPWR sky130_fd_sc_hd__tapvpwrvgnd_1
XFILLER_169_1469 VPWR VGND VPWR VGND sky130_ef_sc_hd__decap_12
XFILLER_204_923 VGND VGND VPWR VPWR sky130_fd_sc_hd__fill_1
XTAP_TAPCELL_ROW_196_2338 VGND VPWR sky130_fd_sc_hd__tapvpwrvgnd_1
XTAP_TAPCELL_ROW_196_2327 VGND VPWR sky130_fd_sc_hd__tapvpwrvgnd_1
XTAP_TAPCELL_ROW_196_2316 VGND VPWR sky130_fd_sc_hd__tapvpwrvgnd_1
XFILLER_188_613 VPWR VGND VPWR VGND sky130_ef_sc_hd__decap_12
XFILLER_215_293 VPWR VGND VPWR VGND sky130_ef_sc_hd__decap_12
XFILLER_188_657 VPWR VGND VPWR VGND sky130_ef_sc_hd__decap_12
XFILLER_163_1035 VGND VGND VPWR VPWR sky130_fd_sc_hd__fill_1
XFILLER_187_167 VGND VGND VPWR VPWR sky130_fd_sc_hd__fill_1
XFILLER_180_1371 VGND VGND VPWR VPWR sky130_fd_sc_hd__fill_1
XFILLER_175_329 VGND VGND VPWR VPWR sky130_fd_sc_hd__decap_6
XFILLER_141_1322 VGND VGND VPWR VPWR sky130_fd_sc_hd__decap_6
XFILLER_141_1366 VPWR VGND VPWR VGND sky130_ef_sc_hd__decap_12
XFILLER_7_531 VGND VGND VPWR VPWR sky130_fd_sc_hd__fill_1
XFILLER_51_81 VGND VGND VPWR VPWR sky130_fd_sc_hd__fill_1
XFILLER_183_373 VPWR VGND VPWR VGND sky130_ef_sc_hd__decap_12
XFILLER_167_81 VPWR VGND VPWR VGND sky130_ef_sc_hd__decap_12
XTAP_TAPCELL_ROW_60_2_3368 VGND VPWR sky130_fd_sc_hd__tapvpwrvgnd_1
XFILLER_176_1429 VPWR VGND VPWR VGND sky130_ef_sc_hd__decap_12
XFILLER_217_1437 VPWR VGND VPWR VGND sky130_ef_sc_hd__decap_12
XFILLER_3_770 VPWR VGND VPWR VGND sky130_ef_sc_hd__decap_12
XFILLER_174_1197 VGND VGND VPWR VPWR sky130_fd_sc_hd__decap_6
XFILLER_170_1017 VPWR VGND VPWR VGND sky130_ef_sc_hd__decap_12
XFILLER_152_1462 VGND VGND VPWR VPWR sky130_fd_sc_hd__decap_6
XFILLER_25_3 VPWR VGND VPWR VGND sky130_ef_sc_hd__decap_12
XTAP_TAPCELL_ROW_181_1906 VGND VPWR sky130_fd_sc_hd__tapvpwrvgnd_1
XTAP_TAPCELL_ROW_166_1474 VGND VPWR sky130_fd_sc_hd__tapvpwrvgnd_1
XTAP_TAPCELL_ROW_166_1463 VGND VPWR sky130_fd_sc_hd__tapvpwrvgnd_1
XTAP_TAPCELL_ROW_19_2_3103 VGND VPWR sky130_fd_sc_hd__tapvpwrvgnd_1
XFILLER_61_1378 VGND VGND VPWR VPWR sky130_fd_sc_hd__decap_6
XFILLER_187_1525 VPWR VGND VPWR VGND sky130_ef_sc_hd__decap_12
XTAP_TAPCELL_ROW_166_1485 VGND VPWR sky130_fd_sc_hd__tapvpwrvgnd_1
XFILLER_4_1261 VPWR VGND VPWR VGND sky130_ef_sc_hd__decap_12
XFILLER_187_1569 VPWR VGND VPWR VGND sky130_ef_sc_hd__decap_12
XFILLER_207_783 VGND VGND VPWR VPWR sky130_fd_sc_hd__fill_1
XFILLER_202_65 VPWR VGND VPWR VGND sky130_ef_sc_hd__decap_12
XFILLER_59_1274 VPWR VGND VPWR VGND sky130_ef_sc_hd__decap_12
XFILLER_181_1113 VGND VGND VPWR VPWR sky130_fd_sc_hd__decap_6
XTAP_TAPCELL_ROW_179_1846 VGND VPWR sky130_fd_sc_hd__tapvpwrvgnd_1
XTAP_TAPCELL_ROW_179_1835 VGND VPWR sky130_fd_sc_hd__tapvpwrvgnd_1
XFILLER_146_1244 VGND VGND VPWR VPWR sky130_fd_sc_hd__fill_1
XTAP_TAPCELL_ROW_37_1_1091 VGND VPWR sky130_fd_sc_hd__tapvpwrvgnd_1
XFILLER_210_937 VPWR VGND VPWR VGND sky130_ef_sc_hd__decap_12
XFILLER_181_1157 VPWR VGND VPWR VGND sky130_ef_sc_hd__decap_12
XFILLER_166_307 VGND VGND VPWR VPWR sky130_fd_sc_hd__fill_1
XFILLER_178_189 VGND VGND VPWR VPWR sky130_fd_sc_hd__decap_6
XFILLER_193_137 VPWR VGND VPWR VGND sky130_ef_sc_hd__decap_12
XFILLER_175_841 VPWR VGND VPWR VGND sky130_ef_sc_hd__decap_12
XFILLER_120_1406 VGND VGND VPWR VPWR sky130_fd_sc_hd__decap_6
XFILLER_200_1441 VPWR VGND VPWR VGND sky130_ef_sc_hd__decap_12
XFILLER_190_811 VGND VGND VPWR VPWR sky130_fd_sc_hd__fill_1
XTAP_TAPCELL_ROW_125_1_1267 VGND VPWR sky130_fd_sc_hd__tapvpwrvgnd_1
XFILLER_200_1485 VPWR VGND VPWR VGND sky130_ef_sc_hd__decap_12
XFILLER_118_1302 VPWR VGND VPWR VGND sky130_ef_sc_hd__decap_12
XTAP_TAPCELL_ROW_30_1_1078 VGND VPWR sky130_fd_sc_hd__tapvpwrvgnd_1
XFILLER_192_1253 VGND VGND VPWR VPWR sky130_fd_sc_hd__decap_6
XFILLER_157_1384 VGND VGND VPWR VPWR sky130_fd_sc_hd__fill_1
XFILLER_1_729 VGND VGND VPWR VPWR sky130_fd_sc_hd__fill_1
XFILLER_192_1297 VPWR VGND VPWR VGND sky130_ef_sc_hd__decap_12
XFILLER_153_1259 VPWR VGND VPWR VGND sky130_ef_sc_hd__decap_12
XTAP_TAPCELL_ROW_116_2_3731 VGND VPWR sky130_fd_sc_hd__tapvpwrvgnd_1
XANTENNA__419__B2 b_addr\[5\] VGND VGND VPWR VPWR sky130_fd_sc_hd__diode_2
XFILLER_217_503 VGND VGND VPWR VPWR sky130_fd_sc_hd__fill_1
XFILLER_170_1595 VGND VGND VPWR VPWR sky130_fd_sc_hd__fill_1
XFILLER_131_1546 VGND VGND VPWR VPWR sky130_fd_sc_hd__decap_6
XFILLER_56_15 VPWR VGND VPWR VGND sky130_ef_sc_hd__decap_12
XFILLER_211_1581 VPWR VGND VPWR VGND sky130_ef_sc_hd__decap_12
XFILLER_205_709 VPWR VGND VPWR VGND sky130_ef_sc_hd__decap_12
XFILLER_186_1035 VGND VGND VPWR VPWR sky130_fd_sc_hd__fill_1
XFILLER_77_1330 VPWR VGND VPWR VGND sky130_ef_sc_hd__decap_12
XFILLER_112_65 VPWR VGND VPWR VGND sky130_ef_sc_hd__decap_12
XTAP_TAPCELL_ROW_0_751 VGND VPWR sky130_fd_sc_hd__tapvpwrvgnd_1
XTAP_TAPCELL_ROW_0_762 VGND VPWR sky130_fd_sc_hd__tapvpwrvgnd_1
XTAP_TAPCELL_ROW_0_773 VGND VPWR sky130_fd_sc_hd__tapvpwrvgnd_1
XFILLER_38_1314 VPWR VGND VPWR VGND sky130_ef_sc_hd__decap_12
XFILLER_213_753 VPWR VGND VPWR VGND sky130_ef_sc_hd__decap_12
XFILLER_129_1442 VPWR VGND VPWR VGND sky130_ef_sc_hd__decap_12
XTAP_TAPCELL_ROW_0_795 VGND VPWR sky130_fd_sc_hd__tapvpwrvgnd_1
XTAP_TAPCELL_ROW_0_784 VGND VPWR sky130_fd_sc_hd__tapvpwrvgnd_1
XFILLER_38_1358 VPWR VGND VPWR VGND sky130_ef_sc_hd__decap_12
XFILLER_213_797 VPWR VGND VPWR VGND sky130_ef_sc_hd__decap_12
XFILLER_169_167 VGND VGND VPWR VPWR sky130_fd_sc_hd__fill_1
XFILLER_125_1328 VGND VGND VPWR VPWR sky130_fd_sc_hd__fill_1
XFILLER_90_1574 VGND VGND VPWR VPWR sky130_fd_sc_hd__decap_6
XFILLER_200_469 VGND VGND VPWR VPWR sky130_fd_sc_hd__decap_6
XFILLER_193_671 VGND VGND VPWR VPWR sky130_fd_sc_hd__fill_1
XFILLER_165_373 VPWR VGND VPWR VGND sky130_ef_sc_hd__decap_12
XFILLER_197_1175 VGND VGND VPWR VPWR sky130_fd_sc_hd__fill_1
XTAP_TAPCELL_ROW_189_2120 VGND VPWR sky130_fd_sc_hd__tapvpwrvgnd_1
XFILLER_181_833 VGND VGND VPWR VPWR sky130_fd_sc_hd__decap_6
XFILLER_180_321 VPWR VGND VPWR VGND sky130_ef_sc_hd__decap_12
XFILLER_49_1410 VPWR VGND VPWR VGND sky130_ef_sc_hd__decap_12
XTAP_TAPCELL_ROW_189_2131 VGND VPWR sky130_fd_sc_hd__tapvpwrvgnd_1
XFILLER_181_877 VPWR VGND VPWR VGND sky130_ef_sc_hd__decap_12
XFILLER_180_365 VPWR VGND VPWR VGND sky130_ef_sc_hd__decap_12
XFILLER_137_51 VGND VGND VPWR VPWR sky130_fd_sc_hd__decap_4
XFILLER_88_1470 VPWR VGND VPWR VGND sky130_ef_sc_hd__decap_12
XFILLER_10_1244 VGND VGND VPWR VPWR sky130_fd_sc_hd__fill_1
XTAP_TAPCELL_ROW_185_2017 VGND VPWR sky130_fd_sc_hd__tapvpwrvgnd_1
XTAP_TAPCELL_ROW_185_2006 VGND VPWR sky130_fd_sc_hd__tapvpwrvgnd_1
XFILLER_97_55 VGND VGND VPWR VPWR sky130_fd_sc_hd__fill_1
XFILLER_84_1356 VGND VGND VPWR VPWR sky130_fd_sc_hd__fill_1
XFILLER_49_1454 VPWR VGND VPWR VGND sky130_ef_sc_hd__decap_12
XFILLER_171_1337 VGND VGND VPWR VPWR sky130_fd_sc_hd__decap_6
XFILLER_136_1468 VGND VGND VPWR VPWR sky130_fd_sc_hd__fill_1
XFILLER_49_1498 VPWR VGND VPWR VGND sky130_ef_sc_hd__decap_12
XFILLER_0_795 VGND VGND VPWR VPWR sky130_fd_sc_hd__decap_3
XFILLER_208_525 VGND VGND VPWR VPWR sky130_fd_sc_hd__decap_6
XFILLER_169_1233 VPWR VGND VPWR VGND sky130_ef_sc_hd__decap_12
XFILLER_1_1401 VPWR VGND VPWR VGND sky130_ef_sc_hd__decap_12
XFILLER_208_569 VPWR VGND VPWR VGND sky130_ef_sc_hd__decap_12
XFILLER_5_1581 VPWR VGND VPWR VGND sky130_ef_sc_hd__decap_12
XFILLER_210_1091 VGND VGND VPWR VPWR sky130_fd_sc_hd__fill_1
XFILLER_165_1119 VGND VGND VPWR VPWR sky130_fd_sc_hd__fill_1
XFILLER_21_1384 VGND VGND VPWR VPWR sky130_fd_sc_hd__fill_1
XFILLER_56_1414 VPWR VGND VPWR VGND sky130_ef_sc_hd__decap_12
XFILLER_206_1105 VPWR VGND VPWR VGND sky130_ef_sc_hd__decap_12
XFILLER_189_933 VPWR VGND VPWR VGND sky130_ef_sc_hd__decap_12
XFILLER_188_421 VPWR VGND VPWR VGND sky130_ef_sc_hd__decap_12
XFILLER_95_1496 VGND VGND VPWR VPWR sky130_fd_sc_hd__fill_1
XFILLER_189_977 VPWR VGND VPWR VGND sky130_ef_sc_hd__decap_12
XFILLER_182_1477 VGND VGND VPWR VPWR sky130_fd_sc_hd__decap_6
XFILLER_108_1526 VPWR VGND VPWR VGND sky130_ef_sc_hd__decap_12
XFILLER_206_1149 VPWR VGND VPWR VGND sky130_ef_sc_hd__decap_12
XTAP_TAPCELL_ROW_174_1710 VGND VPWR sky130_fd_sc_hd__tapvpwrvgnd_1
XTAP_TAPCELL_ROW_142_2_3898 VGND VPWR sky130_fd_sc_hd__tapvpwrvgnd_1
XFILLER_175_137 VPWR VGND VPWR VGND sky130_ef_sc_hd__decap_12
XFILLER_200_981 VPWR VGND VPWR VGND sky130_ef_sc_hd__decap_12
XFILLER_172_811 VGND VGND VPWR VPWR sky130_fd_sc_hd__fill_1
XFILLER_106_1294 VGND VGND VPWR VPWR sky130_fd_sc_hd__decap_6
XFILLER_7_53 VGND VGND VPWR VPWR sky130_fd_sc_hd__decap_3
XFILLER_184_693 VGND VGND VPWR VPWR sky130_fd_sc_hd__decap_6
XFILLER_183_181 VPWR VGND VPWR VGND sky130_ef_sc_hd__decap_12
XTAP_TAPCELL_ROW_122_2_3774 VGND VPWR sky130_fd_sc_hd__tapvpwrvgnd_1
XFILLER_89_1256 VPWR VGND VPWR VGND sky130_ef_sc_hd__decap_12
XFILLER_7_97 VPWR VGND VPWR VGND sky130_ef_sc_hd__decap_12
XFILLER_217_1201 VPWR VGND VPWR VGND sky130_ef_sc_hd__decap_12
XFILLER_176_1259 VGND VGND VPWR VPWR sky130_fd_sc_hd__fill_1
XTAP_TAPCELL_ROW_90_2_3563 VGND VPWR sky130_fd_sc_hd__tapvpwrvgnd_1
XFILLER_67_1510 VPWR VGND VPWR VGND sky130_ef_sc_hd__decap_12
XFILLER_154_1524 VGND VGND VPWR VPWR sky130_fd_sc_hd__fill_1
XTAP_TAPCELL_ROW_89_2_3557 VGND VPWR sky130_fd_sc_hd__tapvpwrvgnd_1
XFILLER_67_1554 VPWR VGND VPWR VGND sky130_ef_sc_hd__decap_12
XFILLER_217_1245 VPWR VGND VPWR VGND sky130_ef_sc_hd__decap_12
XTAP_TAPCELL_ROW_168_1525 VGND VPWR sky130_fd_sc_hd__tapvpwrvgnd_1
XTAP_TAPCELL_ROW_168_1514 VGND VPWR sky130_fd_sc_hd__tapvpwrvgnd_1
XFILLER_28_1538 VPWR VGND VPWR VGND sky130_ef_sc_hd__decap_12
XFILLER_217_1289 VPWR VGND VPWR VGND sky130_ef_sc_hd__decap_12
XTAP_TAPCELL_ROW_168_1536 VGND VPWR sky130_fd_sc_hd__tapvpwrvgnd_1
XPHY_EDGE_ROW_128_2_Left_560 VGND VGND VPWR VPWR sky130_fd_sc_hd__decap_3
XFILLER_152_1270 VPWR VGND VPWR VGND sky130_ef_sc_hd__decap_12
XFILLER_113_1232 VPWR VGND VPWR VGND sky130_ef_sc_hd__decap_12
XFILLER_113_1298 VPWR VGND VPWR VGND sky130_ef_sc_hd__decap_12
XFILLER_26_29 VGND VGND VPWR VPWR sky130_fd_sc_hd__decap_6
XFILLER_187_1399 VGND VGND VPWR VPWR sky130_fd_sc_hd__fill_1
XFILLER_4_1091 VGND VGND VPWR VPWR sky130_fd_sc_hd__fill_1
XPHY_EDGE_ROW_5_Right_5 VGND VGND VPWR VPWR sky130_fd_sc_hd__decap_3
XFILLER_210_701 VPWR VGND VPWR VGND sky130_ef_sc_hd__decap_12
XFILLER_194_413 VGND VGND VPWR VPWR sky130_fd_sc_hd__decap_6
XTAP_TAPCELL_ROW_31_2_3178 VGND VPWR sky130_fd_sc_hd__tapvpwrvgnd_1
XFILLER_194_457 VPWR VGND VPWR VGND sky130_ef_sc_hd__decap_12
XFILLER_124_1350 VGND VGND VPWR VPWR sky130_fd_sc_hd__decap_6
XFILLER_72_1282 VPWR VGND VPWR VGND sky130_ef_sc_hd__decap_12
XFILLER_33_1244 VPWR VGND VPWR VGND sky130_ef_sc_hd__decap_12
XFILLER_175_671 VGND VGND VPWR VPWR sky130_fd_sc_hd__fill_1
XFILLER_124_1394 VPWR VGND VPWR VGND sky130_ef_sc_hd__decap_12
XFILLER_5_309 VPWR VGND VPWR VGND sky130_ef_sc_hd__decap_12
XANTENNA_fanout122_X net122 VGND VGND VPWR VPWR sky130_fd_sc_hd__diode_2
XFILLER_194_1315 VGND VGND VPWR VPWR sky130_fd_sc_hd__fill_1
XFILLER_120_1258 VPWR VGND VPWR VGND sky130_ef_sc_hd__decap_12
XFILLER_50_1580 VGND VGND VPWR VPWR sky130_fd_sc_hd__fill_1
XFILLER_174_27 VGND VGND VPWR VPWR sky130_fd_sc_hd__fill_1
XTAP_TAPCELL_ROW_61_1_1139 VGND VPWR sky130_fd_sc_hd__tapvpwrvgnd_1
XFILLER_192_1061 VPWR VGND VPWR VGND sky130_ef_sc_hd__decap_12
XFILLER_88_121 VGND VGND VPWR VPWR sky130_fd_sc_hd__decap_6
XFILLER_1_559 VGND VGND VPWR VPWR sky130_fd_sc_hd__fill_1
XFILLER_190_15 VPWR VGND VPWR VGND sky130_ef_sc_hd__decap_12
XFILLER_135_1490 VGND VGND VPWR VPWR sky130_fd_sc_hd__decap_6
XFILLER_131_1310 VPWR VGND VPWR VGND sky130_ef_sc_hd__decap_12
XFILLER_67_69 VPWR VGND VPWR VGND sky130_ef_sc_hd__decap_12
XFILLER_131_1354 VPWR VGND VPWR VGND sky130_ef_sc_hd__decap_12
X_620_ clknet_3_3_0_clk _054_ VGND VGND VPWR VPWR net77 sky130_fd_sc_hd__dfxtp_1
XFILLER_218_867 VGND VGND VPWR VPWR sky130_fd_sc_hd__fill_1
XFILLER_177_3 VPWR VGND VPWR VGND sky130_ef_sc_hd__decap_12
XFILLER_131_1398 VPWR VGND VPWR VGND sky130_ef_sc_hd__decap_12
X_551_ net136 _249_ VGND VGND VPWR VPWR _059_ sky130_fd_sc_hd__and2_1
XFILLER_205_517 VPWR VGND VPWR VGND sky130_ef_sc_hd__decap_12
XFILLER_83_57 VPWR VGND VPWR VGND sky130_ef_sc_hd__decap_12
XFILLER_199_57 VPWR VGND VPWR VGND sky130_ef_sc_hd__decap_12
X_482_ net149 net127 VGND VGND VPWR VPWR _214_ sky130_fd_sc_hd__nor2_1
XFILLER_213_561 VPWR VGND VPWR VGND sky130_ef_sc_hd__decap_12
XFILLER_207_1425 VPWR VGND VPWR VGND sky130_ef_sc_hd__decap_12
XFILLER_164_1141 VGND VGND VPWR VPWR sky130_fd_sc_hd__decap_6
XFILLER_129_1272 VGND VGND VPWR VPWR sky130_fd_sc_hd__fill_1
XFILLER_16_73 VGND VGND VPWR VPWR sky130_fd_sc_hd__decap_8
XFILLER_207_1469 VPWR VGND VPWR VGND sky130_ef_sc_hd__decap_12
XFILLER_197_273 VGND VGND VPWR VPWR sky130_fd_sc_hd__decap_6
XFILLER_186_925 VPWR VGND VPWR VGND sky130_ef_sc_hd__decap_12
XFILLER_164_1185 VPWR VGND VPWR VGND sky130_ef_sc_hd__decap_12
XFILLER_200_233 VPWR VGND VPWR VGND sky130_ef_sc_hd__decap_12
XFILLER_142_1450 VPWR VGND VPWR VGND sky130_ef_sc_hd__decap_12
XFILLER_90_1382 VPWR VGND VPWR VGND sky130_ef_sc_hd__decap_12
XANTENNA__328__A0 b_addr\[3\] VGND VGND VPWR VPWR sky130_fd_sc_hd__diode_2
XFILLER_51_1322 VGND VGND VPWR VPWR sky130_fd_sc_hd__decap_6
XFILLER_200_277 VPWR VGND VPWR VGND sky130_ef_sc_hd__decap_12
XFILLER_142_1494 VPWR VGND VPWR VGND sky130_ef_sc_hd__decap_12
XTAP_TAPCELL_ROW_107_2_3676 VGND VPWR sky130_fd_sc_hd__tapvpwrvgnd_1
XFILLER_103_1434 VGND VGND VPWR VPWR sky130_fd_sc_hd__decap_6
XFILLER_32_83 VGND VGND VPWR VPWR sky130_fd_sc_hd__fill_1
XFILLER_51_1366 VPWR VGND VPWR VGND sky130_ef_sc_hd__decap_12
XFILLER_201_1057 VGND VGND VPWR VPWR sky130_fd_sc_hd__decap_6
XFILLER_177_1513 VPWR VGND VPWR VGND sky130_ef_sc_hd__decap_12
XFILLER_166_693 VGND VGND VPWR VPWR sky130_fd_sc_hd__decap_6
XFILLER_165_181 VPWR VGND VPWR VGND sky130_ef_sc_hd__decap_12
XFILLER_148_83 VGND VGND VPWR VPWR sky130_fd_sc_hd__fill_1
XFILLER_103_1478 VPWR VGND VPWR VGND sky130_ef_sc_hd__decap_12
XFILLER_181_641 VPWR VGND VPWR VGND sky130_ef_sc_hd__decap_12
XTAP_TAPCELL_ROW_75_2_3465 VGND VPWR sky130_fd_sc_hd__tapvpwrvgnd_1
XFILLER_218_1521 VPWR VGND VPWR VGND sky130_ef_sc_hd__decap_12
XFILLER_181_685 VPWR VGND VPWR VGND sky130_ef_sc_hd__decap_12
XFILLER_218_1565 VPWR VGND VPWR VGND sky130_ef_sc_hd__decap_12
XFILLER_180_195 VGND VGND VPWR VPWR sky130_fd_sc_hd__fill_1
XFILLER_175_1281 VGND VGND VPWR VPWR sky130_fd_sc_hd__decap_6
XFILLER_171_1101 VPWR VGND VPWR VGND sky130_ef_sc_hd__decap_12
XFILLER_136_1232 VPWR VGND VPWR VGND sky130_ef_sc_hd__decap_12
XFILLER_214_1429 VPWR VGND VPWR VGND sky130_ef_sc_hd__decap_12
XFILLER_171_1145 VPWR VGND VPWR VGND sky130_ef_sc_hd__decap_12
XPHY_EDGE_ROW_113_1_Left_332 VGND VGND VPWR VPWR sky130_fd_sc_hd__decap_3
XFILLER_171_1189 VPWR VGND VPWR VGND sky130_ef_sc_hd__decap_12
XFILLER_153_1590 VPWR VGND VPWR VGND sky130_ef_sc_hd__decap_12
XFILLER_62_1462 VGND VGND VPWR VPWR sky130_fd_sc_hd__decap_6
XFILLER_114_1574 VGND VGND VPWR VPWR sky130_fd_sc_hd__decap_6
XFILLER_212_1197 VGND VGND VPWR VPWR sky130_fd_sc_hd__decap_6
XFILLER_209_889 VGND VGND VPWR VPWR sky130_fd_sc_hd__decap_6
XFILLER_208_333 VPWR VGND VPWR VGND sky130_ef_sc_hd__decap_12
XFILLER_110_1438 VPWR VGND VPWR VGND sky130_ef_sc_hd__decap_12
XFILLER_208_377 VPWR VGND VPWR VGND sky130_ef_sc_hd__decap_12
XFILLER_169_1063 VGND VGND VPWR VPWR sky130_fd_sc_hd__fill_1
XFILLER_1_1231 VGND VGND VPWR VPWR sky130_fd_sc_hd__fill_1
XFILLER_184_1539 VGND VGND VPWR VPWR sky130_fd_sc_hd__fill_1
XFILLER_189_741 VPWR VGND VPWR VGND sky130_ef_sc_hd__decap_12
XFILLER_182_1241 VPWR VGND VPWR VGND sky130_ef_sc_hd__decap_12
XANTENNA__567__B1 net157 VGND VGND VPWR VPWR sky130_fd_sc_hd__diode_2
XFILLER_56_1244 VGND VGND VPWR VPWR sky130_fd_sc_hd__fill_1
XFILLER_189_785 VPWR VGND VPWR VGND sky130_ef_sc_hd__decap_12
XFILLER_188_251 VGND VGND VPWR VPWR sky130_fd_sc_hd__fill_1
XFILLER_182_1285 VPWR VGND VPWR VGND sky130_ef_sc_hd__decap_12
XFILLER_176_413 VGND VGND VPWR VPWR sky130_fd_sc_hd__decap_6
XFILLER_108_1356 VGND VGND VPWR VPWR sky130_fd_sc_hd__fill_1
XFILLER_92_3 VPWR VGND VPWR VGND sky130_ef_sc_hd__decap_12
XFILLER_176_457 VPWR VGND VPWR VGND sky130_ef_sc_hd__decap_12
XFILLER_160_1550 VPWR VGND VPWR VGND sky130_ef_sc_hd__decap_12
XFILLER_192_917 VGND VGND VPWR VPWR sky130_fd_sc_hd__decap_6
XFILLER_191_405 VPWR VGND VPWR VGND sky130_ef_sc_hd__decap_12
XFILLER_121_1534 VPWR VGND VPWR VGND sky130_ef_sc_hd__decap_12
XFILLER_30_1406 VGND VGND VPWR VPWR sky130_fd_sc_hd__decap_6
XFILLER_191_449 VPWR VGND VPWR VGND sky130_ef_sc_hd__decap_12
XFILLER_160_1594 VGND VGND VPWR VPWR sky130_fd_sc_hd__decap_8
XFILLER_219_1329 VPWR VGND VPWR VGND sky130_ef_sc_hd__decap_12
XFILLER_121_1578 VPWR VGND VPWR VGND sky130_ef_sc_hd__decap_12
XFILLER_208_53 VPWR VGND VPWR VGND sky130_ef_sc_hd__decap_12
XFILLER_28_1302 VPWR VGND VPWR VGND sky130_ef_sc_hd__decap_12
XFILLER_208_97 VPWR VGND VPWR VGND sky130_ef_sc_hd__decap_12
XFILLER_193_1381 VPWR VGND VPWR VGND sky130_ef_sc_hd__decap_12
XFILLER_67_1384 VGND VGND VPWR VPWR sky130_fd_sc_hd__fill_1
XPHY_EDGE_ROW_45_1_Left_264 VGND VGND VPWR VPWR sky130_fd_sc_hd__decap_3
XFILLER_119_1496 VGND VGND VPWR VPWR sky130_fd_sc_hd__fill_1
XFILLER_85_113 VPWR VGND VPWR VGND sky130_ef_sc_hd__decap_12
XFILLER_80_1562 VPWR VGND VPWR VGND sky130_ef_sc_hd__decap_12
XFILLER_37_39 VPWR VGND VPWR VGND sky130_ef_sc_hd__decap_12
XFILLER_41_1546 VGND VGND VPWR VPWR sky130_fd_sc_hd__decap_6
XFILLER_160_29 VPWR VGND VPWR VGND sky130_ef_sc_hd__decap_12
XTAP_TAPCELL_ROW_144_2_3917 VGND VPWR sky130_fd_sc_hd__tapvpwrvgnd_1
XTAP_TAPCELL_ROW_2_857 VGND VPWR sky130_fd_sc_hd__tapvpwrvgnd_1
XFILLER_2_1017 VPWR VGND VPWR VGND sky130_ef_sc_hd__decap_12
XTAP_TAPCELL_ROW_2_846 VGND VPWR sky130_fd_sc_hd__tapvpwrvgnd_1
XTAP_TAPCELL_ROW_2_835 VGND VPWR sky130_fd_sc_hd__tapvpwrvgnd_1
XFILLER_6_1197 VGND VGND VPWR VPWR sky130_fd_sc_hd__decap_6
XFILLER_199_505 VPWR VGND VPWR VGND sky130_ef_sc_hd__decap_12
XFILLER_74_1300 VGND VGND VPWR VPWR sky130_fd_sc_hd__fill_1
XFILLER_53_27 VPWR VGND VPWR VGND sky130_ef_sc_hd__decap_12
XFILLER_169_27 VPWR VGND VPWR VGND sky130_ef_sc_hd__decap_12
XFILLER_126_1412 VGND VGND VPWR VPWR sky130_fd_sc_hd__fill_1
XFILLER_39_1442 VPWR VGND VPWR VGND sky130_ef_sc_hd__decap_12
XFILLER_210_531 VGND VGND VPWR VPWR sky130_fd_sc_hd__fill_1
XFILLER_179_273 VGND VGND VPWR VPWR sky130_fd_sc_hd__decap_6
XFILLER_168_925 VPWR VGND VPWR VGND sky130_ef_sc_hd__decap_12
XFILLER_35_1328 VGND VGND VPWR VPWR sky130_fd_sc_hd__fill_1
XFILLER_194_221 VPWR VGND VPWR VGND sky130_ef_sc_hd__decap_12
XFILLER_195_777 VGND VGND VPWR VPWR sky130_fd_sc_hd__decap_6
XFILLER_194_265 VPWR VGND VPWR VGND sky130_ef_sc_hd__decap_12
XFILLER_185_15 VPWR VGND VPWR VGND sky130_ef_sc_hd__decap_12
XTAP_TAPCELL_ROW_61_2_3373 VGND VPWR sky130_fd_sc_hd__tapvpwrvgnd_1
XFILLER_163_641 VGND VGND VPWR VPWR sky130_fd_sc_hd__decap_3
XFILLER_159_1232 VPWR VGND VPWR VGND sky130_ef_sc_hd__decap_12
XFILLER_163_685 VPWR VGND VPWR VGND sky130_ef_sc_hd__decap_12
XFILLER_118_53 VPWR VGND VPWR VGND sky130_ef_sc_hd__decap_12
XFILLER_85_1440 VGND VGND VPWR VPWR sky130_fd_sc_hd__fill_1
XFILLER_172_1421 VGND VGND VPWR VPWR sky130_fd_sc_hd__decap_6
XFILLER_159_1298 VPWR VGND VPWR VGND sky130_ef_sc_hd__decap_12
XFILLER_118_97 VPWR VGND VPWR VGND sky130_ef_sc_hd__decap_12
XFILLER_172_1465 VPWR VGND VPWR VGND sky130_ef_sc_hd__decap_12
XFILLER_137_1552 VGND VGND VPWR VPWR sky130_fd_sc_hd__fill_1
XFILLER_46_1468 VGND VGND VPWR VPWR sky130_fd_sc_hd__fill_1
XFILLER_134_41 VPWR VGND VPWR VGND sky130_ef_sc_hd__decap_12
XFILLER_1_389 VGND VGND VPWR VPWR sky130_fd_sc_hd__decap_3
XFILLER_134_85 VPWR VGND VPWR VGND sky130_ef_sc_hd__decap_12
XFILLER_91_105 VGND VGND VPWR VPWR sky130_fd_sc_hd__decap_6
X_603_ clknet_3_3_0_clk _037_ VGND VGND VPWR VPWR net59 sky130_fd_sc_hd__dfxtp_1
XFILLER_206_837 VPWR VGND VPWR VGND sky130_ef_sc_hd__decap_12
XFILLER_166_1203 VGND VGND VPWR VPWR sky130_fd_sc_hd__fill_1
XFILLER_79_1244 VPWR VGND VPWR VGND sky130_ef_sc_hd__decap_12
XANTENNA_input12_A func_wdata[0] VGND VGND VPWR VPWR sky130_fd_sc_hd__diode_2
XFILLER_27_61 VGND VGND VPWR VPWR sky130_fd_sc_hd__fill_1
XFILLER_27_50 VGND VGND VPWR VPWR sky130_fd_sc_hd__decap_6
X_534_ net74 net121 VGND VGND VPWR VPWR _241_ sky130_fd_sc_hd__or2_1
XFILLER_27_94 VPWR VGND VPWR VGND sky130_ef_sc_hd__decap_12
XFILLER_183_1561 VGND VGND VPWR VPWR sky130_fd_sc_hd__decap_6
XFILLER_96_1580 VGND VGND VPWR VPWR sky130_fd_sc_hd__fill_1
X_465_ net145 net97 VGND VGND VPWR VPWR _197_ sky130_fd_sc_hd__xor2_1
XFILLER_2_1595 VGND VGND VPWR VPWR sky130_fd_sc_hd__fill_1
XFILLER_214_881 VPWR VGND VPWR VGND sky130_ef_sc_hd__decap_12
XFILLER_207_1233 VPWR VGND VPWR VGND sky130_ef_sc_hd__decap_12
XFILLER_18_1526 VPWR VGND VPWR VGND sky130_ef_sc_hd__decap_12
XFILLER_213_391 VGND VGND VPWR VPWR sky130_fd_sc_hd__fill_1
XFILLER_203_1119 VGND VGND VPWR VPWR sky130_fd_sc_hd__fill_1
XFILLER_201_553 VGND VGND VPWR VPWR sky130_fd_sc_hd__decap_6
XFILLER_199_1001 VGND VGND VPWR VPWR sky130_fd_sc_hd__decap_6
XFILLER_186_755 VGND VGND VPWR VPWR sky130_fd_sc_hd__fill_1
X_396_ _128_ _129_ _127_ VGND VGND VPWR VPWR _133_ sky130_fd_sc_hd__o21ai_1
XFILLER_43_93 VPWR VGND VPWR VGND sky130_ef_sc_hd__decap_12
XFILLER_201_597 VPWR VGND VPWR VGND sky130_ef_sc_hd__decap_12
XFILLER_199_1045 VPWR VGND VPWR VGND sky130_ef_sc_hd__decap_12
XFILLER_174_917 VGND VGND VPWR VPWR sky130_fd_sc_hd__decap_6
XFILLER_173_405 VPWR VGND VPWR VGND sky130_ef_sc_hd__decap_12
XFILLER_159_93 VPWR VGND VPWR VGND sky130_ef_sc_hd__decap_12
XFILLER_103_1220 VPWR VGND VPWR VGND sky130_ef_sc_hd__decap_12
XFILLER_199_1089 VPWR VGND VPWR VGND sky130_ef_sc_hd__decap_12
XFILLER_173_449 VPWR VGND VPWR VGND sky130_ef_sc_hd__decap_12
XFILLER_16_1294 VGND VGND VPWR VPWR sky130_fd_sc_hd__decap_6
XFILLER_182_961 VPWR VGND VPWR VGND sky130_ef_sc_hd__decap_12
XFILLER_177_1343 VGND VGND VPWR VPWR sky130_fd_sc_hd__fill_1
XFILLER_103_1286 VPWR VGND VPWR VGND sky130_ef_sc_hd__decap_12
XTAP_TAPCELL_ROW_137_2_3871 VGND VPWR sky130_fd_sc_hd__tapvpwrvgnd_1
XFILLER_190_1521 VPWR VGND VPWR VGND sky130_ef_sc_hd__decap_12
XFILLER_175_81 VPWR VGND VPWR VGND sky130_ef_sc_hd__decap_12
XFILLER_138_1338 VPWR VGND VPWR VGND sky130_ef_sc_hd__decap_12
XFILLER_64_1524 VGND VGND VPWR VPWR sky130_fd_sc_hd__fill_1
XFILLER_218_1373 VPWR VGND VPWR VGND sky130_ef_sc_hd__decap_12
XFILLER_4_65 VPWR VGND VPWR VGND sky130_ef_sc_hd__decap_12
XFILLER_214_1259 VGND VGND VPWR VPWR sky130_fd_sc_hd__fill_1
XFILLER_190_1565 VPWR VGND VPWR VGND sky130_ef_sc_hd__decap_12
XFILLER_67_113 VPWR VGND VPWR VGND sky130_ef_sc_hd__decap_12
XTAP_TAPCELL_ROW_130_2_3825 VGND VPWR sky130_fd_sc_hd__tapvpwrvgnd_1
XFILLER_23_1232 VPWR VGND VPWR VGND sky130_ef_sc_hd__decap_12
XFILLER_62_1270 VPWR VGND VPWR VGND sky130_ef_sc_hd__decap_12
XFILLER_209_653 VPWR VGND VPWR VGND sky130_ef_sc_hd__decap_12
XTAP_TAPCELL_ROW_129_2_3819 VGND VPWR sky130_fd_sc_hd__tapvpwrvgnd_1
XFILLER_114_1382 VPWR VGND VPWR VGND sky130_ef_sc_hd__decap_12
XFILLER_97_1322 VGND VGND VPWR VPWR sky130_fd_sc_hd__decap_6
XFILLER_3_1337 VGND VGND VPWR VPWR sky130_fd_sc_hd__decap_6
XFILLER_209_697 VPWR VGND VPWR VGND sky130_ef_sc_hd__decap_12
XFILLER_208_141 VPWR VGND VPWR VGND sky130_ef_sc_hd__decap_12
XFILLER_110_1246 VPWR VGND VPWR VGND sky130_ef_sc_hd__decap_12
XTAP_TAPCELL_ROW_97_2_3608 VGND VPWR sky130_fd_sc_hd__tapvpwrvgnd_1
XFILLER_23_1298 VPWR VGND VPWR VGND sky130_ef_sc_hd__decap_12
XFILLER_188_1483 VGND VGND VPWR VPWR sky130_fd_sc_hd__fill_1
XFILLER_149_1434 VGND VGND VPWR VPWR sky130_fd_sc_hd__decap_6
XFILLER_97_1366 VPWR VGND VPWR VGND sky130_ef_sc_hd__decap_12
XFILLER_149_1478 VPWR VGND VPWR VGND sky130_ef_sc_hd__decap_12
XTAP_TAPCELL_ROW_85_1_1187 VGND VPWR sky130_fd_sc_hd__tapvpwrvgnd_1
XFILLER_211_317 VPWR VGND VPWR VGND sky130_ef_sc_hd__decap_12
XFILLER_210_65 VPWR VGND VPWR VGND sky130_ef_sc_hd__decap_12
XFILLER_182_1093 VPWR VGND VPWR VGND sky130_ef_sc_hd__decap_12
XFILLER_176_221 VPWR VGND VPWR VGND sky130_ef_sc_hd__decap_12
XFILLER_177_777 VGND VGND VPWR VPWR sky130_fd_sc_hd__decap_6
XFILLER_176_265 VPWR VGND VPWR VGND sky130_ef_sc_hd__decap_12
XFILLER_34_1350 VGND VGND VPWR VPWR sky130_fd_sc_hd__decap_6
XTAP_TAPCELL_ROW_46_2_3275 VGND VPWR sky130_fd_sc_hd__tapvpwrvgnd_1
XFILLER_219_41 VPWR VGND VPWR VGND sky130_ef_sc_hd__decap_12
XFILLER_192_725 VPWR VGND VPWR VGND sky130_ef_sc_hd__decap_12
XFILLER_178_1129 VPWR VGND VPWR VGND sky130_ef_sc_hd__decap_12
XFILLER_121_1342 VPWR VGND VPWR VGND sky130_ef_sc_hd__decap_12
XFILLER_34_1394 VPWR VGND VPWR VGND sky130_ef_sc_hd__decap_12
XFILLER_219_85 VPWR VGND VPWR VGND sky130_ef_sc_hd__decap_12
XFILLER_192_769 VPWR VGND VPWR VGND sky130_ef_sc_hd__decap_12
XFILLER_121_1386 VPWR VGND VPWR VGND sky130_ef_sc_hd__decap_12
XFILLER_30_1258 VPWR VGND VPWR VGND sky130_ef_sc_hd__decap_12
XFILLER_191_279 VGND VGND VPWR VPWR sky130_fd_sc_hd__fill_1
XFILLER_2_109 VGND VGND VPWR VPWR sky130_fd_sc_hd__decap_8
XFILLER_156_1438 VPWR VGND VPWR VGND sky130_ef_sc_hd__decap_12
XFILLER_82_1602 VGND VGND VPWR VPWR sky130_fd_sc_hd__decap_3
XPHY_EDGE_ROW_100_2_Right_157 VGND VGND VPWR VPWR sky130_fd_sc_hd__decap_3
XANTENNA_input4_A func_addr[1] VGND VGND VPWR VPWR sky130_fd_sc_hd__diode_2
XFILLER_48_27 VGND VGND VPWR VPWR sky130_fd_sc_hd__fill_1
XFILLER_219_417 VGND VGND VPWR VPWR sky130_fd_sc_hd__decap_3
XFILLER_189_1225 VGND VGND VPWR VPWR sky130_fd_sc_hd__decap_6
XFILLER_171_39 VPWR VGND VPWR VGND sky130_ef_sc_hd__decap_12
XFILLER_80_1370 VPWR VGND VPWR VGND sky130_ef_sc_hd__decap_12
XFILLER_41_1310 VPWR VGND VPWR VGND sky130_ef_sc_hd__decap_12
XFILLER_45_1490 VGND VGND VPWR VPWR sky130_fd_sc_hd__decap_6
XFILLER_73_105 VGND VGND VPWR VPWR sky130_fd_sc_hd__decap_6
XFILLER_41_1354 VPWR VGND VPWR VGND sky130_ef_sc_hd__decap_12
XFILLER_189_1269 VPWR VGND VPWR VGND sky130_ef_sc_hd__decap_12
XFILLER_132_1482 VPWR VGND VPWR VGND sky130_ef_sc_hd__decap_12
XFILLER_104_77 VGND VGND VPWR VPWR sky130_fd_sc_hd__decap_6
XFILLER_76_1406 VGND VGND VPWR VPWR sky130_fd_sc_hd__decap_6
XFILLER_64_15 VPWR VGND VPWR VGND sky130_ef_sc_hd__decap_12
XFILLER_41_1398 VPWR VGND VPWR VGND sky130_ef_sc_hd__decap_12
XFILLER_214_133 VGND VGND VPWR VPWR sky130_fd_sc_hd__decap_6
XFILLER_199_335 VGND VGND VPWR VPWR sky130_fd_sc_hd__fill_1
XFILLER_167_1567 VGND VGND VPWR VPWR sky130_fd_sc_hd__fill_1
XTAP_TAPCELL_ROW_132_1_1282 VGND VPWR sky130_fd_sc_hd__tapvpwrvgnd_1
XFILLER_128_1518 VGND VGND VPWR VPWR sky130_fd_sc_hd__decap_6
XFILLER_214_177 VPWR VGND VPWR VGND sky130_ef_sc_hd__decap_12
XFILLER_208_1553 VPWR VGND VPWR VGND sky130_ef_sc_hd__decap_12
XFILLER_126_1220 VPWR VGND VPWR VGND sky130_ef_sc_hd__decap_12
XFILLER_120_65 VPWR VGND VPWR VGND sky130_ef_sc_hd__decap_12
XFILLER_39_1272 VGND VGND VPWR VPWR sky130_fd_sc_hd__fill_1
XFILLER_208_1597 VGND VGND VPWR VPWR sky130_fd_sc_hd__decap_8
XFILLER_195_541 VPWR VGND VPWR VGND sky130_ef_sc_hd__decap_12
XFILLER_168_755 VGND VGND VPWR VPWR sky130_fd_sc_hd__fill_1
XFILLER_211_895 VGND VGND VPWR VPWR sky130_fd_sc_hd__fill_1
XFILLER_52_1450 VPWR VGND VPWR VGND sky130_ef_sc_hd__decap_12
XFILLER_202_1141 VGND VGND VPWR VPWR sky130_fd_sc_hd__decap_6
XFILLER_195_585 VPWR VGND VPWR VGND sky130_ef_sc_hd__decap_12
XFILLER_7_949 VGND VGND VPWR VPWR sky130_fd_sc_hd__decap_3
XFILLER_13_1434 VGND VGND VPWR VPWR sky130_fd_sc_hd__decap_6
XFILLER_52_1494 VPWR VGND VPWR VGND sky130_ef_sc_hd__decap_12
XFILLER_202_1185 VPWR VGND VPWR VGND sky130_ef_sc_hd__decap_12
XFILLER_196_1229 VPWR VGND VPWR VGND sky130_ef_sc_hd__decap_12
XFILLER_171_909 VPWR VGND VPWR VGND sky130_ef_sc_hd__decap_12
XFILLER_164_961 VPWR VGND VPWR VGND sky130_ef_sc_hd__decap_12
XFILLER_104_1562 VPWR VGND VPWR VGND sky130_ef_sc_hd__decap_12
XFILLER_100_1426 VPWR VGND VPWR VGND sky130_ef_sc_hd__decap_12
XFILLER_13_1478 VPWR VGND VPWR VGND sky130_ef_sc_hd__decap_12
XANTENNA__352__S net153 VGND VGND VPWR VPWR sky130_fd_sc_hd__diode_2
XFILLER_170_419 VGND VGND VPWR VPWR sky130_fd_sc_hd__fill_1
XFILLER_87_1546 VGND VGND VPWR VPWR sky130_fd_sc_hd__decap_6
XTAP_TAPCELL_ROW_213_2797 VGND VPWR sky130_fd_sc_hd__tapvpwrvgnd_1
XFILLER_150_121 VGND VGND VPWR VPWR sky130_fd_sc_hd__decap_6
XFILLER_215_1513 VPWR VGND VPWR VGND sky130_ef_sc_hd__decap_12
XFILLER_145_51 VGND VGND VPWR VPWR sky130_fd_sc_hd__decap_4
XFILLER_46_1232 VPWR VGND VPWR VGND sky130_ef_sc_hd__decap_12
XFILLER_172_1273 VPWR VGND VPWR VGND sky130_ef_sc_hd__decap_12
XFILLER_2_687 VGND VGND VPWR VPWR sky130_fd_sc_hd__fill_1
XFILLER_1_164 VGND VGND VPWR VPWR sky130_fd_sc_hd__decap_4
XFILLER_49_113 VPWR VGND VPWR VGND sky130_ef_sc_hd__decap_12
XTAP_TAPCELL_ROW_115_2_3727 VGND VPWR sky130_fd_sc_hd__tapvpwrvgnd_1
XFILLER_1_197 VPWR VGND VPWR VGND sky130_ef_sc_hd__decap_12
XTAP_TAPCELL_ROW_6_960 VGND VPWR sky130_fd_sc_hd__tapvpwrvgnd_1
XTAP_TAPCELL_ROW_6_971 VGND VPWR sky130_fd_sc_hd__tapvpwrvgnd_1
XFILLER_213_1281 VGND VGND VPWR VPWR sky130_fd_sc_hd__decap_6
XFILLER_133_1268 VGND VGND VPWR VPWR sky130_fd_sc_hd__decap_4
XFILLER_111_1522 VPWR VGND VPWR VGND sky130_ef_sc_hd__decap_12
XTAP_TAPCELL_ROW_83_2_3516 VGND VPWR sky130_fd_sc_hd__tapvpwrvgnd_1
XFILLER_63_1590 VPWR VGND VPWR VGND sky130_ef_sc_hd__decap_12
XFILLER_24_1574 VGND VGND VPWR VPWR sky130_fd_sc_hd__decap_6
XFILLER_206_601 VPWR VGND VPWR VGND sky130_ef_sc_hd__decap_12
XFILLER_168_1309 VGND VGND VPWR VPWR sky130_fd_sc_hd__decap_6
XFILLER_150_1582 VPWR VGND VPWR VGND sky130_ef_sc_hd__decap_12
XFILLER_20_1438 VPWR VGND VPWR VGND sky130_ef_sc_hd__decap_12
XFILLER_206_645 VPWR VGND VPWR VGND sky130_ef_sc_hd__decap_12
XFILLER_205_111 VGND VGND VPWR VPWR sky130_fd_sc_hd__fill_1
XFILLER_111_1566 VPWR VGND VPWR VGND sky130_ef_sc_hd__decap_12
XFILLER_94_1506 VPWR VGND VPWR VGND sky130_ef_sc_hd__decap_12
X_517_ net150 _186_ net128 net137 _232_ VGND VGND VPWR VPWR _042_ sky130_fd_sc_hd__o311a_1
XFILLER_109_1440 VGND VGND VPWR VPWR sky130_fd_sc_hd__fill_1
XFILLER_207_1063 VGND VGND VPWR VPWR sky130_fd_sc_hd__fill_1
X_448_ net145 net106 VGND VGND VPWR VPWR _180_ sky130_fd_sc_hd__xor2_2
XPHY_EDGE_ROW_12_2_Left_444 VGND VGND VPWR VPWR sky130_fd_sc_hd__decap_3
XFILLER_18_1356 VGND VGND VPWR VPWR sky130_fd_sc_hd__fill_1
XTAP_TAPCELL_ROW_32_2_3183 VGND VPWR sky130_fd_sc_hd__tapvpwrvgnd_1
XFILLER_201_361 VPWR VGND VPWR VGND sky130_ef_sc_hd__decap_12
XFILLER_70_1550 VPWR VGND VPWR VGND sky130_ef_sc_hd__decap_12
X_379_ b_addr\[0\] _102_ VGND VGND VPWR VPWR _119_ sky130_fd_sc_hd__and2_1
XFILLER_174_725 VPWR VGND VPWR VGND sky130_ef_sc_hd__decap_12
XFILLER_31_1534 VPWR VGND VPWR VGND sky130_ef_sc_hd__decap_12
XFILLER_179_1449 VGND VGND VPWR VPWR sky130_fd_sc_hd__decap_6
XFILLER_174_769 VPWR VGND VPWR VGND sky130_ef_sc_hd__decap_12
XFILLER_70_1594 VGND VGND VPWR VPWR sky130_fd_sc_hd__decap_8
XFILLER_173_279 VGND VGND VPWR VPWR sky130_fd_sc_hd__fill_1
XFILLER_31_1578 VPWR VGND VPWR VGND sky130_ef_sc_hd__decap_12
XFILLER_6_993 VPWR VGND VPWR VGND sky130_ef_sc_hd__decap_12
XTAP_TAPCELL_ROW_4_908 VGND VPWR sky130_fd_sc_hd__tapvpwrvgnd_1
XFILLER_9_1546 VGND VGND VPWR VPWR sky130_fd_sc_hd__decap_6
XFILLER_190_1373 VPWR VGND VPWR VGND sky130_ef_sc_hd__decap_12
XTAP_TAPCELL_ROW_4_919 VGND VPWR sky130_fd_sc_hd__tapvpwrvgnd_1
XFILLER_29_1496 VGND VGND VPWR VPWR sky130_fd_sc_hd__fill_1
XFILLER_3_1101 VPWR VGND VPWR VGND sky130_ef_sc_hd__decap_12
XPHY_EDGE_ROW_20_1_Right_606 VGND VGND VPWR VPWR sky130_fd_sc_hd__decap_3
XFILLER_55_105 VGND VGND VPWR VPWR sky130_fd_sc_hd__decap_6
XFILLER_209_461 VPWR VGND VPWR VGND sky130_ef_sc_hd__decap_12
XFILLER_186_1409 VPWR VGND VPWR VGND sky130_ef_sc_hd__decap_12
XFILLER_3_1145 VPWR VGND VPWR VGND sky130_ef_sc_hd__decap_12
XFILLER_149_1220 VPWR VGND VPWR VGND sky130_ef_sc_hd__decap_12
XFILLER_3_1189 VPWR VGND VPWR VGND sky130_ef_sc_hd__decap_12
XFILLER_212_637 VGND VGND VPWR VPWR sky130_fd_sc_hd__decap_6
XFILLER_211_125 VPWR VGND VPWR VGND sky130_ef_sc_hd__decap_12
XFILLER_197_839 VGND VGND VPWR VPWR sky130_fd_sc_hd__fill_1
XFILLER_149_1286 VPWR VGND VPWR VGND sky130_ef_sc_hd__decap_12
XFILLER_34_29 VPWR VGND VPWR VGND sky130_ef_sc_hd__decap_12
XFILLER_36_1412 VGND VGND VPWR VPWR sky130_fd_sc_hd__fill_1
XFILLER_211_169 VPWR VGND VPWR VGND sky130_ef_sc_hd__decap_12
XFILLER_177_541 VPWR VGND VPWR VGND sky130_ef_sc_hd__decap_12
XFILLER_197_1505 VGND VGND VPWR VPWR sky130_fd_sc_hd__decap_6
XFILLER_192_533 VPWR VGND VPWR VGND sky130_ef_sc_hd__decap_12
XFILLER_177_585 VPWR VGND VPWR VGND sky130_ef_sc_hd__decap_12
XTAP_TAPCELL_ROW_108_2_3681 VGND VPWR sky130_fd_sc_hd__tapvpwrvgnd_1
Xclkload6 clknet_3_7_0_clk VGND VGND VPWR VPWR clkload6/Y sky130_fd_sc_hd__inv_6
XFILLER_197_1549 VPWR VGND VPWR VGND sky130_ef_sc_hd__decap_12
XTAP_TAPCELL_ROW_108_1_1233 VGND VPWR sky130_fd_sc_hd__tapvpwrvgnd_1
XTAP_TAPCELL_ROW_76_2_3470 VGND VPWR sky130_fd_sc_hd__tapvpwrvgnd_1
XFILLER_69_1232 VPWR VGND VPWR VGND sky130_ef_sc_hd__decap_12
XFILLER_132_121 VGND VGND VPWR VPWR sky130_fd_sc_hd__decap_6
XTAP_TAPCELL_ROW_13_1_1044 VGND VPWR sky130_fd_sc_hd__tapvpwrvgnd_1
XFILLER_59_15 VPWR VGND VPWR VGND sky130_ef_sc_hd__decap_12
XFILLER_182_27 VGND VGND VPWR VPWR sky130_fd_sc_hd__fill_1
XFILLER_156_1246 VPWR VGND VPWR VGND sky130_ef_sc_hd__decap_12
XFILLER_69_1298 VPWR VGND VPWR VGND sky130_ef_sc_hd__decap_12
XTAP_TAPCELL_ROW_101_2_3635 VGND VPWR sky130_fd_sc_hd__tapvpwrvgnd_1
XFILLER_47_1552 VGND VGND VPWR VPWR sky130_fd_sc_hd__fill_1
XFILLER_219_225 VPWR VGND VPWR VGND sky130_ef_sc_hd__decap_12
XFILLER_173_1593 VPWR VGND VPWR VGND sky130_ef_sc_hd__decap_12
XFILLER_210_1421 VGND VGND VPWR VPWR sky130_fd_sc_hd__decap_6
XFILLER_189_1033 VPWR VGND VPWR VGND sky130_ef_sc_hd__decap_12
XPHY_EDGE_ROW_101_2_Right_158 VGND VGND VPWR VPWR sky130_fd_sc_hd__decap_3
XTAP_TAPCELL_ROW_68_2_3418 VGND VPWR sky130_fd_sc_hd__tapvpwrvgnd_1
XFILLER_75_69 VPWR VGND VPWR VGND sky130_ef_sc_hd__decap_12
XFILLER_210_1465 VPWR VGND VPWR VGND sky130_ef_sc_hd__decap_12
XFILLER_189_1077 VPWR VGND VPWR VGND sky130_ef_sc_hd__decap_12
XFILLER_215_497 VGND VGND VPWR VPWR sky130_fd_sc_hd__decap_6
XTAP_TAPCELL_ROW_202_2498 VGND VPWR sky130_fd_sc_hd__tapvpwrvgnd_1
XFILLER_203_615 VGND VGND VPWR VPWR sky130_fd_sc_hd__fill_1
XTAP_TAPCELL_ROW_202_2487 VGND VPWR sky130_fd_sc_hd__tapvpwrvgnd_1
XTAP_TAPCELL_ROW_198_2380 VGND VPWR sky130_fd_sc_hd__tapvpwrvgnd_1
XFILLER_187_305 VPWR VGND VPWR VGND sky130_ef_sc_hd__decap_12
XFILLER_163_1217 VPWR VGND VPWR VGND sky130_ef_sc_hd__decap_12
XFILLER_128_1326 VPWR VGND VPWR VGND sky130_ef_sc_hd__decap_12
XFILLER_91_57 VPWR VGND VPWR VGND sky130_ef_sc_hd__decap_12
XFILLER_76_1258 VPWR VGND VPWR VGND sky130_ef_sc_hd__decap_12
XFILLER_204_1203 VGND VGND VPWR VPWR sky130_fd_sc_hd__fill_1
XTAP_TAPCELL_ROW_198_2391 VGND VPWR sky130_fd_sc_hd__tapvpwrvgnd_1
XTAP_TAPCELL_ROW_194_2255 VGND VPWR sky130_fd_sc_hd__tapvpwrvgnd_1
XFILLER_187_349 VPWR VGND VPWR VGND sky130_ef_sc_hd__decap_12
XFILLER_106_1602 VGND VGND VPWR VPWR sky130_fd_sc_hd__decap_3
X_302_ net43 net142 net131 VGND VGND VPWR VPWR s_wdata\[9\] sky130_fd_sc_hd__a21o_1
XFILLER_196_861 VGND VGND VPWR VPWR sky130_fd_sc_hd__decap_6
XTAP_TAPCELL_ROW_194_2277 VGND VPWR sky130_fd_sc_hd__tapvpwrvgnd_1
XTAP_TAPCELL_ROW_194_2266 VGND VPWR sky130_fd_sc_hd__tapvpwrvgnd_1
XFILLER_180_1553 VPWR VGND VPWR VGND sky130_ef_sc_hd__decap_12
XPHY_EDGE_ROW_122_1_Left_341 VGND VGND VPWR VPWR sky130_fd_sc_hd__decap_3
XTAP_TAPCELL_ROW_219_2995 VGND VPWR sky130_fd_sc_hd__tapvpwrvgnd_1
XTAP_TAPCELL_ROW_219_2984 VGND VPWR sky130_fd_sc_hd__tapvpwrvgnd_1
XTAP_TAPCELL_ROW_219_2973 VGND VPWR sky130_fd_sc_hd__tapvpwrvgnd_1
XFILLER_180_1597 VGND VGND VPWR VPWR sky130_fd_sc_hd__decap_8
XFILLER_7_713 VPWR VGND VPWR VGND sky130_ef_sc_hd__decap_12
XFILLER_13_1220 VPWR VGND VPWR VGND sky130_ef_sc_hd__decap_12
XTAP_TAPCELL_ROW_215_2859 VGND VPWR sky130_fd_sc_hd__tapvpwrvgnd_1
XFILLER_195_393 VPWR VGND VPWR VGND sky130_ef_sc_hd__decap_12
XFILLER_104_1370 VPWR VGND VPWR VGND sky130_ef_sc_hd__decap_12
XFILLER_87_1310 VPWR VGND VPWR VGND sky130_ef_sc_hd__decap_12
XFILLER_7_757 VPWR VGND VPWR VGND sky130_ef_sc_hd__decap_12
XFILLER_196_1037 VPWR VGND VPWR VGND sky130_ef_sc_hd__decap_12
XFILLER_13_1286 VPWR VGND VPWR VGND sky130_ef_sc_hd__decap_12
XFILLER_139_1422 VPWR VGND VPWR VGND sky130_ef_sc_hd__decap_12
XFILLER_87_1354 VPWR VGND VPWR VGND sky130_ef_sc_hd__decap_12
XFILLER_6_289 VPWR VGND VPWR VGND sky130_ef_sc_hd__decap_12
XFILLER_40_83 VGND VGND VPWR VPWR sky130_fd_sc_hd__fill_1
XFILLER_156_83 VGND VGND VPWR VPWR sky130_fd_sc_hd__fill_1
XFILLER_139_1466 VPWR VGND VPWR VGND sky130_ef_sc_hd__decap_12
XFILLER_87_1398 VPWR VGND VPWR VGND sky130_ef_sc_hd__decap_12
XPHY_EDGE_ROW_63_2_Right_120 VGND VGND VPWR VPWR sky130_fd_sc_hd__decap_3
XFILLER_48_1338 VPWR VGND VPWR VGND sky130_ef_sc_hd__decap_12
XFILLER_215_1343 VGND VGND VPWR VPWR sky130_fd_sc_hd__fill_1
XFILLER_27_7 VGND VGND VPWR VPWR sky130_fd_sc_hd__decap_8
XFILLER_37_105 VGND VGND VPWR VPWR sky130_fd_sc_hd__decap_6
XFILLER_207_921 VPWR VGND VPWR VGND sky130_ef_sc_hd__decap_12
XFILLER_168_1117 VPWR VGND VPWR VGND sky130_ef_sc_hd__decap_12
XTAP_TAPCELL_ROW_160_2_4017 VGND VPWR sky130_fd_sc_hd__tapvpwrvgnd_1
XTAP_TAPCELL_ROW_145_2_3922 VGND VPWR sky130_fd_sc_hd__tapvpwrvgnd_1
XFILLER_111_1330 VPWR VGND VPWR VGND sky130_ef_sc_hd__decap_12
XFILLER_4_1421 VGND VGND VPWR VPWR sky130_fd_sc_hd__decap_6
XFILLER_1_55 VGND VGND VPWR VPWR sky130_fd_sc_hd__fill_1
XFILLER_24_1382 VPWR VGND VPWR VGND sky130_ef_sc_hd__decap_12
XFILLER_219_781 VGND VGND VPWR VPWR sky130_fd_sc_hd__decap_3
XFILLER_98_1450 VPWR VGND VPWR VGND sky130_ef_sc_hd__decap_12
XFILLER_4_1465 VPWR VGND VPWR VGND sky130_ef_sc_hd__decap_12
XFILLER_20_1246 VPWR VGND VPWR VGND sky130_ef_sc_hd__decap_12
XFILLER_207_965 VPWR VGND VPWR VGND sky130_ef_sc_hd__decap_12
XFILLER_98_1494 VPWR VGND VPWR VGND sky130_ef_sc_hd__decap_12
XFILLER_94_1314 VPWR VGND VPWR VGND sky130_ef_sc_hd__decap_12
XFILLER_0_1329 VPWR VGND VPWR VGND sky130_ef_sc_hd__decap_12
XFILLER_59_1434 VGND VGND VPWR VPWR sky130_fd_sc_hd__decap_6
XFILLER_206_475 VGND VGND VPWR VPWR sky130_fd_sc_hd__fill_1
XFILLER_179_839 VGND VGND VPWR VPWR sky130_fd_sc_hd__fill_1
XFILLER_146_1426 VPWR VGND VPWR VGND sky130_ef_sc_hd__decap_12
XFILLER_94_1358 VPWR VGND VPWR VGND sky130_ef_sc_hd__decap_12
XFILLER_59_1478 VPWR VGND VPWR VGND sky130_ef_sc_hd__decap_12
XFILLER_209_1169 VGND VGND VPWR VPWR sky130_fd_sc_hd__decap_6
XPHY_EDGE_ROW_54_1_Left_273 VGND VGND VPWR VPWR sky130_fd_sc_hd__decap_3
XFILLER_202_681 VPWR VGND VPWR VGND sky130_ef_sc_hd__decap_12
XTAP_TAPCELL_ROW_177_1785 VGND VPWR sky130_fd_sc_hd__tapvpwrvgnd_1
XTAP_TAPCELL_ROW_177_1774 VGND VPWR sky130_fd_sc_hd__tapvpwrvgnd_1
XANTENNA__391__A1 b_addr\[0\] VGND VGND VPWR VPWR sky130_fd_sc_hd__diode_2
XFILLER_179_1213 VPWR VGND VPWR VGND sky130_ef_sc_hd__decap_12
XTAP_TAPCELL_ROW_177_1796 VGND VPWR sky130_fd_sc_hd__tapvpwrvgnd_1
XFILLER_174_533 VPWR VGND VPWR VGND sky130_ef_sc_hd__decap_12
XFILLER_31_1342 VPWR VGND VPWR VGND sky130_ef_sc_hd__decap_12
XFILLER_179_1257 VPWR VGND VPWR VGND sky130_ef_sc_hd__decap_12
XFILLER_122_1470 VPWR VGND VPWR VGND sky130_ef_sc_hd__decap_12
XFILLER_157_1522 VPWR VGND VPWR VGND sky130_ef_sc_hd__decap_12
XFILLER_31_1386 VPWR VGND VPWR VGND sky130_ef_sc_hd__decap_12
XFILLER_157_1566 VPWR VGND VPWR VGND sky130_ef_sc_hd__decap_12
XFILLER_118_1506 VPWR VGND VPWR VGND sky130_ef_sc_hd__decap_12
XFILLER_114_121 VGND VGND VPWR VPWR sky130_fd_sc_hd__decap_6
XFILLER_66_1438 VPWR VGND VPWR VGND sky130_ef_sc_hd__decap_12
XFILLER_216_1129 VPWR VGND VPWR VGND sky130_ef_sc_hd__decap_12
XFILLER_216_53 VPWR VGND VPWR VGND sky130_ef_sc_hd__decap_12
XFILLER_9_1310 VPWR VGND VPWR VGND sky130_ef_sc_hd__decap_12
XFILLER_216_97 VPWR VGND VPWR VGND sky130_ef_sc_hd__decap_12
XFILLER_9_1354 VPWR VGND VPWR VGND sky130_ef_sc_hd__decap_12
XTAP_TAPCELL_ROW_54_2_3326 VGND VPWR sky130_fd_sc_hd__tapvpwrvgnd_1
XFILLER_9_1398 VPWR VGND VPWR VGND sky130_ef_sc_hd__decap_12
XFILLER_217_729 VPWR VGND VPWR VGND sky130_ef_sc_hd__decap_12
XFILLER_186_1217 VPWR VGND VPWR VGND sky130_ef_sc_hd__decap_12
XPHY_EDGE_ROW_21_1_Right_607 VGND VGND VPWR VPWR sky130_fd_sc_hd__decap_3
XTAP_TAPCELL_ROW_34_2_3202 VGND VPWR sky130_fd_sc_hd__tapvpwrvgnd_1
XFILLER_42_1482 VPWR VGND VPWR VGND sky130_ef_sc_hd__decap_12
XFILLER_129_1602 VGND VGND VPWR VPWR sky130_fd_sc_hd__decap_3
XFILLER_77_1534 VPWR VGND VPWR VGND sky130_ef_sc_hd__decap_12
XFILLER_45_39 VPWR VGND VPWR VGND sky130_ef_sc_hd__decap_12
XFILLER_212_401 VPWR VGND VPWR VGND sky130_ef_sc_hd__decap_12
XFILLER_169_305 VPWR VGND VPWR VGND sky130_ef_sc_hd__decap_12
XFILLER_77_1578 VPWR VGND VPWR VGND sky130_ef_sc_hd__decap_12
XFILLER_38_1518 VGND VGND VPWR VPWR sky130_fd_sc_hd__decap_6
XFILLER_212_445 VPWR VGND VPWR VGND sky130_ef_sc_hd__decap_12
XFILLER_169_349 VPWR VGND VPWR VGND sky130_ef_sc_hd__decap_12
XFILLER_36_1220 VPWR VGND VPWR VGND sky130_ef_sc_hd__decap_12
XFILLER_212_489 VPWR VGND VPWR VGND sky130_ef_sc_hd__decap_12
XFILLER_185_809 VPWR VGND VPWR VGND sky130_ef_sc_hd__decap_12
XFILLER_178_861 VGND VGND VPWR VPWR sky130_fd_sc_hd__decap_6
XFILLER_61_27 VPWR VGND VPWR VGND sky130_ef_sc_hd__decap_12
XFILLER_205_1567 VGND VGND VPWR VPWR sky130_fd_sc_hd__fill_1
XFILLER_177_27 VPWR VGND VPWR VGND sky130_ef_sc_hd__decap_12
XFILLER_162_1294 VGND VGND VPWR VPWR sky130_fd_sc_hd__decap_6
XFILLER_197_1313 VPWR VGND VPWR VGND sky130_ef_sc_hd__decap_12
XFILLER_193_853 VPWR VGND VPWR VGND sky130_ef_sc_hd__decap_12
XFILLER_177_393 VPWR VGND VPWR VGND sky130_ef_sc_hd__decap_12
XFILLER_123_1256 VPWR VGND VPWR VGND sky130_ef_sc_hd__decap_12
XFILLER_197_1357 VPWR VGND VPWR VGND sky130_ef_sc_hd__decap_12
XFILLER_193_897 VPWR VGND VPWR VGND sky130_ef_sc_hd__decap_12
XFILLER_192_363 VGND VGND VPWR VPWR sky130_fd_sc_hd__fill_1
XFILLER_101_1510 VPWR VGND VPWR VGND sky130_ef_sc_hd__decap_12
XFILLER_10_1426 VPWR VGND VPWR VGND sky130_ef_sc_hd__decap_12
XFILLER_14_1562 VPWR VGND VPWR VGND sky130_ef_sc_hd__decap_12
XTAP_TAPCELL_ROW_210_2723 VGND VPWR sky130_fd_sc_hd__tapvpwrvgnd_1
XTAP_TAPCELL_ROW_210_2712 VGND VPWR sky130_fd_sc_hd__tapvpwrvgnd_1
XFILLER_193_15 VPWR VGND VPWR VGND sky130_ef_sc_hd__decap_12
XFILLER_180_525 VGND VGND VPWR VPWR sky130_fd_sc_hd__decap_6
XFILLER_101_1554 VPWR VGND VPWR VGND sky130_ef_sc_hd__decap_12
XFILLER_4_727 VGND VGND VPWR VPWR sky130_fd_sc_hd__fill_2
XTAP_TAPCELL_ROW_44_1_1105 VGND VPWR sky130_fd_sc_hd__tapvpwrvgnd_1
XTAP_TAPCELL_ROW_210_2734 VGND VPWR sky130_fd_sc_hd__tapvpwrvgnd_1
XFILLER_180_569 VPWR VGND VPWR VGND sky130_ef_sc_hd__decap_12
XFILLER_84_1538 VPWR VGND VPWR VGND sky130_ef_sc_hd__decap_12
XFILLER_3_237 VPWR VGND VPWR VGND sky130_ef_sc_hd__decap_12
XFILLER_126_53 VPWR VGND VPWR VGND sky130_ef_sc_hd__decap_12
XTAP_TAPCELL_ROW_187_2081 VGND VPWR sky130_fd_sc_hd__tapvpwrvgnd_1
XTAP_TAPCELL_ROW_187_2070 VGND VPWR sky130_fd_sc_hd__tapvpwrvgnd_1
XFILLER_126_97 VPWR VGND VPWR VGND sky130_ef_sc_hd__decap_12
XTAP_TAPCELL_ROW_131_2_3830 VGND VPWR sky130_fd_sc_hd__tapvpwrvgnd_1
XPHY_EDGE_ROW_8_2_Right_65 VGND VGND VPWR VPWR sky130_fd_sc_hd__decap_3
XFILLER_43_1235 VPWR VGND VPWR VGND sky130_ef_sc_hd__decap_12
XTAP_TAPCELL_ROW_208_2674 VGND VPWR sky130_fd_sc_hd__tapvpwrvgnd_1
XTAP_TAPCELL_ROW_208_2663 VGND VPWR sky130_fd_sc_hd__tapvpwrvgnd_1
XFILLER_142_41 VPWR VGND VPWR VGND sky130_ef_sc_hd__decap_12
XPHY_EDGE_ROW_102_2_Right_159 VGND VGND VPWR VPWR sky130_fd_sc_hd__decap_3
XFILLER_19_51 VGND VGND VPWR VPWR sky130_fd_sc_hd__decap_4
XFILLER_21_1522 VPWR VGND VPWR VGND sky130_ef_sc_hd__decap_12
XFILLER_207_217 VGND VGND VPWR VPWR sky130_fd_sc_hd__decap_6
XTAP_TAPCELL_ROW_204_2549 VGND VPWR sky130_fd_sc_hd__tapvpwrvgnd_1
XFILLER_169_1437 VPWR VGND VPWR VGND sky130_ef_sc_hd__decap_12
XFILLER_142_85 VPWR VGND VPWR VGND sky130_ef_sc_hd__decap_12
XTAP_TAPCELL_ROW_98_2_3613 VGND VPWR sky130_fd_sc_hd__tapvpwrvgnd_1
XFILLER_60_1582 VPWR VGND VPWR VGND sky130_ef_sc_hd__decap_12
XFILLER_210_1273 VPWR VGND VPWR VGND sky130_ef_sc_hd__decap_12
XFILLER_21_1566 VPWR VGND VPWR VGND sky130_ef_sc_hd__decap_12
XFILLER_215_261 VPWR VGND VPWR VGND sky130_ef_sc_hd__decap_12
XTAP_TAPCELL_ROW_196_2339 VGND VPWR sky130_fd_sc_hd__tapvpwrvgnd_1
XTAP_TAPCELL_ROW_196_2328 VGND VPWR sky130_fd_sc_hd__tapvpwrvgnd_1
XTAP_TAPCELL_ROW_196_2317 VGND VPWR sky130_fd_sc_hd__tapvpwrvgnd_1
XFILLER_206_1309 VGND VGND VPWR VPWR sky130_fd_sc_hd__decap_6
XFILLER_204_979 VGND VGND VPWR VPWR sky130_fd_sc_hd__fill_1
XFILLER_188_625 VPWR VGND VPWR VGND sky130_ef_sc_hd__decap_12
XFILLER_187_113 VPWR VGND VPWR VGND sky130_ef_sc_hd__decap_12
XFILLER_19_1440 VGND VGND VPWR VPWR sky130_fd_sc_hd__fill_1
XFILLER_188_669 VPWR VGND VPWR VGND sky130_ef_sc_hd__decap_12
XFILLER_141_1378 VGND VGND VPWR VPWR sky130_fd_sc_hd__decap_6
XFILLER_171_503 VGND VGND VPWR VPWR sky130_fd_sc_hd__fill_1
XTAP_TAPCELL_ROW_60_2_3369 VGND VPWR sky130_fd_sc_hd__tapvpwrvgnd_1
XFILLER_183_385 VGND VGND VPWR VPWR sky130_fd_sc_hd__decap_6
XFILLER_167_93 VPWR VGND VPWR VGND sky130_ef_sc_hd__decap_12
XFILLER_217_1449 VGND VGND VPWR VPWR sky130_fd_sc_hd__decap_6
XFILLER_139_1274 VPWR VGND VPWR VGND sky130_ef_sc_hd__decap_12
XPHY_EDGE_ROW_64_2_Right_121 VGND VGND VPWR VPWR sky130_fd_sc_hd__decap_3
XFILLER_3_782 VGND VGND VPWR VPWR sky130_fd_sc_hd__fill_2
XFILLER_183_81 VPWR VGND VPWR VGND sky130_ef_sc_hd__decap_12
XFILLER_170_1029 VGND VGND VPWR VPWR sky130_fd_sc_hd__decap_6
XFILLER_111_113 VPWR VGND VPWR VGND sky130_ef_sc_hd__decap_12
XANTENNA__571__CLK clknet_3_2_0_clk VGND VGND VPWR VPWR sky130_fd_sc_hd__diode_2
XFILLER_2_281 VPWR VGND VPWR VGND sky130_ef_sc_hd__decap_12
XTAP_TAPCELL_ROW_181_1907 VGND VPWR sky130_fd_sc_hd__tapvpwrvgnd_1
XTAP_TAPCELL_ROW_166_1475 VGND VPWR sky130_fd_sc_hd__tapvpwrvgnd_1
XTAP_TAPCELL_ROW_166_1464 VGND VPWR sky130_fd_sc_hd__tapvpwrvgnd_1
XFILLER_18_3 VPWR VGND VPWR VGND sky130_ef_sc_hd__decap_12
XTAP_TAPCELL_ROW_20_2_3110 VGND VPWR sky130_fd_sc_hd__tapvpwrvgnd_1
XTAP_TAPCELL_ROW_19_2_3104 VGND VPWR sky130_fd_sc_hd__tapvpwrvgnd_1
XFILLER_187_1537 VPWR VGND VPWR VGND sky130_ef_sc_hd__decap_12
XFILLER_4_1273 VPWR VGND VPWR VGND sky130_ef_sc_hd__decap_12
XFILLER_59_1220 VPWR VGND VPWR VGND sky130_ef_sc_hd__decap_12
XFILLER_202_77 VGND VGND VPWR VPWR sky130_fd_sc_hd__decap_6
XFILLER_210_905 VPWR VGND VPWR VGND sky130_ef_sc_hd__decap_12
XTAP_TAPCELL_ROW_179_1847 VGND VPWR sky130_fd_sc_hd__tapvpwrvgnd_1
XTAP_TAPCELL_ROW_179_1836 VGND VPWR sky130_fd_sc_hd__tapvpwrvgnd_1
XTAP_TAPCELL_ROW_37_1_1092 VGND VPWR sky130_fd_sc_hd__tapvpwrvgnd_1
XFILLER_59_1286 VPWR VGND VPWR VGND sky130_ef_sc_hd__decap_12
XFILLER_181_1169 VGND VGND VPWR VPWR sky130_fd_sc_hd__decap_6
XFILLER_167_809 VPWR VGND VPWR VGND sky130_ef_sc_hd__decap_12
XFILLER_210_949 VPWR VGND VPWR VGND sky130_ef_sc_hd__decap_12
XFILLER_193_105 VGND VGND VPWR VPWR sky130_fd_sc_hd__decap_6
XFILLER_163_1581 VPWR VGND VPWR VGND sky130_ef_sc_hd__decap_12
XFILLER_193_149 VPWR VGND VPWR VGND sky130_ef_sc_hd__decap_12
XFILLER_179_1021 VPWR VGND VPWR VGND sky130_ef_sc_hd__decap_12
XFILLER_175_853 VPWR VGND VPWR VGND sky130_ef_sc_hd__decap_12
XFILLER_175_897 VPWR VGND VPWR VGND sky130_ef_sc_hd__decap_12
XFILLER_174_363 VGND VGND VPWR VPWR sky130_fd_sc_hd__fill_1
XTAP_TAPCELL_ROW_125_1_1268 VGND VPWR sky130_fd_sc_hd__tapvpwrvgnd_1
XFILLER_200_1453 VPWR VGND VPWR VGND sky130_ef_sc_hd__decap_12
XFILLER_179_1065 VPWR VGND VPWR VGND sky130_ef_sc_hd__decap_12
XFILLER_200_1497 VPWR VGND VPWR VGND sky130_ef_sc_hd__decap_12
XFILLER_190_867 VGND VGND VPWR VPWR sky130_fd_sc_hd__fill_1
XFILLER_157_1330 VPWR VGND VPWR VGND sky130_ef_sc_hd__decap_12
XFILLER_163_29 VPWR VGND VPWR VGND sky130_ef_sc_hd__decap_12
XFILLER_118_1314 VPWR VGND VPWR VGND sky130_ef_sc_hd__decap_12
XFILLER_66_1246 VPWR VGND VPWR VGND sky130_ef_sc_hd__decap_12
XFILLER_118_1358 VPWR VGND VPWR VGND sky130_ef_sc_hd__decap_12
XFILLER_170_1541 VPWR VGND VPWR VGND sky130_ef_sc_hd__decap_12
XTAP_TAPCELL_ROW_116_2_3732 VGND VPWR sky130_fd_sc_hd__tapvpwrvgnd_1
XTAP_TAPCELL_ROW_84_2_3521 VGND VPWR sky130_fd_sc_hd__tapvpwrvgnd_1
XFILLER_56_27 VGND VGND VPWR VPWR sky130_fd_sc_hd__fill_1
XFILLER_217_559 VGND VGND VPWR VPWR sky130_fd_sc_hd__fill_1
XFILLER_211_1593 VPWR VGND VPWR VGND sky130_ef_sc_hd__decap_12
XPHY_EDGE_ROW_22_1_Right_608 VGND VGND VPWR VPWR sky130_fd_sc_hd__decap_3
XFILLER_213_721 VGND VGND VPWR VPWR sky130_fd_sc_hd__decap_6
XFILLER_204_209 VPWR VGND VPWR VGND sky130_ef_sc_hd__decap_12
XFILLER_198_923 VGND VGND VPWR VPWR sky130_fd_sc_hd__fill_1
XFILLER_129_1410 VPWR VGND VPWR VGND sky130_ef_sc_hd__decap_12
XFILLER_112_77 VGND VGND VPWR VPWR sky130_fd_sc_hd__decap_6
XFILLER_77_1342 VPWR VGND VPWR VGND sky130_ef_sc_hd__decap_12
XFILLER_72_15 VPWR VGND VPWR VGND sky130_ef_sc_hd__decap_12
XTAP_TAPCELL_ROW_0_752 VGND VPWR sky130_fd_sc_hd__tapvpwrvgnd_1
XTAP_TAPCELL_ROW_0_763 VGND VPWR sky130_fd_sc_hd__tapvpwrvgnd_1
XTAP_TAPCELL_ROW_0_774 VGND VPWR sky130_fd_sc_hd__tapvpwrvgnd_1
XFILLER_188_15 VPWR VGND VPWR VGND sky130_ef_sc_hd__decap_12
XFILLER_169_113 VPWR VGND VPWR VGND sky130_ef_sc_hd__decap_12
XFILLER_129_1454 VPWR VGND VPWR VGND sky130_ef_sc_hd__decap_12
XFILLER_77_1386 VPWR VGND VPWR VGND sky130_ef_sc_hd__decap_12
XTAP_TAPCELL_ROW_0_796 VGND VPWR sky130_fd_sc_hd__tapvpwrvgnd_1
XTAP_TAPCELL_ROW_0_785 VGND VPWR sky130_fd_sc_hd__tapvpwrvgnd_1
XFILLER_38_1326 VPWR VGND VPWR VGND sky130_ef_sc_hd__decap_12
XFILLER_213_765 VPWR VGND VPWR VGND sky130_ef_sc_hd__decap_12
XFILLER_212_253 VPWR VGND VPWR VGND sky130_ef_sc_hd__decap_12
XFILLER_129_1498 VPWR VGND VPWR VGND sky130_ef_sc_hd__decap_12
XFILLER_16_1602 VGND VGND VPWR VPWR sky130_fd_sc_hd__decap_3
XTAP_TAPCELL_ROW_216_2910 VGND VPWR sky130_fd_sc_hd__tapvpwrvgnd_1
XFILLER_185_617 VPWR VGND VPWR VGND sky130_ef_sc_hd__decap_12
XFILLER_197_1121 VPWR VGND VPWR VGND sky130_ef_sc_hd__decap_12
XFILLER_122_3 VPWR VGND VPWR VGND sky130_ef_sc_hd__decap_12
XFILLER_14_1370 VPWR VGND VPWR VGND sky130_ef_sc_hd__decap_12
XFILLER_193_1007 VGND VGND VPWR VPWR sky130_fd_sc_hd__fill_1
XFILLER_165_385 VGND VGND VPWR VPWR sky130_fd_sc_hd__decap_6
XTAP_TAPCELL_ROW_189_2132 VGND VPWR sky130_fd_sc_hd__tapvpwrvgnd_1
XTAP_TAPCELL_ROW_189_2121 VGND VPWR sky130_fd_sc_hd__tapvpwrvgnd_1
XFILLER_181_889 VGND VGND VPWR VPWR sky130_fd_sc_hd__decap_6
XFILLER_180_333 VPWR VGND VPWR VGND sky130_ef_sc_hd__decap_12
XFILLER_101_1384 VGND VGND VPWR VPWR sky130_fd_sc_hd__fill_1
XFILLER_88_1482 VPWR VGND VPWR VGND sky130_ef_sc_hd__decap_12
XFILLER_84_1302 VPWR VGND VPWR VGND sky130_ef_sc_hd__decap_12
XFILLER_49_1422 VPWR VGND VPWR VGND sky130_ef_sc_hd__decap_12
XTAP_TAPCELL_ROW_185_2018 VGND VPWR sky130_fd_sc_hd__tapvpwrvgnd_1
XTAP_TAPCELL_ROW_185_2007 VGND VPWR sky130_fd_sc_hd__tapvpwrvgnd_1
XFILLER_180_377 VPWR VGND VPWR VGND sky130_ef_sc_hd__decap_12
XFILLER_136_1414 VPWR VGND VPWR VGND sky130_ef_sc_hd__decap_12
XFILLER_49_1466 VPWR VGND VPWR VGND sky130_ef_sc_hd__decap_12
XANTENNA_input42_A func_wdata[8] VGND VGND VPWR VPWR sky130_fd_sc_hd__diode_2
XFILLER_153_51 VGND VGND VPWR VPWR sky130_fd_sc_hd__decap_4
XFILLER_0_774 VGND VGND VPWR VPWR sky130_fd_sc_hd__decap_3
XPHY_EDGE_ROW_21_2_Left_453 VGND VGND VPWR VPWR sky130_fd_sc_hd__decap_3
XFILLER_169_1201 VPWR VGND VPWR VGND sky130_ef_sc_hd__decap_12
XFILLER_21_1330 VPWR VGND VPWR VGND sky130_ef_sc_hd__decap_12
XFILLER_169_1245 VPWR VGND VPWR VGND sky130_ef_sc_hd__decap_12
XFILLER_1_1413 VPWR VGND VPWR VGND sky130_ef_sc_hd__decap_12
XFILLER_5_1593 VPWR VGND VPWR VGND sky130_ef_sc_hd__decap_12
XFILLER_216_581 VGND VGND VPWR VPWR sky130_fd_sc_hd__decap_6
XFILLER_169_1289 VPWR VGND VPWR VGND sky130_ef_sc_hd__decap_12
XFILLER_147_1510 VPWR VGND VPWR VGND sky130_ef_sc_hd__decap_12
XFILLER_95_1442 VPWR VGND VPWR VGND sky130_ef_sc_hd__decap_12
XFILLER_1_1457 VPWR VGND VPWR VGND sky130_ef_sc_hd__decap_12
XFILLER_189_945 VGND VGND VPWR VPWR sky130_fd_sc_hd__decap_6
XFILLER_147_1554 VPWR VGND VPWR VGND sky130_ef_sc_hd__decap_12
XFILLER_91_1328 VGND VGND VPWR VPWR sky130_fd_sc_hd__fill_1
XFILLER_56_1426 VPWR VGND VPWR VGND sky130_ef_sc_hd__decap_12
XFILLER_206_1117 VPWR VGND VPWR VGND sky130_ef_sc_hd__decap_12
XFILLER_189_989 VPWR VGND VPWR VGND sky130_ef_sc_hd__decap_12
XFILLER_188_433 VPWR VGND VPWR VGND sky130_ef_sc_hd__decap_12
XFILLER_108_1538 VPWR VGND VPWR VGND sky130_ef_sc_hd__decap_12
XFILLER_188_477 VPWR VGND VPWR VGND sky130_ef_sc_hd__decap_12
XFILLER_175_105 VGND VGND VPWR VPWR sky130_fd_sc_hd__decap_6
XTAP_TAPCELL_ROW_174_1700 VGND VPWR sky130_fd_sc_hd__tapvpwrvgnd_1
XTAP_TAPCELL_ROW_142_2_3899 VGND VPWR sky130_fd_sc_hd__tapvpwrvgnd_1
XFILLER_175_149 VPWR VGND VPWR VGND sky130_ef_sc_hd__decap_12
XTAP_TAPCELL_ROW_174_1711 VGND VPWR sky130_fd_sc_hd__tapvpwrvgnd_1
XANTENNA__346__A1 b_addr\[4\] VGND VGND VPWR VPWR sky130_fd_sc_hd__diode_2
XFILLER_200_993 VPWR VGND VPWR VGND sky130_ef_sc_hd__decap_12
XFILLER_191_609 VGND VGND VPWR VPWR sky130_fd_sc_hd__decap_6
XFILLER_7_340 VGND VGND VPWR VPWR sky130_fd_sc_hd__decap_6
XFILLER_176_1205 VPWR VGND VPWR VGND sky130_ef_sc_hd__decap_12
XFILLER_89_1268 VGND VGND VPWR VPWR sky130_fd_sc_hd__decap_4
XFILLER_32_1470 VPWR VGND VPWR VGND sky130_ef_sc_hd__decap_12
XFILLER_183_193 VPWR VGND VPWR VGND sky130_ef_sc_hd__decap_12
XFILLER_172_867 VGND VGND VPWR VPWR sky130_fd_sc_hd__fill_1
XTAP_TAPCELL_ROW_90_2_3564 VGND VPWR sky130_fd_sc_hd__tapvpwrvgnd_1
XFILLER_67_1522 VPWR VGND VPWR VGND sky130_ef_sc_hd__decap_12
XFILLER_217_1213 VPWR VGND VPWR VGND sky130_ef_sc_hd__decap_12
XTAP_TAPCELL_ROW_89_2_3558 VGND VPWR sky130_fd_sc_hd__tapvpwrvgnd_1
XFILLER_67_1566 VPWR VGND VPWR VGND sky130_ef_sc_hd__decap_12
XFILLER_28_1506 VPWR VGND VPWR VGND sky130_ef_sc_hd__decap_12
XPHY_EDGE_ROW_32_2_Right_89 VGND VGND VPWR VPWR sky130_fd_sc_hd__decap_3
XFILLER_217_1257 VPWR VGND VPWR VGND sky130_ef_sc_hd__decap_12
XTAP_TAPCELL_ROW_168_1526 VGND VPWR sky130_fd_sc_hd__tapvpwrvgnd_1
XTAP_TAPCELL_ROW_168_1515 VGND VPWR sky130_fd_sc_hd__tapvpwrvgnd_1
XTAP_TAPCELL_ROW_102_2_3640 VGND VPWR sky130_fd_sc_hd__tapvpwrvgnd_1
XFILLER_97_111 VGND VGND VPWR VPWR sky130_fd_sc_hd__fill_1
XTAP_TAPCELL_ROW_168_1537 VGND VPWR sky130_fd_sc_hd__tapvpwrvgnd_1
XPHY_EDGE_ROW_65_2_Right_122 VGND VGND VPWR VPWR sky130_fd_sc_hd__decap_3
XFILLER_152_1282 VPWR VGND VPWR VGND sky130_ef_sc_hd__decap_12
XFILLER_187_1301 VPWR VGND VPWR VGND sky130_ef_sc_hd__decap_12
XFILLER_113_1244 VPWR VGND VPWR VGND sky130_ef_sc_hd__decap_12
XFILLER_187_1345 VPWR VGND VPWR VGND sky130_ef_sc_hd__decap_12
XFILLER_199_709 VPWR VGND VPWR VGND sky130_ef_sc_hd__decap_12
XFILLER_130_1580 VGND VGND VPWR VPWR sky130_fd_sc_hd__fill_1
XFILLER_39_1602 VGND VGND VPWR VPWR sky130_fd_sc_hd__decap_3
XPHY_EDGE_ROW_174_Right_19 VGND VGND VPWR VPWR sky130_fd_sc_hd__decap_3
XFILLER_74_1526 VPWR VGND VPWR VGND sky130_ef_sc_hd__decap_12
XTAP_TAPCELL_ROW_68_1_1153 VGND VPWR sky130_fd_sc_hd__tapvpwrvgnd_1
XFILLER_210_713 VPWR VGND VPWR VGND sky130_ef_sc_hd__decap_12
XFILLER_167_617 VPWR VGND VPWR VGND sky130_ef_sc_hd__decap_12
XPHY_EDGE_ROW_97_2_Left_529 VGND VGND VPWR VPWR sky130_fd_sc_hd__decap_3
XTAP_TAPCELL_ROW_31_2_3179 VGND VPWR sky130_fd_sc_hd__tapvpwrvgnd_1
XFILLER_42_29 VPWR VGND VPWR VGND sky130_ef_sc_hd__decap_12
XFILLER_210_757 VPWR VGND VPWR VGND sky130_ef_sc_hd__decap_12
XFILLER_158_29 VPWR VGND VPWR VGND sky130_ef_sc_hd__decap_12
XFILLER_72_1294 VGND VGND VPWR VPWR sky130_fd_sc_hd__decap_6
XFILLER_198_1441 VPWR VGND VPWR VGND sky130_ef_sc_hd__decap_12
XFILLER_194_469 VGND VGND VPWR VPWR sky130_fd_sc_hd__decap_6
XPHY_EDGE_ROW_17_1_Left_236 VGND VGND VPWR VPWR sky130_fd_sc_hd__decap_3
XFILLER_33_1256 VPWR VGND VPWR VGND sky130_ef_sc_hd__decap_12
XFILLER_198_1485 VPWR VGND VPWR VGND sky130_ef_sc_hd__decap_12
XTAP_TAPCELL_ROW_156_1_1329 VGND VPWR sky130_fd_sc_hd__tapvpwrvgnd_1
XFILLER_11_1510 VPWR VGND VPWR VGND sky130_ef_sc_hd__decap_12
XFILLER_200_1261 VPWR VGND VPWR VGND sky130_ef_sc_hd__decap_12
XFILLER_11_1554 VPWR VGND VPWR VGND sky130_ef_sc_hd__decap_12
XPHY_EDGE_ROW_183_Right_28 VGND VGND VPWR VPWR sky130_fd_sc_hd__decap_3
XFILLER_1_505 VGND VGND VPWR VPWR sky130_fd_sc_hd__decap_8
XFILLER_192_1073 VPWR VGND VPWR VGND sky130_ef_sc_hd__decap_12
XFILLER_107_55 VGND VGND VPWR VPWR sky130_fd_sc_hd__fill_1
XFILLER_1_527 VGND VGND VPWR VPWR sky130_fd_sc_hd__decap_4
XFILLER_67_15 VPWR VGND VPWR VGND sky130_ef_sc_hd__decap_12
XFILLER_218_813 VPWR VGND VPWR VGND sky130_ef_sc_hd__decap_12
XFILLER_190_27 VGND VGND VPWR VPWR sky130_fd_sc_hd__fill_1
XFILLER_170_1371 VGND VGND VPWR VPWR sky130_fd_sc_hd__fill_1
XFILLER_131_1322 VGND VGND VPWR VPWR sky130_fd_sc_hd__decap_6
XTAP_TAPCELL_ROW_161_2_4022 VGND VPWR sky130_fd_sc_hd__tapvpwrvgnd_1
XPHY_EDGE_ROW_131_1_Left_350 VGND VGND VPWR VPWR sky130_fd_sc_hd__decap_3
XFILLER_131_1366 VPWR VGND VPWR VGND sky130_ef_sc_hd__decap_12
X_550_ net50 u_ctrl.cmp_addr\[1\] net122 VGND VGND VPWR VPWR _249_ sky130_fd_sc_hd__mux2_1
XFILLER_205_529 VPWR VGND VPWR VGND sky130_ef_sc_hd__decap_12
XPHY_EDGE_ROW_192_Right_37 VGND VGND VPWR VPWR sky130_fd_sc_hd__decap_3
XFILLER_166_1429 VPWR VGND VPWR VGND sky130_ef_sc_hd__decap_12
XFILLER_83_69 VPWR VGND VPWR VGND sky130_ef_sc_hd__decap_12
XFILLER_199_69 VPWR VGND VPWR VGND sky130_ef_sc_hd__decap_12
X_481_ net130 VGND VGND VPWR VPWR _213_ sky130_fd_sc_hd__inv_2
XPHY_EDGE_ROW_23_1_Right_609 VGND VGND VPWR VPWR sky130_fd_sc_hd__decap_3
XFILLER_213_573 VPWR VGND VPWR VGND sky130_ef_sc_hd__decap_12
XFILLER_207_1437 VPWR VGND VPWR VGND sky130_ef_sc_hd__decap_12
XFILLER_16_85 VGND VGND VPWR VPWR sky130_fd_sc_hd__decap_8
XFILLER_186_937 VPWR VGND VPWR VGND sky130_ef_sc_hd__decap_12
XFILLER_164_1197 VGND VGND VPWR VPWR sky130_fd_sc_hd__decap_6
XFILLER_157_105 VGND VGND VPWR VPWR sky130_fd_sc_hd__decap_6
XFILLER_90_1350 VGND VGND VPWR VPWR sky130_fd_sc_hd__decap_6
XFILLER_200_245 VGND VGND VPWR VPWR sky130_fd_sc_hd__decap_6
XFILLER_185_447 VGND VGND VPWR VPWR sky130_fd_sc_hd__fill_1
XFILLER_8_104 VGND VGND VPWR VPWR sky130_fd_sc_hd__fill_2
XFILLER_200_289 VPWR VGND VPWR VGND sky130_ef_sc_hd__decap_12
XFILLER_173_609 VGND VGND VPWR VPWR sky130_fd_sc_hd__decap_6
XFILLER_142_1462 VGND VGND VPWR VPWR sky130_fd_sc_hd__decap_6
XFILLER_90_1394 VPWR VGND VPWR VGND sky130_ef_sc_hd__decap_12
XFILLER_194_981 VPWR VGND VPWR VGND sky130_ef_sc_hd__decap_12
XFILLER_177_1525 VPWR VGND VPWR VGND sky130_ef_sc_hd__decap_12
XFILLER_51_1378 VGND VGND VPWR VPWR sky130_fd_sc_hd__decap_6
XFILLER_181_653 VPWR VGND VPWR VGND sky130_ef_sc_hd__decap_12
XFILLER_180_141 VPWR VGND VPWR VGND sky130_ef_sc_hd__decap_12
XFILLER_177_1569 VPWR VGND VPWR VGND sky130_ef_sc_hd__decap_12
XFILLER_165_193 VPWR VGND VPWR VGND sky130_ef_sc_hd__decap_12
XTAP_TAPCELL_ROW_75_2_3466 VGND VPWR sky130_fd_sc_hd__tapvpwrvgnd_1
XFILLER_218_1533 VGND VGND VPWR VPWR sky130_fd_sc_hd__decap_6
XFILLER_181_697 VPWR VGND VPWR VGND sky130_ef_sc_hd__decap_12
XFILLER_4_365 VPWR VGND VPWR VGND sky130_ef_sc_hd__decap_12
XFILLER_218_1577 VPWR VGND VPWR VGND sky130_ef_sc_hd__decap_12
XFILLER_171_1113 VGND VGND VPWR VPWR sky130_fd_sc_hd__decap_6
XFILLER_79_111 VGND VGND VPWR VPWR sky130_fd_sc_hd__fill_1
XFILLER_49_1274 VPWR VGND VPWR VGND sky130_ef_sc_hd__decap_12
XFILLER_171_1157 VPWR VGND VPWR VGND sky130_ef_sc_hd__decap_12
XFILLER_164_83 VGND VGND VPWR VPWR sky130_fd_sc_hd__fill_1
XFILLER_136_1244 VGND VGND VPWR VPWR sky130_fd_sc_hd__fill_1
XPHY_EDGE_ROW_63_1_Left_282 VGND VGND VPWR VPWR sky130_fd_sc_hd__decap_3
XFILLER_0_571 VGND VGND VPWR VPWR sky130_fd_sc_hd__fill_1
XFILLER_208_301 VGND VGND VPWR VPWR sky130_fd_sc_hd__decap_6
XFILLER_110_1406 VGND VGND VPWR VPWR sky130_fd_sc_hd__decap_6
XFILLER_208_345 VPWR VGND VPWR VGND sky130_ef_sc_hd__decap_12
XFILLER_57_81 VPWR VGND VPWR VGND sky130_ef_sc_hd__decap_12
XFILLER_208_389 VPWR VGND VPWR VGND sky130_ef_sc_hd__decap_12
XFILLER_189_753 VPWR VGND VPWR VGND sky130_ef_sc_hd__decap_12
XFILLER_182_1253 VGND VGND VPWR VPWR sky130_fd_sc_hd__decap_6
XFILLER_108_1302 VPWR VGND VPWR VGND sky130_ef_sc_hd__decap_12
XFILLER_95_1272 VGND VGND VPWR VPWR sky130_fd_sc_hd__fill_1
XFILLER_1_1287 VGND VGND VPWR VPWR sky130_fd_sc_hd__fill_1
XANTENNA__567__A1 net147 VGND VGND VPWR VPWR sky130_fd_sc_hd__diode_2
XFILLER_189_797 VPWR VGND VPWR VGND sky130_ef_sc_hd__decap_12
XFILLER_147_1384 VGND VGND VPWR VPWR sky130_fd_sc_hd__fill_1
XFILLER_182_1297 VPWR VGND VPWR VGND sky130_ef_sc_hd__decap_12
XFILLER_85_3 VPWR VGND VPWR VGND sky130_ef_sc_hd__decap_12
XFILLER_191_417 VPWR VGND VPWR VGND sky130_ef_sc_hd__decap_12
XFILLER_176_469 VGND VGND VPWR VPWR sky130_fd_sc_hd__decap_6
XFILLER_160_1562 VPWR VGND VPWR VGND sky130_ef_sc_hd__decap_12
XFILLER_121_1546 VGND VGND VPWR VPWR sky130_fd_sc_hd__decap_6
XFILLER_201_1581 VPWR VGND VPWR VGND sky130_ef_sc_hd__decap_12
XFILLER_176_1035 VGND VGND VPWR VPWR sky130_fd_sc_hd__fill_1
XFILLER_208_65 VPWR VGND VPWR VGND sky130_ef_sc_hd__decap_12
XFILLER_67_1330 VPWR VGND VPWR VGND sky130_ef_sc_hd__decap_12
XFILLER_217_1021 VPWR VGND VPWR VGND sky130_ef_sc_hd__decap_12
XFILLER_154_1300 VGND VGND VPWR VPWR sky130_fd_sc_hd__fill_1
XFILLER_119_1442 VPWR VGND VPWR VGND sky130_ef_sc_hd__decap_12
XFILLER_28_1314 VPWR VGND VPWR VGND sky130_ef_sc_hd__decap_12
XFILLER_217_1065 VPWR VGND VPWR VGND sky130_ef_sc_hd__decap_12
XFILLER_193_1393 VGND VGND VPWR VPWR sky130_fd_sc_hd__decap_6
XFILLER_28_1358 VPWR VGND VPWR VGND sky130_ef_sc_hd__decap_12
XFILLER_218_109 VPWR VGND VPWR VGND sky130_ef_sc_hd__decap_12
XFILLER_115_1328 VGND VGND VPWR VPWR sky130_fd_sc_hd__fill_1
XFILLER_85_125 VGND VGND VPWR VPWR sky130_fd_sc_hd__fill_2
XPHY_EDGE_ROW_66_2_Right_123 VGND VGND VPWR VPWR sky130_fd_sc_hd__decap_3
XFILLER_80_1574 VGND VGND VPWR VPWR sky130_fd_sc_hd__decap_6
XTAP_TAPCELL_ROW_2_858 VGND VPWR sky130_fd_sc_hd__tapvpwrvgnd_1
XFILLER_2_1029 VGND VGND VPWR VPWR sky130_fd_sc_hd__decap_6
XTAP_TAPCELL_ROW_2_847 VGND VPWR sky130_fd_sc_hd__tapvpwrvgnd_1
XTAP_TAPCELL_ROW_2_836 VGND VPWR sky130_fd_sc_hd__tapvpwrvgnd_1
XFILLER_199_517 VPWR VGND VPWR VGND sky130_ef_sc_hd__decap_12
XPHY_EDGE_ROW_150_1_Right_736 VGND VGND VPWR VPWR sky130_fd_sc_hd__decap_3
XFILLER_187_1175 VGND VGND VPWR VPWR sky130_fd_sc_hd__fill_1
XFILLER_78_1470 VPWR VGND VPWR VGND sky130_ef_sc_hd__decap_12
XFILLER_39_1410 VPWR VGND VPWR VGND sky130_ef_sc_hd__decap_12
XFILLER_39_1454 VPWR VGND VPWR VGND sky130_ef_sc_hd__decap_12
XFILLER_53_39 VPWR VGND VPWR VGND sky130_ef_sc_hd__decap_12
XFILLER_168_937 VPWR VGND VPWR VGND sky130_ef_sc_hd__decap_12
XFILLER_169_39 VPWR VGND VPWR VGND sky130_ef_sc_hd__decap_12
XFILLER_139_105 VGND VGND VPWR VPWR sky130_fd_sc_hd__decap_6
XFILLER_74_1356 VGND VGND VPWR VPWR sky130_fd_sc_hd__fill_1
XFILLER_39_1498 VPWR VGND VPWR VGND sky130_ef_sc_hd__decap_12
XFILLER_194_233 VPWR VGND VPWR VGND sky130_ef_sc_hd__decap_12
XFILLER_167_447 VGND VGND VPWR VPWR sky130_fd_sc_hd__fill_1
XFILLER_126_1468 VGND VGND VPWR VPWR sky130_fd_sc_hd__fill_1
XFILLER_210_587 VGND VGND VPWR VPWR sky130_fd_sc_hd__fill_1
XFILLER_194_277 VPWR VGND VPWR VGND sky130_ef_sc_hd__decap_12
XFILLER_185_27 VPWR VGND VPWR VGND sky130_ef_sc_hd__decap_12
XFILLER_176_981 VPWR VGND VPWR VGND sky130_ef_sc_hd__decap_12
XFILLER_6_619 VPWR VGND VPWR VGND sky130_ef_sc_hd__decap_12
XTAP_TAPCELL_ROW_61_2_3374 VGND VPWR sky130_fd_sc_hd__tapvpwrvgnd_1
XFILLER_191_951 VGND VGND VPWR VPWR sky130_fd_sc_hd__fill_1
XFILLER_159_1244 VPWR VGND VPWR VGND sky130_ef_sc_hd__decap_12
XFILLER_200_1091 VGND VGND VPWR VPWR sky130_fd_sc_hd__fill_1
XFILLER_163_697 VGND VGND VPWR VPWR sky130_fd_sc_hd__decap_3
XFILLER_118_65 VPWR VGND VPWR VGND sky130_ef_sc_hd__decap_12
XFILLER_11_1384 VGND VGND VPWR VPWR sky130_fd_sc_hd__fill_1
XFILLER_46_1414 VPWR VGND VPWR VGND sky130_ef_sc_hd__decap_12
XFILLER_85_1496 VGND VGND VPWR VPWR sky130_fd_sc_hd__fill_1
XFILLER_172_1477 VGND VGND VPWR VPWR sky130_fd_sc_hd__decap_6
XFILLER_134_53 VPWR VGND VPWR VGND sky130_ef_sc_hd__decap_12
XFILLER_218_643 VGND VGND VPWR VPWR sky130_fd_sc_hd__fill_1
XFILLER_206_805 VGND VGND VPWR VPWR sky130_fd_sc_hd__decap_6
XFILLER_134_97 VPWR VGND VPWR VGND sky130_ef_sc_hd__decap_12
X_602_ clknet_3_7_0_clk _036_ VGND VGND VPWR VPWR net58 sky130_fd_sc_hd__dfxtp_1
XFILLER_79_1256 VPWR VGND VPWR VGND sky130_ef_sc_hd__decap_12
XFILLER_2_1541 VPWR VGND VPWR VGND sky130_ef_sc_hd__decap_12
XFILLER_206_849 VPWR VGND VPWR VGND sky130_ef_sc_hd__decap_12
XFILLER_205_337 VPWR VGND VPWR VGND sky130_ef_sc_hd__decap_12
XFILLER_150_41 VPWR VGND VPWR VGND sky130_ef_sc_hd__decap_12
X_533_ net150 _171_ net128 net137 _240_ VGND VGND VPWR VPWR _050_ sky130_fd_sc_hd__o311a_1
XFILLER_27_73 VPWR VGND VPWR VGND sky130_ef_sc_hd__decap_12
XFILLER_57_1510 VPWR VGND VPWR VGND sky130_ef_sc_hd__decap_12
XFILLER_207_1201 VPWR VGND VPWR VGND sky130_ef_sc_hd__decap_12
XFILLER_166_1259 VGND VGND VPWR VPWR sky130_fd_sc_hd__fill_1
XFILLER_150_85 VPWR VGND VPWR VGND sky130_ef_sc_hd__decap_12
XFILLER_92_1412 VGND VGND VPWR VPWR sky130_fd_sc_hd__fill_1
X_464_ net148 net108 VGND VGND VPWR VPWR _196_ sky130_fd_sc_hd__xor2_1
XTAP_TAPCELL_ROW_51_1_1120 VGND VPWR sky130_fd_sc_hd__tapvpwrvgnd_1
XFILLER_57_1554 VPWR VGND VPWR VGND sky130_ef_sc_hd__decap_12
XFILLER_214_893 VPWR VGND VPWR VGND sky130_ef_sc_hd__decap_12
XFILLER_207_1245 VPWR VGND VPWR VGND sky130_ef_sc_hd__decap_12
XFILLER_186_701 VPWR VGND VPWR VGND sky130_ef_sc_hd__decap_12
XFILLER_144_1524 VGND VGND VPWR VPWR sky130_fd_sc_hd__fill_1
XFILLER_18_1538 VPWR VGND VPWR VGND sky130_ef_sc_hd__decap_12
XFILLER_207_1289 VPWR VGND VPWR VGND sky130_ef_sc_hd__decap_12
X_395_ _131_ _132_ net156 VGND VGND VPWR VPWR _020_ sky130_fd_sc_hd__o21a_1
XTAP_TAPCELL_ROW_157_2_3996 VGND VPWR sky130_fd_sc_hd__tapvpwrvgnd_1
XFILLER_199_1057 VGND VGND VPWR VPWR sky130_fd_sc_hd__decap_6
XFILLER_173_417 VPWR VGND VPWR VGND sky130_ef_sc_hd__decap_12
XFILLER_142_1270 VPWR VGND VPWR VGND sky130_ef_sc_hd__decap_12
XFILLER_103_1232 VPWR VGND VPWR VGND sky130_ef_sc_hd__decap_12
XFILLER_182_973 VGND VGND VPWR VPWR sky130_fd_sc_hd__decap_6
XFILLER_181_461 VPWR VGND VPWR VGND sky130_ef_sc_hd__decap_12
XFILLER_103_1298 VPWR VGND VPWR VGND sky130_ef_sc_hd__decap_12
XFILLER_218_1341 VPWR VGND VPWR VGND sky130_ef_sc_hd__decap_12
XFILLER_177_1399 VGND VGND VPWR VPWR sky130_fd_sc_hd__fill_1
XFILLER_175_93 VPWR VGND VPWR VGND sky130_ef_sc_hd__decap_12
XFILLER_218_1385 VPWR VGND VPWR VGND sky130_ef_sc_hd__decap_12
XFILLER_214_1205 VPWR VGND VPWR VGND sky130_ef_sc_hd__decap_12
XFILLER_190_1533 VGND VGND VPWR VPWR sky130_fd_sc_hd__decap_6
XFILLER_4_77 VGND VGND VPWR VPWR sky130_fd_sc_hd__decap_6
XFILLER_190_1577 VPWR VGND VPWR VGND sky130_ef_sc_hd__decap_12
XFILLER_191_81 VPWR VGND VPWR VGND sky130_ef_sc_hd__decap_12
XFILLER_67_125 VGND VGND VPWR VPWR sky130_fd_sc_hd__fill_2
XFILLER_7_1441 VPWR VGND VPWR VGND sky130_ef_sc_hd__decap_12
XPHY_EDGE_ROW_163_Right_8 VGND VGND VPWR VPWR sky130_fd_sc_hd__decap_3
XTAP_TAPCELL_ROW_130_2_3826 VGND VPWR sky130_fd_sc_hd__tapvpwrvgnd_1
XFILLER_114_1350 VGND VGND VPWR VPWR sky130_fd_sc_hd__decap_6
XFILLER_7_1485 VPWR VGND VPWR VGND sky130_ef_sc_hd__decap_12
XFILLER_23_1244 VPWR VGND VPWR VGND sky130_ef_sc_hd__decap_12
XFILLER_62_1282 VPWR VGND VPWR VGND sky130_ef_sc_hd__decap_12
XFILLER_209_665 VGND VGND VPWR VPWR sky130_fd_sc_hd__decap_6
XFILLER_208_153 VPWR VGND VPWR VGND sky130_ef_sc_hd__decap_12
XFILLER_114_1394 VPWR VGND VPWR VGND sky130_ef_sc_hd__decap_12
XTAP_TAPCELL_ROW_97_2_3609 VGND VPWR sky130_fd_sc_hd__tapvpwrvgnd_1
XFILLER_208_197 VPWR VGND VPWR VGND sky130_ef_sc_hd__decap_12
XFILLER_184_1315 VGND VGND VPWR VPWR sky130_fd_sc_hd__fill_1
XFILLER_110_1258 VPWR VGND VPWR VGND sky130_ef_sc_hd__decap_12
XFILLER_97_1378 VGND VGND VPWR VPWR sky130_fd_sc_hd__decap_6
XFILLER_40_1580 VGND VGND VPWR VPWR sky130_fd_sc_hd__fill_1
XPHY_EDGE_ROW_109_2_Left_541 VGND VGND VPWR VPWR sky130_fd_sc_hd__decap_3
XTAP_TAPCELL_ROW_85_1_1188 VGND VPWR sky130_fd_sc_hd__tapvpwrvgnd_1
XFILLER_211_329 VGND VGND VPWR VPWR sky130_fd_sc_hd__decap_6
XFILLER_189_561 VPWR VGND VPWR VGND sky130_ef_sc_hd__decap_12
XFILLER_182_1061 VPWR VGND VPWR VGND sky130_ef_sc_hd__decap_12
XFILLER_162_1602 VGND VGND VPWR VPWR sky130_fd_sc_hd__decap_3
XFILLER_210_77 VGND VGND VPWR VPWR sky130_fd_sc_hd__decap_6
XFILLER_176_233 VPWR VGND VPWR VGND sky130_ef_sc_hd__decap_12
XTAP_TAPCELL_ROW_46_2_3276 VGND VPWR sky130_fd_sc_hd__tapvpwrvgnd_1
XFILLER_192_737 VPWR VGND VPWR VGND sky130_ef_sc_hd__decap_12
XFILLER_191_225 VPWR VGND VPWR VGND sky130_ef_sc_hd__decap_12
XFILLER_176_277 VPWR VGND VPWR VGND sky130_ef_sc_hd__decap_12
XFILLER_160_1370 VPWR VGND VPWR VGND sky130_ef_sc_hd__decap_12
XFILLER_125_1490 VGND VGND VPWR VPWR sky130_fd_sc_hd__decap_6
XFILLER_121_1310 VPWR VGND VPWR VGND sky130_ef_sc_hd__decap_12
XFILLER_219_53 VGND VGND VPWR VPWR sky130_fd_sc_hd__decap_3
XFILLER_173_951 VGND VGND VPWR VPWR sky130_fd_sc_hd__fill_1
XFILLER_121_1354 VPWR VGND VPWR VGND sky130_ef_sc_hd__decap_12
XFILLER_219_1105 VPWR VGND VPWR VGND sky130_ef_sc_hd__decap_12
XFILLER_219_97 VPWR VGND VPWR VGND sky130_ef_sc_hd__decap_12
XFILLER_195_1455 VGND VGND VPWR VPWR sky130_fd_sc_hd__fill_1
XFILLER_156_1406 VGND VGND VPWR VPWR sky130_fd_sc_hd__decap_6
XFILLER_121_1398 VPWR VGND VPWR VGND sky130_ef_sc_hd__decap_12
XFILLER_219_1149 VPWR VGND VPWR VGND sky130_ef_sc_hd__decap_12
XFILLER_119_1272 VGND VGND VPWR VPWR sky130_fd_sc_hd__fill_1
XFILLER_41_1322 VGND VGND VPWR VPWR sky130_fd_sc_hd__decap_6
XFILLER_132_1450 VPWR VGND VPWR VGND sky130_ef_sc_hd__decap_12
XFILLER_80_1382 VPWR VGND VPWR VGND sky130_ef_sc_hd__decap_12
XPHY_EDGE_ROW_67_2_Right_124 VGND VGND VPWR VPWR sky130_fd_sc_hd__decap_3
XFILLER_167_1513 VPWR VGND VPWR VGND sky130_ef_sc_hd__decap_12
XFILLER_132_1494 VPWR VGND VPWR VGND sky130_ef_sc_hd__decap_12
XFILLER_64_27 VGND VGND VPWR VPWR sky130_fd_sc_hd__fill_1
XFILLER_41_1366 VPWR VGND VPWR VGND sky130_ef_sc_hd__decap_12
XFILLER_208_1521 VPWR VGND VPWR VGND sky130_ef_sc_hd__decap_12
XFILLER_202_307 VGND VGND VPWR VPWR sky130_fd_sc_hd__fill_1
XPHY_EDGE_ROW_151_1_Right_737 VGND VGND VPWR VPWR sky130_fd_sc_hd__decap_3
XFILLER_214_189 VGND VGND VPWR VPWR sky130_fd_sc_hd__decap_6
XFILLER_168_701 VPWR VGND VPWR VGND sky130_ef_sc_hd__decap_12
XFILLER_211_841 VPWR VGND VPWR VGND sky130_ef_sc_hd__decap_12
XFILLER_208_1565 VPWR VGND VPWR VGND sky130_ef_sc_hd__decap_12
XFILLER_204_1429 VPWR VGND VPWR VGND sky130_ef_sc_hd__decap_12
XFILLER_196_15 VPWR VGND VPWR VGND sky130_ef_sc_hd__decap_12
XFILLER_165_1281 VGND VGND VPWR VPWR sky130_fd_sc_hd__decap_6
XFILLER_126_1232 VPWR VGND VPWR VGND sky130_ef_sc_hd__decap_12
XFILLER_120_77 VGND VGND VPWR VPWR sky130_fd_sc_hd__decap_6
XFILLER_80_15 VPWR VGND VPWR VGND sky130_ef_sc_hd__decap_12
XFILLER_195_553 VGND VGND VPWR VPWR sky130_fd_sc_hd__decap_6
XFILLER_195_597 VPWR VGND VPWR VGND sky130_ef_sc_hd__decap_12
XFILLER_143_1590 VPWR VGND VPWR VGND sky130_ef_sc_hd__decap_12
XPHY_EDGE_ROW_30_2_Left_462 VGND VGND VPWR VPWR sky130_fd_sc_hd__decap_3
XFILLER_52_1462 VGND VGND VPWR VPWR sky130_fd_sc_hd__decap_6
XTAP_TAPCELL_ROW_123_2_3780 VGND VPWR sky130_fd_sc_hd__tapvpwrvgnd_1
XFILLER_104_1574 VGND VGND VPWR VPWR sky130_fd_sc_hd__decap_6
XFILLER_202_1197 VGND VGND VPWR VPWR sky130_fd_sc_hd__decap_6
XFILLER_202_3 VPWR VGND VPWR VGND sky130_ef_sc_hd__decap_12
XFILLER_164_973 VGND VGND VPWR VPWR sky130_fd_sc_hd__decap_6
XFILLER_163_461 VPWR VGND VPWR VGND sky130_ef_sc_hd__decap_12
XFILLER_100_1438 VPWR VGND VPWR VGND sky130_ef_sc_hd__decap_12
XFILLER_89_57 VPWR VGND VPWR VGND sky130_ef_sc_hd__decap_12
XANTENNA_clkbuf_3_0_0_clk_X clknet_3_0_0_clk VGND VGND VPWR VPWR sky130_fd_sc_hd__diode_2
XTAP_TAPCELL_ROW_213_2798 VGND VPWR sky130_fd_sc_hd__tapvpwrvgnd_1
XFILLER_174_1539 VGND VGND VPWR VPWR sky130_fd_sc_hd__fill_1
XFILLER_215_1525 VPWR VGND VPWR VGND sky130_ef_sc_hd__decap_12
XFILLER_172_1241 VPWR VGND VPWR VGND sky130_ef_sc_hd__decap_12
XFILLER_46_1244 VGND VGND VPWR VPWR sky130_fd_sc_hd__fill_1
XFILLER_215_1569 VPWR VGND VPWR VGND sky130_ef_sc_hd__decap_12
XFILLER_172_1285 VPWR VGND VPWR VGND sky130_ef_sc_hd__decap_12
XTAP_TAPCELL_ROW_115_2_3728 VGND VPWR sky130_fd_sc_hd__tapvpwrvgnd_1
XFILLER_1_187 VGND VGND VPWR VPWR sky130_fd_sc_hd__decap_3
XTAP_TAPCELL_ROW_6_950 VGND VPWR sky130_fd_sc_hd__tapvpwrvgnd_1
XTAP_TAPCELL_ROW_6_961 VGND VPWR sky130_fd_sc_hd__tapvpwrvgnd_1
XTAP_TAPCELL_ROW_6_972 VGND VPWR sky130_fd_sc_hd__tapvpwrvgnd_1
XFILLER_49_125 VGND VGND VPWR VPWR sky130_fd_sc_hd__fill_2
XFILLER_150_1550 VPWR VGND VPWR VGND sky130_ef_sc_hd__decap_12
XTAP_TAPCELL_ROW_83_2_3517 VGND VPWR sky130_fd_sc_hd__tapvpwrvgnd_1
XFILLER_206_613 VPWR VGND VPWR VGND sky130_ef_sc_hd__decap_12
XFILLER_161_51 VGND VGND VPWR VPWR sky130_fd_sc_hd__decap_4
XFILLER_150_1594 VGND VGND VPWR VPWR sky130_fd_sc_hd__decap_8
XFILLER_111_1534 VPWR VGND VPWR VGND sky130_ef_sc_hd__decap_12
XFILLER_20_1406 VGND VGND VPWR VPWR sky130_fd_sc_hd__decap_6
XFILLER_38_83 VGND VGND VPWR VPWR sky130_fd_sc_hd__fill_1
XFILLER_111_1578 VPWR VGND VPWR VGND sky130_ef_sc_hd__decap_12
XFILLER_94_1518 VGND VGND VPWR VPWR sky130_fd_sc_hd__decap_6
XFILLER_206_657 VPWR VGND VPWR VGND sky130_ef_sc_hd__decap_12
X_516_ net64 net124 VGND VGND VPWR VPWR _232_ sky130_fd_sc_hd__or2_1
XFILLER_2_1371 VGND VGND VPWR VPWR sky130_fd_sc_hd__fill_1
XFILLER_205_167 VGND VGND VPWR VPWR sky130_fd_sc_hd__fill_1
XFILLER_92_1220 VPWR VGND VPWR VGND sky130_ef_sc_hd__decap_12
XFILLER_18_1302 VPWR VGND VPWR VGND sky130_ef_sc_hd__decap_12
XFILLER_186_531 VGND VGND VPWR VPWR sky130_fd_sc_hd__fill_1
XFILLER_183_1381 VPWR VGND VPWR VGND sky130_ef_sc_hd__decap_12
X_447_ net147 net116 VGND VGND VPWR VPWR _179_ sky130_fd_sc_hd__xor2_1
XTAP_TAPCELL_ROW_32_2_3184 VGND VPWR sky130_fd_sc_hd__tapvpwrvgnd_1
XPHY_EDGE_ROW_41_2_Right_98 VGND VGND VPWR VPWR sky130_fd_sc_hd__decap_3
XFILLER_57_1384 VGND VGND VPWR VPWR sky130_fd_sc_hd__fill_1
XFILLER_109_1496 VGND VGND VPWR VPWR sky130_fd_sc_hd__fill_1
X_378_ b_addr\[0\] _108_ _117_ VGND VGND VPWR VPWR _118_ sky130_fd_sc_hd__a21oi_1
XFILLER_201_373 VPWR VGND VPWR VGND sky130_ef_sc_hd__decap_12
XFILLER_174_737 VPWR VGND VPWR VGND sky130_ef_sc_hd__decap_12
XFILLER_70_1562 VPWR VGND VPWR VGND sky130_ef_sc_hd__decap_12
XFILLER_173_225 VPWR VGND VPWR VGND sky130_ef_sc_hd__decap_12
XFILLER_31_1546 VGND VGND VPWR VPWR sky130_fd_sc_hd__decap_6
XFILLER_6_961 VPWR VGND VPWR VGND sky130_ef_sc_hd__decap_12
XFILLER_182_781 VPWR VGND VPWR VGND sky130_ef_sc_hd__decap_12
XFILLER_141_111 VGND VGND VPWR VPWR sky130_fd_sc_hd__fill_1
XFILLER_64_1300 VGND VGND VPWR VPWR sky130_fd_sc_hd__fill_1
XFILLER_5_493 VGND VGND VPWR VPWR sky130_fd_sc_hd__decap_4
XFILLER_29_1442 VPWR VGND VPWR VGND sky130_ef_sc_hd__decap_12
XFILLER_48_3 VPWR VGND VPWR VGND sky130_ef_sc_hd__decap_12
XFILLER_190_1341 VPWR VGND VPWR VGND sky130_ef_sc_hd__decap_12
XFILLER_116_1412 VGND VGND VPWR VPWR sky130_fd_sc_hd__fill_1
XANTENNA__498__B net125 VGND VGND VPWR VPWR sky130_fd_sc_hd__diode_2
XFILLER_214_1035 VGND VGND VPWR VPWR sky130_fd_sc_hd__fill_1
XFILLER_205_55 VGND VGND VPWR VPWR sky130_fd_sc_hd__fill_1
XFILLER_190_1385 VPWR VGND VPWR VGND sky130_ef_sc_hd__decap_12
XTAP_TAPCELL_ROW_4_909 VGND VPWR sky130_fd_sc_hd__tapvpwrvgnd_1
XFILLER_25_1328 VGND VGND VPWR VPWR sky130_fd_sc_hd__fill_1
XFILLER_3_1113 VGND VGND VPWR VPWR sky130_fd_sc_hd__decap_6
XFILLER_209_473 VPWR VGND VPWR VGND sky130_ef_sc_hd__decap_12
XFILLER_149_1232 VPWR VGND VPWR VGND sky130_ef_sc_hd__decap_12
XFILLER_3_1157 VPWR VGND VPWR VGND sky130_ef_sc_hd__decap_12
XPHY_EDGE_ROW_26_1_Left_245 VGND VGND VPWR VPWR sky130_fd_sc_hd__decap_3
XFILLER_70_109 VPWR VGND VPWR VGND sky130_ef_sc_hd__decap_12
XFILLER_149_1298 VPWR VGND VPWR VGND sky130_ef_sc_hd__decap_12
XFILLER_75_1440 VGND VGND VPWR VPWR sky130_fd_sc_hd__fill_1
XFILLER_211_137 VPWR VGND VPWR VGND sky130_ef_sc_hd__decap_12
XFILLER_127_1552 VGND VGND VPWR VPWR sky130_fd_sc_hd__fill_1
XANTENNA_fanout142_A net144 VGND VGND VPWR VPWR sky130_fd_sc_hd__diode_2
XFILLER_189_391 VGND VGND VPWR VPWR sky130_fd_sc_hd__fill_1
XFILLER_177_553 VGND VGND VPWR VPWR sky130_fd_sc_hd__decap_6
XFILLER_36_1468 VGND VGND VPWR VPWR sky130_fd_sc_hd__fill_1
XFILLER_192_501 VPWR VGND VPWR VGND sky130_ef_sc_hd__decap_12
XFILLER_177_597 VPWR VGND VPWR VGND sky130_ef_sc_hd__decap_12
XTAP_TAPCELL_ROW_108_2_3682 VGND VPWR sky130_fd_sc_hd__tapvpwrvgnd_1
XFILLER_50_29 VPWR VGND VPWR VGND sky130_ef_sc_hd__decap_12
XFILLER_192_545 VPWR VGND VPWR VGND sky130_ef_sc_hd__decap_12
XFILLER_166_29 VPWR VGND VPWR VGND sky130_ef_sc_hd__decap_12
XFILLER_192_589 VPWR VGND VPWR VGND sky130_ef_sc_hd__decap_12
XTAP_TAPCELL_ROW_108_1_1234 VGND VPWR sky130_fd_sc_hd__tapvpwrvgnd_1
XTAP_TAPCELL_ROW_76_2_3471 VGND VPWR sky130_fd_sc_hd__tapvpwrvgnd_1
XFILLER_69_1244 VPWR VGND VPWR VGND sky130_ef_sc_hd__decap_12
XFILLER_156_1258 VPWR VGND VPWR VGND sky130_ef_sc_hd__decap_12
XFILLER_86_1580 VGND VGND VPWR VPWR sky130_fd_sc_hd__fill_1
XFILLER_59_27 VPWR VGND VPWR VGND sky130_ef_sc_hd__decap_12
XFILLER_173_1561 VGND VGND VPWR VPWR sky130_fd_sc_hd__decap_6
XTAP_TAPCELL_ROW_101_2_3636 VGND VPWR sky130_fd_sc_hd__tapvpwrvgnd_1
XFILLER_115_55 VGND VGND VPWR VPWR sky130_fd_sc_hd__fill_1
XFILLER_219_237 VPWR VGND VPWR VGND sky130_ef_sc_hd__decap_12
XFILLER_189_1001 VGND VGND VPWR VPWR sky130_fd_sc_hd__decap_6
XFILLER_75_15 VPWR VGND VPWR VGND sky130_ef_sc_hd__decap_12
XTAP_TAPCELL_ROW_68_2_3419 VGND VPWR sky130_fd_sc_hd__tapvpwrvgnd_1
XFILLER_189_1045 VPWR VGND VPWR VGND sky130_ef_sc_hd__decap_12
XPHY_EDGE_ROW_68_2_Right_125 VGND VGND VPWR VPWR sky130_fd_sc_hd__decap_3
XFILLER_210_1477 VGND VGND VPWR VPWR sky130_fd_sc_hd__decap_6
XFILLER_189_1089 VPWR VGND VPWR VGND sky130_ef_sc_hd__decap_12
XFILLER_199_111 VGND VGND VPWR VPWR sky130_fd_sc_hd__fill_1
XFILLER_167_1343 VGND VGND VPWR VPWR sky130_fd_sc_hd__fill_1
XTAP_TAPCELL_ROW_202_2488 VGND VPWR sky130_fd_sc_hd__tapvpwrvgnd_1
XTAP_TAPCELL_ROW_198_2381 VGND VPWR sky130_fd_sc_hd__tapvpwrvgnd_1
XTAP_TAPCELL_ROW_198_2370 VGND VPWR sky130_fd_sc_hd__tapvpwrvgnd_1
XFILLER_187_317 VPWR VGND VPWR VGND sky130_ef_sc_hd__decap_12
XFILLER_163_1229 VGND VGND VPWR VPWR sky130_fd_sc_hd__decap_3
XPHY_EDGE_ROW_152_1_Right_738 VGND VGND VPWR VPWR sky130_fd_sc_hd__decap_3
XFILLER_152_3 VPWR VGND VPWR VGND sky130_ef_sc_hd__decap_12
XFILLER_128_1338 VPWR VGND VPWR VGND sky130_ef_sc_hd__decap_12
XTAP_TAPCELL_ROW_202_2499 VGND VPWR sky130_fd_sc_hd__tapvpwrvgnd_1
XTAP_TAPCELL_ROW_198_2392 VGND VPWR sky130_fd_sc_hd__tapvpwrvgnd_1
XFILLER_180_1521 VPWR VGND VPWR VGND sky130_ef_sc_hd__decap_12
XFILLER_91_69 VPWR VGND VPWR VGND sky130_ef_sc_hd__decap_12
X_301_ net42 net142 net131 VGND VGND VPWR VPWR s_wdata\[8\] sky130_fd_sc_hd__a21o_1
XTAP_TAPCELL_ROW_17_2_3086 VGND VPWR sky130_fd_sc_hd__tapvpwrvgnd_1
XFILLER_54_1524 VGND VGND VPWR VPWR sky130_fd_sc_hd__fill_1
XFILLER_211_671 VGND VGND VPWR VPWR sky130_fd_sc_hd__fill_1
XFILLER_208_1373 VPWR VGND VPWR VGND sky130_ef_sc_hd__decap_12
XTAP_TAPCELL_ROW_194_2278 VGND VPWR sky130_fd_sc_hd__tapvpwrvgnd_1
XTAP_TAPCELL_ROW_194_2267 VGND VPWR sky130_fd_sc_hd__tapvpwrvgnd_1
XTAP_TAPCELL_ROW_194_2256 VGND VPWR sky130_fd_sc_hd__tapvpwrvgnd_1
XFILLER_180_1565 VPWR VGND VPWR VGND sky130_ef_sc_hd__decap_12
XFILLER_168_531 VGND VGND VPWR VPWR sky130_fd_sc_hd__fill_1
XTAP_TAPCELL_ROW_219_2996 VGND VPWR sky130_fd_sc_hd__tapvpwrvgnd_1
XTAP_TAPCELL_ROW_219_2985 VGND VPWR sky130_fd_sc_hd__tapvpwrvgnd_1
XTAP_TAPCELL_ROW_219_2974 VGND VPWR sky130_fd_sc_hd__tapvpwrvgnd_1
XFILLER_204_1259 VGND VGND VPWR VPWR sky130_fd_sc_hd__fill_1
XFILLER_195_361 VPWR VGND VPWR VGND sky130_ef_sc_hd__decap_12
XPHY_EDGE_ROW_72_1_Left_291 VGND VGND VPWR VPWR sky130_fd_sc_hd__decap_3
XFILLER_7_725 VGND VGND VPWR VPWR sky130_fd_sc_hd__decap_3
XFILLER_196_1005 VPWR VGND VPWR VGND sky130_ef_sc_hd__decap_12
XFILLER_13_1232 VPWR VGND VPWR VGND sky130_ef_sc_hd__decap_12
XFILLER_52_1270 VPWR VGND VPWR VGND sky130_ef_sc_hd__decap_12
XFILLER_196_1049 VPWR VGND VPWR VGND sky130_ef_sc_hd__decap_12
XFILLER_171_729 VPWR VGND VPWR VGND sky130_ef_sc_hd__decap_12
XFILLER_104_1382 VPWR VGND VPWR VGND sky130_ef_sc_hd__decap_12
XFILLER_87_1322 VGND VGND VPWR VPWR sky130_fd_sc_hd__decap_6
XFILLER_7_769 VPWR VGND VPWR VGND sky130_ef_sc_hd__decap_12
XFILLER_178_1483 VGND VGND VPWR VPWR sky130_fd_sc_hd__fill_1
XFILLER_164_781 VPWR VGND VPWR VGND sky130_ef_sc_hd__decap_12
XFILLER_139_1434 VGND VGND VPWR VPWR sky130_fd_sc_hd__decap_6
XFILLER_123_111 VGND VGND VPWR VPWR sky130_fd_sc_hd__fill_1
XFILLER_100_1246 VPWR VGND VPWR VGND sky130_ef_sc_hd__decap_12
XFILLER_87_1366 VPWR VGND VPWR VGND sky130_ef_sc_hd__decap_12
XFILLER_13_1298 VPWR VGND VPWR VGND sky130_ef_sc_hd__decap_12
XFILLER_139_1478 VPWR VGND VPWR VGND sky130_ef_sc_hd__decap_12
XFILLER_3_953 VPWR VGND VPWR VGND sky130_ef_sc_hd__decap_12
XFILLER_215_1399 VGND VGND VPWR VPWR sky130_fd_sc_hd__fill_1
XFILLER_172_1093 VPWR VGND VPWR VGND sky130_ef_sc_hd__decap_12
XFILLER_172_83 VGND VGND VPWR VPWR sky130_fd_sc_hd__fill_1
XFILLER_8_1580 VGND VGND VPWR VPWR sky130_fd_sc_hd__fill_1
XTAP_TAPCELL_ROW_183_1960 VGND VPWR sky130_fd_sc_hd__tapvpwrvgnd_1
XTAP_TAPCELL_ROW_160_2_4018 VGND VPWR sky130_fd_sc_hd__tapvpwrvgnd_1
XTAP_TAPCELL_ROW_145_2_3923 VGND VPWR sky130_fd_sc_hd__tapvpwrvgnd_1
XFILLER_24_1350 VGND VGND VPWR VPWR sky130_fd_sc_hd__decap_6
XFILLER_37_117 VGND VGND VPWR VPWR sky130_fd_sc_hd__fill_1
XFILLER_207_933 VPWR VGND VPWR VGND sky130_ef_sc_hd__decap_12
XFILLER_206_421 VPWR VGND VPWR VGND sky130_ef_sc_hd__decap_12
XFILLER_168_1129 VPWR VGND VPWR VGND sky130_ef_sc_hd__decap_12
XFILLER_111_1342 VPWR VGND VPWR VGND sky130_ef_sc_hd__decap_12
XFILLER_98_1462 VGND VGND VPWR VPWR sky130_fd_sc_hd__decap_6
XFILLER_4_1477 VGND VGND VPWR VPWR sky130_fd_sc_hd__decap_6
XFILLER_24_1394 VPWR VGND VPWR VGND sky130_ef_sc_hd__decap_12
XFILLER_207_977 VPWR VGND VPWR VGND sky130_ef_sc_hd__decap_12
XFILLER_111_1386 VPWR VGND VPWR VGND sky130_ef_sc_hd__decap_12
XFILLER_94_1326 VPWR VGND VPWR VGND sky130_ef_sc_hd__decap_12
XFILLER_65_81 VPWR VGND VPWR VGND sky130_ef_sc_hd__decap_12
XFILLER_20_1258 VPWR VGND VPWR VGND sky130_ef_sc_hd__decap_12
XFILLER_146_1438 VPWR VGND VPWR VGND sky130_ef_sc_hd__decap_12
XFILLER_72_1602 VGND VGND VPWR VPWR sky130_fd_sc_hd__decap_3
XFILLER_202_693 VGND VGND VPWR VPWR sky130_fd_sc_hd__decap_6
XFILLER_201_181 VPWR VGND VPWR VGND sky130_ef_sc_hd__decap_12
XFILLER_187_895 VGND VGND VPWR VPWR sky130_fd_sc_hd__fill_1
XTAP_TAPCELL_ROW_177_1786 VGND VPWR sky130_fd_sc_hd__tapvpwrvgnd_1
XTAP_TAPCELL_ROW_177_1775 VGND VPWR sky130_fd_sc_hd__tapvpwrvgnd_1
XFILLER_174_501 VPWR VGND VPWR VGND sky130_ef_sc_hd__decap_12
XFILLER_179_1225 VGND VGND VPWR VPWR sky130_fd_sc_hd__decap_6
XTAP_TAPCELL_ROW_177_1797 VGND VPWR sky130_fd_sc_hd__tapvpwrvgnd_1
XFILLER_174_545 VPWR VGND VPWR VGND sky130_ef_sc_hd__decap_12
XFILLER_70_1370 VPWR VGND VPWR VGND sky130_ef_sc_hd__decap_12
XFILLER_31_1310 VPWR VGND VPWR VGND sky130_ef_sc_hd__decap_12
XFILLER_35_1490 VGND VGND VPWR VPWR sky130_fd_sc_hd__decap_6
XFILLER_179_1269 VPWR VGND VPWR VGND sky130_ef_sc_hd__decap_12
XFILLER_174_589 VPWR VGND VPWR VGND sky130_ef_sc_hd__decap_12
XFILLER_122_1482 VPWR VGND VPWR VGND sky130_ef_sc_hd__decap_12
XFILLER_31_1354 VPWR VGND VPWR VGND sky130_ef_sc_hd__decap_12
XFILLER_157_1534 VPWR VGND VPWR VGND sky130_ef_sc_hd__decap_12
XPHY_EDGE_ROW_114_1_Right_700 VGND VGND VPWR VPWR sky130_fd_sc_hd__decap_3
XFILLER_66_1406 VGND VGND VPWR VPWR sky130_fd_sc_hd__decap_6
XFILLER_31_1398 VPWR VGND VPWR VGND sky130_ef_sc_hd__decap_12
XFILLER_118_1518 VGND VGND VPWR VPWR sky130_fd_sc_hd__decap_6
XFILLER_216_65 VPWR VGND VPWR VGND sky130_ef_sc_hd__decap_12
XFILLER_157_1578 VPWR VGND VPWR VGND sky130_ef_sc_hd__decap_12
XFILLER_9_1322 VGND VGND VPWR VPWR sky130_fd_sc_hd__decap_6
XFILLER_116_1220 VPWR VGND VPWR VGND sky130_ef_sc_hd__decap_12
XFILLER_9_1366 VPWR VGND VPWR VGND sky130_ef_sc_hd__decap_12
XFILLER_29_1272 VGND VGND VPWR VPWR sky130_fd_sc_hd__fill_1
XTAP_TAPCELL_ROW_54_2_3327 VGND VPWR sky130_fd_sc_hd__tapvpwrvgnd_1
XPHY_EDGE_ROW_3_Left_223 VGND VGND VPWR VPWR sky130_fd_sc_hd__decap_3
XFILLER_42_1450 VPWR VGND VPWR VGND sky130_ef_sc_hd__decap_12
XFILLER_209_281 VPWR VGND VPWR VGND sky130_ef_sc_hd__decap_12
XFILLER_186_1229 VPWR VGND VPWR VGND sky130_ef_sc_hd__decap_12
XFILLER_42_1494 VPWR VGND VPWR VGND sky130_ef_sc_hd__decap_12
XFILLER_77_1546 VGND VGND VPWR VPWR sky130_fd_sc_hd__decap_6
XFILLER_212_413 VGND VGND VPWR VPWR sky130_fd_sc_hd__decap_6
XFILLER_197_615 VGND VGND VPWR VPWR sky130_fd_sc_hd__fill_1
XFILLER_212_457 VPWR VGND VPWR VGND sky130_ef_sc_hd__decap_12
XFILLER_169_317 VPWR VGND VPWR VGND sky130_ef_sc_hd__decap_12
XFILLER_101_57 VPWR VGND VPWR VGND sky130_ef_sc_hd__decap_12
XFILLER_205_1513 VPWR VGND VPWR VGND sky130_ef_sc_hd__decap_12
XFILLER_36_1232 VPWR VGND VPWR VGND sky130_ef_sc_hd__decap_12
XFILLER_61_39 VPWR VGND VPWR VGND sky130_ef_sc_hd__decap_12
XFILLER_193_821 VPWR VGND VPWR VGND sky130_ef_sc_hd__decap_12
XFILLER_184_309 VPWR VGND VPWR VGND sky130_ef_sc_hd__decap_12
XFILLER_177_361 VPWR VGND VPWR VGND sky130_ef_sc_hd__decap_12
XFILLER_177_39 VPWR VGND VPWR VGND sky130_ef_sc_hd__decap_12
XFILLER_197_1325 VPWR VGND VPWR VGND sky130_ef_sc_hd__decap_12
XFILLER_193_865 VPWR VGND VPWR VGND sky130_ef_sc_hd__decap_12
XFILLER_123_1268 VGND VGND VPWR VPWR sky130_fd_sc_hd__decap_4
XFILLER_53_1590 VPWR VGND VPWR VGND sky130_ef_sc_hd__decap_12
XFILLER_203_1281 VGND VGND VPWR VPWR sky130_fd_sc_hd__decap_6
XFILLER_197_1369 VPWR VGND VPWR VGND sky130_ef_sc_hd__decap_12
XFILLER_140_1582 VPWR VGND VPWR VGND sky130_ef_sc_hd__decap_12
XFILLER_101_1522 VPWR VGND VPWR VGND sky130_ef_sc_hd__decap_12
XFILLER_14_1574 VGND VGND VPWR VPWR sky130_fd_sc_hd__decap_6
XTAP_TAPCELL_ROW_210_2724 VGND VPWR sky130_fd_sc_hd__tapvpwrvgnd_1
XTAP_TAPCELL_ROW_210_2713 VGND VPWR sky130_fd_sc_hd__tapvpwrvgnd_1
XFILLER_193_27 VPWR VGND VPWR VGND sky130_ef_sc_hd__decap_12
XFILLER_101_1566 VPWR VGND VPWR VGND sky130_ef_sc_hd__decap_12
XFILLER_84_1506 VPWR VGND VPWR VGND sky130_ef_sc_hd__decap_12
XFILLER_10_1438 VPWR VGND VPWR VGND sky130_ef_sc_hd__decap_12
XTAP_TAPCELL_ROW_44_1_1106 VGND VPWR sky130_fd_sc_hd__tapvpwrvgnd_1
XTAP_TAPCELL_ROW_210_2735 VGND VPWR sky130_fd_sc_hd__tapvpwrvgnd_1
XFILLER_105_111 VGND VGND VPWR VPWR sky130_fd_sc_hd__fill_1
XFILLER_3_249 VGND VGND VPWR VPWR sky130_fd_sc_hd__decap_3
XTAP_TAPCELL_ROW_187_2060 VGND VPWR sky130_fd_sc_hd__tapvpwrvgnd_1
XFILLER_0_901 VGND VGND VPWR VPWR sky130_fd_sc_hd__fill_2
XTAP_TAPCELL_ROW_187_2082 VGND VPWR sky130_fd_sc_hd__tapvpwrvgnd_1
XTAP_TAPCELL_ROW_187_2071 VGND VPWR sky130_fd_sc_hd__tapvpwrvgnd_1
XFILLER_126_65 VPWR VGND VPWR VGND sky130_ef_sc_hd__decap_12
XFILLER_212_1539 VGND VGND VPWR VPWR sky130_fd_sc_hd__fill_1
XTAP_TAPCELL_ROW_131_2_3831 VGND VPWR sky130_fd_sc_hd__tapvpwrvgnd_1
XFILLER_43_1247 VPWR VGND VPWR VGND sky130_ef_sc_hd__decap_12
XTAP_TAPCELL_ROW_208_2675 VGND VPWR sky130_fd_sc_hd__tapvpwrvgnd_1
XTAP_TAPCELL_ROW_208_2664 VGND VPWR sky130_fd_sc_hd__tapvpwrvgnd_1
XFILLER_60_1550 VPWR VGND VPWR VGND sky130_ef_sc_hd__decap_12
XFILLER_210_1241 VPWR VGND VPWR VGND sky130_ef_sc_hd__decap_12
XFILLER_169_1449 VGND VGND VPWR VPWR sky130_fd_sc_hd__decap_6
XFILLER_142_53 VPWR VGND VPWR VGND sky130_ef_sc_hd__decap_12
XTAP_TAPCELL_ROW_98_2_3614 VGND VPWR sky130_fd_sc_hd__tapvpwrvgnd_1
XFILLER_95_1602 VGND VGND VPWR VPWR sky130_fd_sc_hd__decap_3
XFILLER_19_96 VGND VGND VPWR VPWR sky130_fd_sc_hd__fill_1
XFILLER_21_1534 VPWR VGND VPWR VGND sky130_ef_sc_hd__decap_12
XFILLER_60_1594 VGND VGND VPWR VPWR sky130_fd_sc_hd__decap_8
XFILLER_210_1285 VPWR VGND VPWR VGND sky130_ef_sc_hd__decap_12
XFILLER_142_97 VPWR VGND VPWR VGND sky130_ef_sc_hd__decap_12
XPHY_EDGE_ROW_69_2_Right_126 VGND VGND VPWR VPWR sky130_fd_sc_hd__decap_3
XFILLER_21_1578 VPWR VGND VPWR VGND sky130_ef_sc_hd__decap_12
XFILLER_215_273 VGND VGND VPWR VPWR sky130_fd_sc_hd__decap_6
XFILLER_204_925 VPWR VGND VPWR VGND sky130_ef_sc_hd__decap_12
XTAP_TAPCELL_ROW_196_2329 VGND VPWR sky130_fd_sc_hd__tapvpwrvgnd_1
XTAP_TAPCELL_ROW_196_2318 VGND VPWR sky130_fd_sc_hd__tapvpwrvgnd_1
XFILLER_35_51 VGND VGND VPWR VPWR sky130_fd_sc_hd__decap_4
XFILLER_188_637 VGND VGND VPWR VPWR sky130_fd_sc_hd__decap_6
XFILLER_187_125 VPWR VGND VPWR VGND sky130_ef_sc_hd__decap_12
XFILLER_163_1037 VPWR VGND VPWR VGND sky130_ef_sc_hd__decap_12
XFILLER_163_1015 VGND VGND VPWR VPWR sky130_fd_sc_hd__fill_1
XPHY_EDGE_ROW_153_1_Right_739 VGND VGND VPWR VPWR sky130_fd_sc_hd__decap_3
XFILLER_196_681 VPWR VGND VPWR VGND sky130_ef_sc_hd__decap_12
XFILLER_187_169 VPWR VGND VPWR VGND sky130_ef_sc_hd__decap_12
XFILLER_180_1373 VPWR VGND VPWR VGND sky130_ef_sc_hd__decap_12
XFILLER_169_895 VGND VGND VPWR VPWR sky130_fd_sc_hd__fill_1
XFILLER_19_1496 VGND VGND VPWR VPWR sky130_fd_sc_hd__fill_1
XTAP_TAPCELL_ROW_47_2_3281 VGND VPWR sky130_fd_sc_hd__tapvpwrvgnd_1
XFILLER_7_511 VGND VGND VPWR VPWR sky130_fd_sc_hd__fill_1
XFILLER_7_533 VPWR VGND VPWR VGND sky130_ef_sc_hd__decap_12
XFILLER_176_1409 VPWR VGND VPWR VGND sky130_ef_sc_hd__decap_12
XTAP_TAPCELL_ROW_172_1650 VGND VPWR sky130_fd_sc_hd__tapvpwrvgnd_1
XFILLER_171_559 VGND VGND VPWR VPWR sky130_fd_sc_hd__fill_1
XFILLER_139_1220 VPWR VGND VPWR VGND sky130_ef_sc_hd__decap_12
XFILLER_139_1286 VPWR VGND VPWR VGND sky130_ef_sc_hd__decap_12
XTAP_TAPCELL_ROW_40_2_3235 VGND VPWR sky130_fd_sc_hd__tapvpwrvgnd_1
XTAP_TAPCELL_ROW_39_2_3229 VGND VPWR sky130_fd_sc_hd__tapvpwrvgnd_1
XFILLER_183_93 VPWR VGND VPWR VGND sky130_ef_sc_hd__decap_12
XPHY_EDGE_ROW_118_2_Left_550 VGND VGND VPWR VPWR sky130_fd_sc_hd__decap_3
XFILLER_111_125 VGND VGND VPWR VPWR sky130_fd_sc_hd__fill_2
XFILLER_26_1412 VGND VGND VPWR VPWR sky130_fd_sc_hd__fill_1
XFILLER_2_293 VPWR VGND VPWR VGND sky130_ef_sc_hd__decap_12
XFILLER_6_1539 VGND VGND VPWR VPWR sky130_fd_sc_hd__fill_1
XFILLER_187_1505 VGND VGND VPWR VPWR sky130_fd_sc_hd__decap_6
XTAP_TAPCELL_ROW_181_1908 VGND VPWR sky130_fd_sc_hd__tapvpwrvgnd_1
XTAP_TAPCELL_ROW_166_1465 VGND VPWR sky130_fd_sc_hd__tapvpwrvgnd_1
XTAP_TAPCELL_ROW_20_2_3111 VGND VPWR sky130_fd_sc_hd__tapvpwrvgnd_1
XTAP_TAPCELL_ROW_166_1476 VGND VPWR sky130_fd_sc_hd__tapvpwrvgnd_1
XFILLER_4_1241 VPWR VGND VPWR VGND sky130_ef_sc_hd__decap_12
XFILLER_207_741 VPWR VGND VPWR VGND sky130_ef_sc_hd__decap_12
XFILLER_187_1549 VPWR VGND VPWR VGND sky130_ef_sc_hd__decap_12
XFILLER_98_1270 VPWR VGND VPWR VGND sky130_ef_sc_hd__decap_12
XFILLER_4_1285 VPWR VGND VPWR VGND sky130_ef_sc_hd__decap_12
XFILLER_0_1105 VPWR VGND VPWR VGND sky130_ef_sc_hd__decap_12
XFILLER_59_1232 VPWR VGND VPWR VGND sky130_ef_sc_hd__decap_12
XFILLER_207_785 VPWR VGND VPWR VGND sky130_ef_sc_hd__decap_12
XFILLER_206_251 VGND VGND VPWR VPWR sky130_fd_sc_hd__fill_1
XFILLER_179_615 VGND VGND VPWR VPWR sky130_fd_sc_hd__fill_1
XFILLER_0_1149 VPWR VGND VPWR VGND sky130_ef_sc_hd__decap_12
XTAP_TAPCELL_ROW_179_1837 VGND VPWR sky130_fd_sc_hd__tapvpwrvgnd_1
XFILLER_146_1246 VPWR VGND VPWR VGND sky130_ef_sc_hd__decap_12
XFILLER_59_1298 VPWR VGND VPWR VGND sky130_ef_sc_hd__decap_12
XFILLER_210_917 VGND VGND VPWR VPWR sky130_fd_sc_hd__decap_6
XTAP_TAPCELL_ROW_179_1848 VGND VPWR sky130_fd_sc_hd__tapvpwrvgnd_1
XFILLER_37_1552 VGND VGND VPWR VPWR sky130_fd_sc_hd__fill_1
XFILLER_175_821 VPWR VGND VPWR VGND sky130_ef_sc_hd__decap_12
XFILLER_166_309 VPWR VGND VPWR VGND sky130_ef_sc_hd__decap_12
XFILLER_163_1593 VGND VGND VPWR VPWR sky130_fd_sc_hd__decap_3
XFILLER_200_1421 VGND VGND VPWR VPWR sky130_fd_sc_hd__decap_6
XFILLER_190_813 VPWR VGND VPWR VGND sky130_ef_sc_hd__decap_12
XFILLER_179_1033 VPWR VGND VPWR VGND sky130_ef_sc_hd__decap_12
XFILLER_175_865 VPWR VGND VPWR VGND sky130_ef_sc_hd__decap_12
XFILLER_200_1465 VPWR VGND VPWR VGND sky130_ef_sc_hd__decap_12
XFILLER_194_1509 VPWR VGND VPWR VGND sky130_ef_sc_hd__decap_12
XFILLER_179_1077 VPWR VGND VPWR VGND sky130_ef_sc_hd__decap_12
XFILLER_157_1342 VPWR VGND VPWR VGND sky130_ef_sc_hd__decap_12
XPHY_EDGE_ROW_115_1_Right_701 VGND VGND VPWR VPWR sky130_fd_sc_hd__decap_3
XFILLER_118_1326 VPWR VGND VPWR VGND sky130_ef_sc_hd__decap_12
XFILLER_66_1258 VPWR VGND VPWR VGND sky130_ef_sc_hd__decap_12
XFILLER_170_581 VGND VGND VPWR VPWR sky130_fd_sc_hd__decap_6
XFILLER_157_1386 VPWR VGND VPWR VGND sky130_ef_sc_hd__decap_12
XFILLER_170_1553 VPWR VGND VPWR VGND sky130_ef_sc_hd__decap_12
XTAP_TAPCELL_ROW_116_2_3733 VGND VPWR sky130_fd_sc_hd__tapvpwrvgnd_1
XFILLER_217_505 VPWR VGND VPWR VGND sky130_ef_sc_hd__decap_12
XTAP_TAPCELL_ROW_84_2_3522 VGND VPWR sky130_fd_sc_hd__tapvpwrvgnd_1
XFILLER_211_1561 VGND VGND VPWR VPWR sky130_fd_sc_hd__decap_6
XFILLER_170_1597 VGND VGND VPWR VPWR sky130_fd_sc_hd__decap_8
XFILLER_186_1037 VPWR VGND VPWR VGND sky130_ef_sc_hd__decap_12
XFILLER_77_1310 VPWR VGND VPWR VGND sky130_ef_sc_hd__decap_12
XFILLER_129_1422 VPWR VGND VPWR VGND sky130_ef_sc_hd__decap_12
XFILLER_77_1354 VPWR VGND VPWR VGND sky130_ef_sc_hd__decap_12
XTAP_TAPCELL_ROW_0_753 VGND VPWR sky130_fd_sc_hd__tapvpwrvgnd_1
XTAP_TAPCELL_ROW_0_764 VGND VPWR sky130_fd_sc_hd__tapvpwrvgnd_1
XFILLER_212_221 VPWR VGND VPWR VGND sky130_ef_sc_hd__decap_12
XFILLER_77_1398 VPWR VGND VPWR VGND sky130_ef_sc_hd__decap_12
XFILLER_72_27 VGND VGND VPWR VPWR sky130_fd_sc_hd__fill_1
XTAP_TAPCELL_ROW_0_797 VGND VPWR sky130_fd_sc_hd__tapvpwrvgnd_1
XTAP_TAPCELL_ROW_0_786 VGND VPWR sky130_fd_sc_hd__tapvpwrvgnd_1
XTAP_TAPCELL_ROW_0_775 VGND VPWR sky130_fd_sc_hd__tapvpwrvgnd_1
XFILLER_38_1338 VPWR VGND VPWR VGND sky130_ef_sc_hd__decap_12
XFILLER_213_777 VGND VGND VPWR VPWR sky130_fd_sc_hd__decap_6
XFILLER_212_265 VPWR VGND VPWR VGND sky130_ef_sc_hd__decap_12
XFILLER_198_979 VGND VGND VPWR VPWR sky130_fd_sc_hd__fill_1
XFILLER_188_27 VGND VGND VPWR VPWR sky130_fd_sc_hd__fill_1
XFILLER_169_125 VPWR VGND VPWR VGND sky130_ef_sc_hd__decap_12
XFILLER_129_1466 VPWR VGND VPWR VGND sky130_ef_sc_hd__decap_12
XTAP_TAPCELL_ROW_216_2900 VGND VPWR sky130_fd_sc_hd__tapvpwrvgnd_1
XFILLER_205_1343 VGND VGND VPWR VPWR sky130_fd_sc_hd__fill_1
XFILLER_185_629 VPWR VGND VPWR VGND sky130_ef_sc_hd__decap_12
XFILLER_169_169 VPWR VGND VPWR VGND sky130_ef_sc_hd__decap_12
XFILLER_184_139 VGND VGND VPWR VPWR sky130_fd_sc_hd__fill_1
XFILLER_178_681 VPWR VGND VPWR VGND sky130_ef_sc_hd__decap_12
XFILLER_197_1133 VPWR VGND VPWR VGND sky130_ef_sc_hd__decap_12
XFILLER_193_673 VPWR VGND VPWR VGND sky130_ef_sc_hd__decap_12
XFILLER_197_1177 VPWR VGND VPWR VGND sky130_ef_sc_hd__decap_12
XFILLER_180_301 VGND VGND VPWR VPWR sky130_fd_sc_hd__decap_6
XFILLER_115_3 VPWR VGND VPWR VGND sky130_ef_sc_hd__decap_12
XFILLER_101_1330 VPWR VGND VPWR VGND sky130_ef_sc_hd__decap_12
XFILLER_88_1450 VPWR VGND VPWR VGND sky130_ef_sc_hd__decap_12
XFILLER_14_1382 VPWR VGND VPWR VGND sky130_ef_sc_hd__decap_12
XTAP_TAPCELL_ROW_189_2133 VGND VPWR sky130_fd_sc_hd__tapvpwrvgnd_1
XTAP_TAPCELL_ROW_189_2122 VGND VPWR sky130_fd_sc_hd__tapvpwrvgnd_1
XFILLER_180_345 VPWR VGND VPWR VGND sky130_ef_sc_hd__decap_12
XFILLER_84_1314 VPWR VGND VPWR VGND sky130_ef_sc_hd__decap_12
XFILLER_10_1246 VPWR VGND VPWR VGND sky130_ef_sc_hd__decap_12
XFILLER_49_1434 VGND VGND VPWR VPWR sky130_fd_sc_hd__decap_6
XTAP_TAPCELL_ROW_185_2019 VGND VPWR sky130_fd_sc_hd__tapvpwrvgnd_1
XTAP_TAPCELL_ROW_185_2008 VGND VPWR sky130_fd_sc_hd__tapvpwrvgnd_1
XFILLER_180_389 VPWR VGND VPWR VGND sky130_ef_sc_hd__decap_12
XFILLER_136_1426 VPWR VGND VPWR VGND sky130_ef_sc_hd__decap_12
XPHY_EDGE_ROW_103_1_Left_322 VGND VGND VPWR VPWR sky130_fd_sc_hd__decap_3
XFILLER_88_1494 VPWR VGND VPWR VGND sky130_ef_sc_hd__decap_12
XFILLER_84_1358 VPWR VGND VPWR VGND sky130_ef_sc_hd__decap_12
XFILLER_49_1478 VPWR VGND VPWR VGND sky130_ef_sc_hd__decap_12
XFILLER_97_57 VPWR VGND VPWR VGND sky130_ef_sc_hd__decap_12
XFILLER_216_1483 VGND VGND VPWR VPWR sky130_fd_sc_hd__fill_1
XFILLER_0_753 VGND VGND VPWR VPWR sky130_fd_sc_hd__decap_3
XANTENNA_input35_A func_wdata[30] VGND VGND VPWR VPWR sky130_fd_sc_hd__diode_2
XFILLER_169_1213 VPWR VGND VPWR VGND sky130_ef_sc_hd__decap_12
XFILLER_5_1561 VGND VGND VPWR VPWR sky130_fd_sc_hd__decap_6
XFILLER_169_1257 VPWR VGND VPWR VGND sky130_ef_sc_hd__decap_12
XFILLER_112_1470 VPWR VGND VPWR VGND sky130_ef_sc_hd__decap_12
XFILLER_95_1410 VPWR VGND VPWR VGND sky130_ef_sc_hd__decap_12
XFILLER_1_1425 VPWR VGND VPWR VGND sky130_ef_sc_hd__decap_12
XFILLER_21_1342 VPWR VGND VPWR VGND sky130_ef_sc_hd__decap_12
XFILLER_210_1093 VPWR VGND VPWR VGND sky130_ef_sc_hd__decap_12
XFILLER_99_1590 VPWR VGND VPWR VGND sky130_ef_sc_hd__decap_12
XFILLER_95_1454 VPWR VGND VPWR VGND sky130_ef_sc_hd__decap_12
XFILLER_1_1469 VPWR VGND VPWR VGND sky130_ef_sc_hd__decap_12
XFILLER_21_1386 VPWR VGND VPWR VGND sky130_ef_sc_hd__decap_12
XFILLER_46_83 VGND VGND VPWR VPWR sky130_fd_sc_hd__fill_1
XFILLER_204_755 VGND VGND VPWR VPWR sky130_fd_sc_hd__fill_1
XFILLER_188_401 VPWR VGND VPWR VGND sky130_ef_sc_hd__decap_12
XFILLER_147_1522 VPWR VGND VPWR VGND sky130_ef_sc_hd__decap_12
XTAP_TAPCELL_ROW_131_1_1279 VGND VPWR sky130_fd_sc_hd__tapvpwrvgnd_1
XFILLER_108_1506 VPWR VGND VPWR VGND sky130_ef_sc_hd__decap_12
XFILLER_56_1438 VPWR VGND VPWR VGND sky130_ef_sc_hd__decap_12
XFILLER_206_1129 VPWR VGND VPWR VGND sky130_ef_sc_hd__decap_12
XFILLER_188_445 VPWR VGND VPWR VGND sky130_ef_sc_hd__decap_12
XFILLER_147_1566 VPWR VGND VPWR VGND sky130_ef_sc_hd__decap_12
XFILLER_95_1498 VPWR VGND VPWR VGND sky130_ef_sc_hd__decap_12
XFILLER_188_489 VPWR VGND VPWR VGND sky130_ef_sc_hd__decap_12
XTAP_TAPCELL_ROW_174_1701 VGND VPWR sky130_fd_sc_hd__tapvpwrvgnd_1
XFILLER_200_961 VPWR VGND VPWR VGND sky130_ef_sc_hd__decap_12
XTAP_TAPCELL_ROW_174_1712 VGND VPWR sky130_fd_sc_hd__tapvpwrvgnd_1
XFILLER_190_109 VPWR VGND VPWR VGND sky130_ef_sc_hd__decap_12
XFILLER_172_813 VPWR VGND VPWR VGND sky130_ef_sc_hd__decap_12
XFILLER_183_161 VGND VGND VPWR VPWR sky130_fd_sc_hd__decap_6
XFILLER_176_1217 VPWR VGND VPWR VGND sky130_ef_sc_hd__decap_12
XFILLER_7_374 VPWR VGND VPWR VGND sky130_ef_sc_hd__decap_12
XFILLER_32_1482 VPWR VGND VPWR VGND sky130_ef_sc_hd__decap_12
XFILLER_119_1602 VGND VGND VPWR VPWR sky130_fd_sc_hd__decap_3
XFILLER_67_1534 VPWR VGND VPWR VGND sky130_ef_sc_hd__decap_12
XPHY_EDGE_ROW_35_1_Left_254 VGND VGND VPWR VPWR sky130_fd_sc_hd__decap_3
XFILLER_217_1225 VGND VGND VPWR VPWR sky130_fd_sc_hd__decap_6
XTAP_TAPCELL_ROW_90_2_3565 VGND VPWR sky130_fd_sc_hd__tapvpwrvgnd_1
XTAP_TAPCELL_ROW_89_2_3559 VGND VPWR sky130_fd_sc_hd__tapvpwrvgnd_1
XFILLER_28_1518 VGND VGND VPWR VPWR sky130_fd_sc_hd__decap_6
XFILLER_217_1269 VPWR VGND VPWR VGND sky130_ef_sc_hd__decap_12
XTAP_TAPCELL_ROW_168_1516 VGND VPWR sky130_fd_sc_hd__tapvpwrvgnd_1
XFILLER_154_1526 VPWR VGND VPWR VGND sky130_ef_sc_hd__decap_12
XTAP_TAPCELL_ROW_102_2_3641 VGND VPWR sky130_fd_sc_hd__tapvpwrvgnd_1
XFILLER_67_1578 VPWR VGND VPWR VGND sky130_ef_sc_hd__decap_12
XFILLER_3_580 VGND VGND VPWR VPWR sky130_fd_sc_hd__decap_8
XPHY_EDGE_ROW_209_Left_428 VGND VGND VPWR VPWR sky130_fd_sc_hd__decap_3
XTAP_TAPCELL_ROW_168_1538 VGND VPWR sky130_fd_sc_hd__tapvpwrvgnd_1
XTAP_TAPCELL_ROW_168_1527 VGND VPWR sky130_fd_sc_hd__tapvpwrvgnd_1
XTAP_TAPCELL_ROW_70_2_3430 VGND VPWR sky130_fd_sc_hd__tapvpwrvgnd_1
XFILLER_26_1220 VPWR VGND VPWR VGND sky130_ef_sc_hd__decap_12
XFILLER_30_3 VPWR VGND VPWR VGND sky130_ef_sc_hd__decap_12
XTAP_TAPCELL_ROW_69_2_3424 VGND VPWR sky130_fd_sc_hd__tapvpwrvgnd_1
XFILLER_187_1313 VPWR VGND VPWR VGND sky130_ef_sc_hd__decap_12
XFILLER_152_1294 VGND VGND VPWR VPWR sky130_fd_sc_hd__decap_6
XFILLER_113_1256 VPWR VGND VPWR VGND sky130_ef_sc_hd__decap_12
XFILLER_213_55 VGND VGND VPWR VPWR sky130_fd_sc_hd__fill_1
XFILLER_198_209 VPWR VGND VPWR VGND sky130_ef_sc_hd__decap_12
XFILLER_187_1357 VPWR VGND VPWR VGND sky130_ef_sc_hd__decap_12
XFILLER_4_1093 VPWR VGND VPWR VGND sky130_ef_sc_hd__decap_12
XTAP_TAPCELL_ROW_68_1_1154 VGND VPWR sky130_fd_sc_hd__tapvpwrvgnd_1
XPHY_EDGE_ROW_218_Left_437 VGND VGND VPWR VPWR sky130_fd_sc_hd__decap_3
XFILLER_74_1538 VPWR VGND VPWR VGND sky130_ef_sc_hd__decap_12
XFILLER_210_725 VPWR VGND VPWR VGND sky130_ef_sc_hd__decap_12
XFILLER_167_629 VPWR VGND VPWR VGND sky130_ef_sc_hd__decap_12
XFILLER_210_769 VPWR VGND VPWR VGND sky130_ef_sc_hd__decap_12
XFILLER_166_139 VGND VGND VPWR VPWR sky130_fd_sc_hd__fill_1
XFILLER_33_1268 VGND VGND VPWR VPWR sky130_fd_sc_hd__decap_4
XFILLER_198_1453 VPWR VGND VPWR VGND sky130_ef_sc_hd__decap_12
XFILLER_194_1317 VPWR VGND VPWR VGND sky130_ef_sc_hd__decap_12
XFILLER_175_673 VPWR VGND VPWR VGND sky130_ef_sc_hd__decap_12
XFILLER_163_813 VPWR VGND VPWR VGND sky130_ef_sc_hd__decap_12
XFILLER_11_1522 VPWR VGND VPWR VGND sky130_ef_sc_hd__decap_12
XFILLER_50_1582 VPWR VGND VPWR VGND sky130_ef_sc_hd__decap_12
XFILLER_200_1273 VPWR VGND VPWR VGND sky130_ef_sc_hd__decap_12
XFILLER_198_1497 VPWR VGND VPWR VGND sky130_ef_sc_hd__decap_12
XFILLER_190_643 VGND VGND VPWR VPWR sky130_fd_sc_hd__fill_1
XFILLER_174_29 VPWR VGND VPWR VGND sky130_ef_sc_hd__decap_12
XFILLER_11_1566 VPWR VGND VPWR VGND sky130_ef_sc_hd__decap_12
XPHY_EDGE_ROW_116_1_Right_702 VGND VGND VPWR VPWR sky130_fd_sc_hd__decap_3
XFILLER_192_1085 VGND VGND VPWR VPWR sky130_fd_sc_hd__decap_6
XFILLER_67_27 VPWR VGND VPWR VGND sky130_ef_sc_hd__decap_12
XFILLER_218_825 VPWR VGND VPWR VGND sky130_ef_sc_hd__decap_12
XTAP_TAPCELL_ROW_161_2_4023 VGND VPWR sky130_fd_sc_hd__tapvpwrvgnd_1
XFILLER_218_869 VPWR VGND VPWR VGND sky130_ef_sc_hd__decap_12
XFILLER_217_335 VGND VGND VPWR VPWR sky130_fd_sc_hd__fill_1
XFILLER_131_1378 VGND VGND VPWR VPWR sky130_fd_sc_hd__decap_6
XFILLER_123_55 VGND VGND VPWR VPWR sky130_fd_sc_hd__fill_1
XFILLER_83_15 VPWR VGND VPWR VGND sky130_ef_sc_hd__decap_12
XFILLER_199_15 VPWR VGND VPWR VGND sky130_ef_sc_hd__decap_12
X_480_ u_ctrl.cmp_valid _211_ VGND VGND VPWR VPWR _212_ sky130_fd_sc_hd__nand2_1
XFILLER_213_541 VPWR VGND VPWR VGND sky130_ef_sc_hd__decap_12
XFILLER_186_905 VPWR VGND VPWR VGND sky130_ef_sc_hd__decap_12
XFILLER_129_1274 VPWR VGND VPWR VGND sky130_ef_sc_hd__decap_12
XFILLER_213_585 VPWR VGND VPWR VGND sky130_ef_sc_hd__decap_12
XFILLER_207_1449 VGND VGND VPWR VPWR sky130_fd_sc_hd__decap_6
XFILLER_186_949 VPWR VGND VPWR VGND sky130_ef_sc_hd__decap_12
XFILLER_148_41 VPWR VGND VPWR VGND sky130_ef_sc_hd__decap_12
XFILLER_32_41 VGND VGND VPWR VPWR sky130_fd_sc_hd__decap_6
XFILLER_194_993 VPWR VGND VPWR VGND sky130_ef_sc_hd__decap_12
XFILLER_172_109 VPWR VGND VPWR VGND sky130_ef_sc_hd__decap_12
XFILLER_165_161 VGND VGND VPWR VPWR sky130_fd_sc_hd__decap_6
XFILLER_5_801 VGND VGND VPWR VPWR sky130_fd_sc_hd__fill_1
XFILLER_32_85 VGND VGND VPWR VPWR sky130_fd_sc_hd__decap_8
XFILLER_177_1537 VPWR VGND VPWR VGND sky130_ef_sc_hd__decap_12
XFILLER_148_85 VPWR VGND VPWR VGND sky130_ef_sc_hd__decap_12
XTAP_TAPCELL_ROW_75_2_3467 VGND VPWR sky130_fd_sc_hd__tapvpwrvgnd_1
XFILLER_181_665 VGND VGND VPWR VPWR sky130_fd_sc_hd__decap_6
XFILLER_180_153 VPWR VGND VPWR VGND sky130_ef_sc_hd__decap_12
XFILLER_49_1220 VPWR VGND VPWR VGND sky130_ef_sc_hd__decap_12
XFILLER_180_197 VPWR VGND VPWR VGND sky130_ef_sc_hd__decap_12
XFILLER_4_377 VPWR VGND VPWR VGND sky130_ef_sc_hd__decap_12
XFILLER_49_1286 VPWR VGND VPWR VGND sky130_ef_sc_hd__decap_12
XFILLER_218_1589 VGND VGND VPWR VPWR sky130_fd_sc_hd__decap_6
XFILLER_214_1409 VPWR VGND VPWR VGND sky130_ef_sc_hd__decap_12
XFILLER_171_1169 VGND VGND VPWR VPWR sky130_fd_sc_hd__decap_6
XFILLER_208_357 VGND VGND VPWR VPWR sky130_fd_sc_hd__decap_6
XFILLER_169_1021 VPWR VGND VPWR VGND sky130_ef_sc_hd__decap_12
XFILLER_57_93 VPWR VGND VPWR VGND sky130_ef_sc_hd__decap_12
XFILLER_180_83 VGND VGND VPWR VPWR sky130_fd_sc_hd__fill_1
XFILLER_169_1065 VPWR VGND VPWR VGND sky130_ef_sc_hd__decap_12
XFILLER_1_1233 VPWR VGND VPWR VGND sky130_ef_sc_hd__decap_12
XANTENNA_clkload0_A clknet_3_0_0_clk VGND VGND VPWR VPWR sky130_fd_sc_hd__diode_2
XFILLER_189_721 VGND VGND VPWR VPWR sky130_fd_sc_hd__decap_6
XFILLER_147_1330 VPWR VGND VPWR VGND sky130_ef_sc_hd__decap_12
XFILLER_108_1314 VPWR VGND VPWR VGND sky130_ef_sc_hd__decap_12
XFILLER_73_81 VPWR VGND VPWR VGND sky130_ef_sc_hd__decap_12
XFILLER_56_1246 VPWR VGND VPWR VGND sky130_ef_sc_hd__decap_12
XFILLER_189_765 VPWR VGND VPWR VGND sky130_ef_sc_hd__decap_12
XFILLER_188_253 VPWR VGND VPWR VGND sky130_ef_sc_hd__decap_12
XFILLER_189_81 VPWR VGND VPWR VGND sky130_ef_sc_hd__decap_12
XFILLER_108_1358 VPWR VGND VPWR VGND sky130_ef_sc_hd__decap_12
XFILLER_160_1574 VGND VGND VPWR VPWR sky130_fd_sc_hd__decap_6
XFILLER_78_3 VPWR VGND VPWR VGND sky130_ef_sc_hd__decap_12
XFILLER_191_429 VPWR VGND VPWR VGND sky130_ef_sc_hd__decap_12
XFILLER_163_109 VGND VGND VPWR VPWR sky130_fd_sc_hd__decap_3
XFILLER_172_643 VGND VGND VPWR VPWR sky130_fd_sc_hd__fill_1
XFILLER_7_193 VGND VGND VPWR VPWR sky130_fd_sc_hd__fill_1
XFILLER_201_1593 VPWR VGND VPWR VGND sky130_ef_sc_hd__decap_12
XFILLER_119_1410 VPWR VGND VPWR VGND sky130_ef_sc_hd__decap_12
XFILLER_67_1342 VPWR VGND VPWR VGND sky130_ef_sc_hd__decap_12
XFILLER_217_1033 VPWR VGND VPWR VGND sky130_ef_sc_hd__decap_12
XFILLER_208_77 VGND VGND VPWR VPWR sky130_fd_sc_hd__decap_6
XFILLER_158_1470 VPWR VGND VPWR VGND sky130_ef_sc_hd__decap_12
XFILLER_28_1326 VPWR VGND VPWR VGND sky130_ef_sc_hd__decap_12
XFILLER_217_1077 VPWR VGND VPWR VGND sky130_ef_sc_hd__decap_12
XFILLER_154_1356 VGND VGND VPWR VPWR sky130_fd_sc_hd__fill_1
XFILLER_119_1454 VPWR VGND VPWR VGND sky130_ef_sc_hd__decap_12
XFILLER_67_1386 VPWR VGND VPWR VGND sky130_ef_sc_hd__decap_12
XFILLER_119_1498 VPWR VGND VPWR VGND sky130_ef_sc_hd__decap_12
XFILLER_187_1121 VPWR VGND VPWR VGND sky130_ef_sc_hd__decap_12
XTAP_TAPCELL_ROW_2_848 VGND VPWR sky130_fd_sc_hd__tapvpwrvgnd_1
XTAP_TAPCELL_ROW_2_837 VGND VPWR sky130_fd_sc_hd__tapvpwrvgnd_1
XFILLER_215_839 VGND VGND VPWR VPWR sky130_fd_sc_hd__fill_1
XTAP_TAPCELL_ROW_2_859 VGND VPWR sky130_fd_sc_hd__tapvpwrvgnd_1
XFILLER_199_529 VPWR VGND VPWR VGND sky130_ef_sc_hd__decap_12
XFILLER_183_1007 VGND VGND VPWR VPWR sky130_fd_sc_hd__fill_1
XFILLER_74_1302 VPWR VGND VPWR VGND sky130_ef_sc_hd__decap_12
XANTENNA__584__CLK clknet_3_3_0_clk VGND VGND VPWR VPWR sky130_fd_sc_hd__diode_2
XFILLER_39_1422 VPWR VGND VPWR VGND sky130_ef_sc_hd__decap_12
XTAP_TAPCELL_ROW_99_1_1215 VGND VPWR sky130_fd_sc_hd__tapvpwrvgnd_1
XFILLER_78_1482 VPWR VGND VPWR VGND sky130_ef_sc_hd__decap_12
XFILLER_168_905 VPWR VGND VPWR VGND sky130_ef_sc_hd__decap_12
XFILLER_126_1414 VPWR VGND VPWR VGND sky130_ef_sc_hd__decap_12
XFILLER_39_1466 VPWR VGND VPWR VGND sky130_ef_sc_hd__decap_12
XFILLER_210_533 VPWR VGND VPWR VGND sky130_ef_sc_hd__decap_12
XFILLER_168_949 VPWR VGND VPWR VGND sky130_ef_sc_hd__decap_12
XFILLER_194_245 VGND VGND VPWR VPWR sky130_fd_sc_hd__decap_6
XFILLER_6_609 VGND VGND VPWR VPWR sky130_fd_sc_hd__fill_1
XFILLER_194_289 VPWR VGND VPWR VGND sky130_ef_sc_hd__decap_12
XFILLER_185_39 VPWR VGND VPWR VGND sky130_ef_sc_hd__decap_12
XFILLER_176_993 VPWR VGND VPWR VGND sky130_ef_sc_hd__decap_12
XFILLER_154_109 VPWR VGND VPWR VGND sky130_ef_sc_hd__decap_12
XFILLER_5_108 VGND VGND VPWR VPWR sky130_fd_sc_hd__decap_4
XTAP_TAPCELL_ROW_61_2_3375 VGND VPWR sky130_fd_sc_hd__tapvpwrvgnd_1
XFILLER_198_1261 VPWR VGND VPWR VGND sky130_ef_sc_hd__decap_12
XFILLER_11_1330 VPWR VGND VPWR VGND sky130_ef_sc_hd__decap_12
XFILLER_194_1147 VGND VGND VPWR VPWR sky130_fd_sc_hd__fill_1
XFILLER_159_1256 VPWR VGND VPWR VGND sky130_ef_sc_hd__decap_12
XFILLER_78_15 VPWR VGND VPWR VGND sky130_ef_sc_hd__decap_12
XFILLER_137_1510 VPWR VGND VPWR VGND sky130_ef_sc_hd__decap_12
XFILLER_118_77 VGND VGND VPWR VPWR sky130_fd_sc_hd__decap_6
XFILLER_85_1442 VPWR VGND VPWR VGND sky130_ef_sc_hd__decap_12
XFILLER_46_1426 VPWR VGND VPWR VGND sky130_ef_sc_hd__decap_12
XFILLER_137_1554 VPWR VGND VPWR VGND sky130_ef_sc_hd__decap_12
XPHY_EDGE_ROW_117_1_Right_703 VGND VGND VPWR VPWR sky130_fd_sc_hd__decap_3
XFILLER_81_1328 VGND VGND VPWR VPWR sky130_fd_sc_hd__fill_1
XFILLER_134_65 VPWR VGND VPWR VGND sky130_ef_sc_hd__decap_12
XFILLER_182_3 VPWR VGND VPWR VGND sky130_ef_sc_hd__decap_12
X_601_ clknet_3_5_0_clk _035_ VGND VGND VPWR VPWR net88 sky130_fd_sc_hd__dfxtp_1
XFILLER_205_305 VPWR VGND VPWR VGND sky130_ef_sc_hd__decap_12
XFILLER_166_1205 VPWR VGND VPWR VGND sky130_ef_sc_hd__decap_12
XFILLER_22_1470 VPWR VGND VPWR VGND sky130_ef_sc_hd__decap_12
XFILLER_218_699 VGND VGND VPWR VPWR sky130_fd_sc_hd__fill_1
XFILLER_150_53 VPWR VGND VPWR VGND sky130_ef_sc_hd__decap_12
XTAP_TAPCELL_ROW_146_1_1310 VGND VPWR sky130_fd_sc_hd__tapvpwrvgnd_1
XFILLER_79_1268 VGND VGND VPWR VPWR sky130_fd_sc_hd__decap_4
XFILLER_2_1553 VPWR VGND VPWR VGND sky130_ef_sc_hd__decap_12
X_532_ net73 net123 VGND VGND VPWR VPWR _240_ sky130_fd_sc_hd__or2_1
XFILLER_27_85 VGND VGND VPWR VPWR sky130_fd_sc_hd__decap_4
XFILLER_214_861 VGND VGND VPWR VPWR sky130_fd_sc_hd__decap_6
XFILLER_207_1213 VPWR VGND VPWR VGND sky130_ef_sc_hd__decap_12
XFILLER_205_349 VPWR VGND VPWR VGND sky130_ef_sc_hd__decap_12
XFILLER_150_97 VPWR VGND VPWR VGND sky130_ef_sc_hd__decap_12
XFILLER_96_1582 VPWR VGND VPWR VGND sky130_ef_sc_hd__decap_12
XFILLER_2_1597 VGND VGND VPWR VPWR sky130_fd_sc_hd__decap_8
X_463_ net148 net107 VGND VGND VPWR VPWR _195_ sky130_fd_sc_hd__xor2_1
XFILLER_18_1506 VPWR VGND VPWR VGND sky130_ef_sc_hd__decap_12
XFILLER_57_1522 VPWR VGND VPWR VGND sky130_ef_sc_hd__decap_12
XFILLER_186_713 VPWR VGND VPWR VGND sky130_ef_sc_hd__decap_12
XFILLER_92_1468 VGND VGND VPWR VPWR sky130_fd_sc_hd__fill_1
XFILLER_57_1566 VPWR VGND VPWR VGND sky130_ef_sc_hd__decap_12
XFILLER_213_393 VPWR VGND VPWR VGND sky130_ef_sc_hd__decap_12
XFILLER_207_1257 VPWR VGND VPWR VGND sky130_ef_sc_hd__decap_12
XFILLER_185_223 VGND VGND VPWR VPWR sky130_fd_sc_hd__fill_1
X_394_ b_addr\[2\] _102_ VGND VGND VPWR VPWR _132_ sky130_fd_sc_hd__and2_1
XFILLER_43_51 VGND VGND VPWR VPWR sky130_fd_sc_hd__decap_4
XFILLER_186_757 VPWR VGND VPWR VGND sky130_ef_sc_hd__decap_12
XFILLER_159_51 VGND VGND VPWR VPWR sky130_fd_sc_hd__decap_4
XTAP_TAPCELL_ROW_157_2_3997 VGND VPWR sky130_fd_sc_hd__tapvpwrvgnd_1
XFILLER_177_1301 VPWR VGND VPWR VGND sky130_ef_sc_hd__decap_12
XFILLER_173_429 VPWR VGND VPWR VGND sky130_ef_sc_hd__decap_12
XFILLER_142_1282 VPWR VGND VPWR VGND sky130_ef_sc_hd__decap_12
XFILLER_103_1244 VPWR VGND VPWR VGND sky130_ef_sc_hd__decap_12
XFILLER_181_473 VPWR VGND VPWR VGND sky130_ef_sc_hd__decap_12
XFILLER_177_1345 VPWR VGND VPWR VGND sky130_ef_sc_hd__decap_12
XFILLER_120_1580 VGND VGND VPWR VPWR sky130_fd_sc_hd__fill_1
XFILLER_57_8 VPWR VGND VPWR VGND sky130_ef_sc_hd__decap_12
XFILLER_29_1602 VGND VGND VPWR VPWR sky130_fd_sc_hd__decap_3
XFILLER_218_1353 VPWR VGND VPWR VGND sky130_ef_sc_hd__decap_12
XFILLER_64_1526 VPWR VGND VPWR VGND sky130_ef_sc_hd__decap_12
XFILLER_218_1397 VPWR VGND VPWR VGND sky130_ef_sc_hd__decap_12
XFILLER_214_1217 VPWR VGND VPWR VGND sky130_ef_sc_hd__decap_12
XFILLER_1_870 VGND VGND VPWR VPWR sky130_fd_sc_hd__decap_8
XFILLER_190_1589 VGND VGND VPWR VPWR sky130_fd_sc_hd__decap_6
XFILLER_7_1453 VGND VGND VPWR VPWR sky130_fd_sc_hd__decap_3
XFILLER_208_121 VPWR VGND VPWR VGND sky130_ef_sc_hd__decap_12
XFILLER_191_93 VPWR VGND VPWR VGND sky130_ef_sc_hd__decap_12
XFILLER_7_1497 VPWR VGND VPWR VGND sky130_ef_sc_hd__decap_12
XFILLER_23_1256 VPWR VGND VPWR VGND sky130_ef_sc_hd__decap_12
XFILLER_62_1294 VGND VGND VPWR VPWR sky130_fd_sc_hd__decap_6
XFILLER_208_165 VPWR VGND VPWR VGND sky130_ef_sc_hd__decap_12
XFILLER_188_1441 VPWR VGND VPWR VGND sky130_ef_sc_hd__decap_12
XFILLER_188_1485 VPWR VGND VPWR VGND sky130_ef_sc_hd__decap_12
XFILLER_1_1063 VGND VGND VPWR VPWR sky130_fd_sc_hd__fill_1
XFILLER_189_573 VPWR VGND VPWR VGND sky130_ef_sc_hd__decap_12
XPHY_EDGE_ROW_59_2_Left_491 VGND VGND VPWR VPWR sky130_fd_sc_hd__decap_3
XFILLER_182_1073 VPWR VGND VPWR VGND sky130_ef_sc_hd__decap_12
XFILLER_176_245 VGND VGND VPWR VPWR sky130_fd_sc_hd__decap_6
XTAP_TAPCELL_ROW_46_2_3277 VGND VPWR sky130_fd_sc_hd__tapvpwrvgnd_1
XFILLER_192_749 VGND VGND VPWR VPWR sky130_fd_sc_hd__decap_6
XFILLER_176_289 VPWR VGND VPWR VGND sky130_ef_sc_hd__decap_12
XFILLER_160_1382 VPWR VGND VPWR VGND sky130_ef_sc_hd__decap_12
XFILLER_136_109 VPWR VGND VPWR VGND sky130_ef_sc_hd__decap_12
XFILLER_121_1322 VGND VGND VPWR VPWR sky130_fd_sc_hd__decap_6
XFILLER_199_1581 VPWR VGND VPWR VGND sky130_ef_sc_hd__decap_12
XFILLER_195_1401 VPWR VGND VPWR VGND sky130_ef_sc_hd__decap_12
XFILLER_191_237 VPWR VGND VPWR VGND sky130_ef_sc_hd__decap_12
XFILLER_121_1366 VPWR VGND VPWR VGND sky130_ef_sc_hd__decap_12
XFILLER_219_1117 VGND VGND VPWR VPWR sky130_fd_sc_hd__decap_3
XFILLER_48_29 VPWR VGND VPWR VGND sky130_ef_sc_hd__decap_12
XFILLER_80_1350 VGND VGND VPWR VPWR sky130_fd_sc_hd__decap_6
XFILLER_132_1462 VGND VGND VPWR VPWR sky130_fd_sc_hd__decap_6
XFILLER_80_1394 VPWR VGND VPWR VGND sky130_ef_sc_hd__decap_12
XFILLER_41_1378 VGND VGND VPWR VPWR sky130_fd_sc_hd__decap_6
XFILLER_167_1525 VPWR VGND VPWR VGND sky130_ef_sc_hd__decap_12
XFILLER_203_809 VPWR VGND VPWR VGND sky130_ef_sc_hd__decap_12
XFILLER_199_337 VPWR VGND VPWR VGND sky130_ef_sc_hd__decap_12
XPHY_EDGE_ROW_169_Left_388 VGND VGND VPWR VPWR sky130_fd_sc_hd__decap_3
XFILLER_167_1569 VPWR VGND VPWR VGND sky130_ef_sc_hd__decap_12
XFILLER_208_1533 VGND VGND VPWR VPWR sky130_fd_sc_hd__decap_6
XFILLER_168_713 VPWR VGND VPWR VGND sky130_ef_sc_hd__decap_12
XTAP_TAPCELL_ROW_36_1_1089 VGND VPWR sky130_fd_sc_hd__tapvpwrvgnd_1
XFILLER_211_853 VPWR VGND VPWR VGND sky130_ef_sc_hd__decap_12
XFILLER_208_1577 VPWR VGND VPWR VGND sky130_ef_sc_hd__decap_12
XFILLER_167_223 VGND VGND VPWR VPWR sky130_fd_sc_hd__fill_1
XFILLER_126_1244 VGND VGND VPWR VPWR sky130_fd_sc_hd__fill_1
XPHY_EDGE_ROW_112_1_Left_331 VGND VGND VPWR VPWR sky130_fd_sc_hd__decap_3
XFILLER_80_27 VGND VGND VPWR VPWR sky130_fd_sc_hd__fill_1
XFILLER_39_1274 VPWR VGND VPWR VGND sky130_ef_sc_hd__decap_12
XFILLER_210_363 VGND VGND VPWR VPWR sky130_fd_sc_hd__fill_1
XFILLER_196_27 VGND VGND VPWR VPWR sky130_fd_sc_hd__fill_1
XFILLER_168_757 VPWR VGND VPWR VGND sky130_ef_sc_hd__decap_12
XFILLER_91_1490 VGND VGND VPWR VPWR sky130_fd_sc_hd__decap_6
XFILLER_211_897 VPWR VGND VPWR VGND sky130_ef_sc_hd__decap_12
XFILLER_183_727 VGND VGND VPWR VPWR sky130_fd_sc_hd__fill_1
XFILLER_13_54 VGND VGND VPWR VPWR sky130_fd_sc_hd__fill_2
XFILLER_100_1406 VGND VGND VPWR VPWR sky130_fd_sc_hd__decap_6
XFILLER_198_1091 VGND VGND VPWR VPWR sky130_fd_sc_hd__fill_1
XTAP_TAPCELL_ROW_91_2_3570 VGND VPWR sky130_fd_sc_hd__tapvpwrvgnd_1
XTAP_TAPCELL_ROW_213_2799 VGND VPWR sky130_fd_sc_hd__tapvpwrvgnd_1
XPHY_EDGE_ROW_178_Left_397 VGND VGND VPWR VPWR sky130_fd_sc_hd__decap_3
XFILLER_163_473 VGND VGND VPWR VPWR sky130_fd_sc_hd__decap_3
XFILLER_89_69 VPWR VGND VPWR VGND sky130_ef_sc_hd__decap_12
XFILLER_85_1272 VGND VGND VPWR VPWR sky130_fd_sc_hd__fill_1
XFILLER_1_111 VGND VGND VPWR VPWR sky130_fd_sc_hd__fill_1
XFILLER_8_3 VPWR VGND VPWR VGND sky130_ef_sc_hd__decap_12
XFILLER_215_1537 VPWR VGND VPWR VGND sky130_ef_sc_hd__decap_12
XFILLER_172_1253 VGND VGND VPWR VPWR sky130_fd_sc_hd__decap_6
XFILLER_137_1384 VGND VGND VPWR VPWR sky130_fd_sc_hd__fill_1
XFILLER_172_1297 VPWR VGND VPWR VGND sky130_ef_sc_hd__decap_12
XPHY_EDGE_ROW_118_1_Right_704 VGND VGND VPWR VPWR sky130_fd_sc_hd__decap_3
XTAP_TAPCELL_ROW_91_1_1199 VGND VPWR sky130_fd_sc_hd__tapvpwrvgnd_1
XTAP_TAPCELL_ROW_6_951 VGND VPWR sky130_fd_sc_hd__tapvpwrvgnd_1
XTAP_TAPCELL_ROW_6_962 VGND VPWR sky130_fd_sc_hd__tapvpwrvgnd_1
XTAP_TAPCELL_ROW_6_973 VGND VPWR sky130_fd_sc_hd__tapvpwrvgnd_1
XFILLER_219_953 VPWR VGND VPWR VGND sky130_ef_sc_hd__decap_12
XFILLER_150_1562 VPWR VGND VPWR VGND sky130_ef_sc_hd__decap_12
XFILLER_111_1546 VGND VGND VPWR VPWR sky130_fd_sc_hd__decap_6
XTAP_TAPCELL_ROW_83_2_3518 VGND VPWR sky130_fd_sc_hd__tapvpwrvgnd_1
XFILLER_206_625 VPWR VGND VPWR VGND sky130_ef_sc_hd__decap_12
XFILLER_205_113 VPWR VGND VPWR VGND sky130_ef_sc_hd__decap_12
XFILLER_206_669 VPWR VGND VPWR VGND sky130_ef_sc_hd__decap_12
XFILLER_166_1035 VGND VGND VPWR VPWR sky130_fd_sc_hd__fill_1
X_515_ net150 _188_ net128 net137 _231_ VGND VGND VPWR VPWR _041_ sky130_fd_sc_hd__o311a_1
XFILLER_207_1021 VPWR VGND VPWR VGND sky130_ef_sc_hd__decap_12
XFILLER_144_1300 VGND VGND VPWR VPWR sky130_fd_sc_hd__fill_1
XFILLER_92_1232 VPWR VGND VPWR VGND sky130_ef_sc_hd__decap_12
XFILLER_18_1314 VPWR VGND VPWR VGND sky130_ef_sc_hd__decap_12
XPHY_EDGE_ROW_44_1_Left_263 VGND VGND VPWR VPWR sky130_fd_sc_hd__decap_3
XFILLER_54_83 VGND VGND VPWR VPWR sky130_fd_sc_hd__fill_1
XFILLER_57_1330 VPWR VGND VPWR VGND sky130_ef_sc_hd__decap_12
XFILLER_183_1393 VGND VGND VPWR VPWR sky130_fd_sc_hd__decap_6
XFILLER_109_1442 VPWR VGND VPWR VGND sky130_ef_sc_hd__decap_12
X_446_ net147 net114 VGND VGND VPWR VPWR _178_ sky130_fd_sc_hd__xor2_1
XTAP_TAPCELL_ROW_32_2_3185 VGND VPWR sky130_fd_sc_hd__tapvpwrvgnd_1
XFILLER_207_1065 VPWR VGND VPWR VGND sky130_ef_sc_hd__decap_12
XFILLER_105_1328 VGND VGND VPWR VPWR sky130_fd_sc_hd__fill_1
X_377_ _081_ _098_ _100_ _116_ VGND VGND VPWR VPWR _117_ sky130_fd_sc_hd__or4_4
XFILLER_18_1358 VPWR VGND VPWR VGND sky130_ef_sc_hd__decap_12
XFILLER_201_385 VGND VGND VPWR VPWR sky130_fd_sc_hd__decap_6
XFILLER_186_587 VGND VGND VPWR VPWR sky130_fd_sc_hd__fill_1
XFILLER_118_109 VPWR VGND VPWR VGND sky130_ef_sc_hd__decap_12
XFILLER_70_1574 VGND VGND VPWR VPWR sky130_fd_sc_hd__decap_6
XFILLER_174_749 VGND VGND VPWR VPWR sky130_fd_sc_hd__decap_6
XFILLER_173_237 VPWR VGND VPWR VGND sky130_ef_sc_hd__decap_12
XFILLER_6_973 VGND VGND VPWR VPWR sky130_fd_sc_hd__decap_6
XFILLER_182_793 VPWR VGND VPWR VGND sky130_ef_sc_hd__decap_12
XFILLER_181_281 VPWR VGND VPWR VGND sky130_ef_sc_hd__decap_12
XFILLER_177_1175 VGND VGND VPWR VPWR sky130_fd_sc_hd__fill_1
XPHY_EDGE_ROW_80_1_Right_666 VGND VGND VPWR VPWR sky130_fd_sc_hd__decap_3
XFILLER_5_483 VGND VGND VPWR VPWR sky130_fd_sc_hd__decap_4
XFILLER_5_461 VGND VGND VPWR VPWR sky130_fd_sc_hd__decap_4
XFILLER_29_1410 VPWR VGND VPWR VGND sky130_ef_sc_hd__decap_12
XFILLER_155_1440 VGND VGND VPWR VPWR sky130_fd_sc_hd__fill_1
XFILLER_68_1470 VPWR VGND VPWR VGND sky130_ef_sc_hd__decap_12
XFILLER_218_1161 VPWR VGND VPWR VGND sky130_ef_sc_hd__decap_12
XFILLER_190_1353 VPWR VGND VPWR VGND sky130_ef_sc_hd__decap_12
XFILLER_64_1356 VGND VGND VPWR VPWR sky130_fd_sc_hd__fill_1
XFILLER_29_1454 VPWR VGND VPWR VGND sky130_ef_sc_hd__decap_12
XFILLER_190_1397 VPWR VGND VPWR VGND sky130_ef_sc_hd__decap_12
XFILLER_29_1498 VPWR VGND VPWR VGND sky130_ef_sc_hd__decap_12
XFILLER_116_1468 VGND VGND VPWR VPWR sky130_fd_sc_hd__fill_1
XFILLER_7_1261 VPWR VGND VPWR VGND sky130_ef_sc_hd__decap_12
XFILLER_209_441 VGND VGND VPWR VPWR sky130_fd_sc_hd__decap_6
XFILLER_209_485 VPWR VGND VPWR VGND sky130_ef_sc_hd__decap_12
XFILLER_3_1169 VGND VGND VPWR VPWR sky130_fd_sc_hd__decap_6
XFILLER_149_1244 VPWR VGND VPWR VGND sky130_ef_sc_hd__decap_12
XFILLER_211_105 VGND VGND VPWR VPWR sky130_fd_sc_hd__decap_6
XFILLER_196_307 VGND VGND VPWR VPWR sky130_fd_sc_hd__fill_1
XFILLER_211_149 VPWR VGND VPWR VGND sky130_ef_sc_hd__decap_12
XFILLER_36_1414 VPWR VGND VPWR VGND sky130_ef_sc_hd__decap_12
XFILLER_75_1496 VGND VGND VPWR VPWR sky130_fd_sc_hd__fill_1
XANTENNA__622__CLK clknet_3_6_0_clk VGND VGND VPWR VPWR sky130_fd_sc_hd__diode_2
XFILLER_192_513 VPWR VGND VPWR VGND sky130_ef_sc_hd__decap_12
XFILLER_165_727 VGND VGND VPWR VPWR sky130_fd_sc_hd__fill_1
XTAP_TAPCELL_ROW_108_2_3683 VGND VPWR sky130_fd_sc_hd__tapvpwrvgnd_1
XANTENNA_fanout135_A net136 VGND VGND VPWR VPWR sky130_fd_sc_hd__diode_2
XFILLER_192_557 VPWR VGND VPWR VGND sky130_ef_sc_hd__decap_12
XFILLER_195_1231 VGND VGND VPWR VPWR sky130_fd_sc_hd__fill_1
XTAP_TAPCELL_ROW_76_2_3472 VGND VPWR sky130_fd_sc_hd__tapvpwrvgnd_1
XFILLER_69_1256 VPWR VGND VPWR VGND sky130_ef_sc_hd__decap_12
XFILLER_82_1412 VGND VGND VPWR VPWR sky130_fd_sc_hd__fill_1
XFILLER_47_1510 VPWR VGND VPWR VGND sky130_ef_sc_hd__decap_12
XFILLER_59_39 VPWR VGND VPWR VGND sky130_ef_sc_hd__decap_12
XFILLER_182_29 VPWR VGND VPWR VGND sky130_ef_sc_hd__decap_12
XFILLER_134_1524 VGND VGND VPWR VPWR sky130_fd_sc_hd__fill_1
XTAP_TAPCELL_ROW_101_2_3637 VGND VPWR sky130_fd_sc_hd__tapvpwrvgnd_1
XFILLER_47_1554 VPWR VGND VPWR VGND sky130_ef_sc_hd__decap_12
XFILLER_219_249 VGND VGND VPWR VPWR sky130_fd_sc_hd__decap_3
XFILLER_75_27 VPWR VGND VPWR VGND sky130_ef_sc_hd__decap_12
XFILLER_189_1057 VGND VGND VPWR VPWR sky130_fd_sc_hd__decap_6
XFILLER_132_1270 VPWR VGND VPWR VGND sky130_ef_sc_hd__decap_12
XFILLER_216_923 VGND VGND VPWR VPWR sky130_fd_sc_hd__fill_1
XFILLER_131_55 VGND VGND VPWR VPWR sky130_fd_sc_hd__fill_1
XFILLER_91_15 VPWR VGND VPWR VGND sky130_ef_sc_hd__decap_12
XFILLER_203_617 VPWR VGND VPWR VGND sky130_ef_sc_hd__decap_12
XTAP_TAPCELL_ROW_202_2489 VGND VPWR sky130_fd_sc_hd__tapvpwrvgnd_1
XFILLER_199_167 VGND VGND VPWR VPWR sky130_fd_sc_hd__fill_1
XTAP_TAPCELL_ROW_198_2371 VGND VPWR sky130_fd_sc_hd__tapvpwrvgnd_1
X_300_ net41 net142 net131 VGND VGND VPWR VPWR s_wdata\[7\] sky130_fd_sc_hd__a21o_1
XFILLER_208_1341 VPWR VGND VPWR VGND sky130_ef_sc_hd__decap_12
XTAP_TAPCELL_ROW_198_2393 VGND VPWR sky130_fd_sc_hd__tapvpwrvgnd_1
XTAP_TAPCELL_ROW_198_2382 VGND VPWR sky130_fd_sc_hd__tapvpwrvgnd_1
XFILLER_187_329 VGND VGND VPWR VPWR sky130_fd_sc_hd__decap_6
XFILLER_180_1533 VGND VGND VPWR VPWR sky130_fd_sc_hd__decap_6
XFILLER_167_1399 VGND VGND VPWR VPWR sky130_fd_sc_hd__fill_1
XFILLER_93_1552 VGND VGND VPWR VPWR sky130_fd_sc_hd__fill_1
XTAP_TAPCELL_ROW_17_2_3087 VGND VPWR sky130_fd_sc_hd__tapvpwrvgnd_1
XFILLER_208_1385 VPWR VGND VPWR VGND sky130_ef_sc_hd__decap_12
XFILLER_204_1205 VPWR VGND VPWR VGND sky130_ef_sc_hd__decap_12
XTAP_TAPCELL_ROW_194_2279 VGND VPWR sky130_fd_sc_hd__tapvpwrvgnd_1
XTAP_TAPCELL_ROW_194_2268 VGND VPWR sky130_fd_sc_hd__tapvpwrvgnd_1
XTAP_TAPCELL_ROW_194_2257 VGND VPWR sky130_fd_sc_hd__tapvpwrvgnd_1
XFILLER_145_3 VPWR VGND VPWR VGND sky130_ef_sc_hd__decap_12
XTAP_TAPCELL_ROW_219_2986 VGND VPWR sky130_fd_sc_hd__tapvpwrvgnd_1
XTAP_TAPCELL_ROW_219_2975 VGND VPWR sky130_fd_sc_hd__tapvpwrvgnd_1
XFILLER_195_373 VPWR VGND VPWR VGND sky130_ef_sc_hd__decap_12
XFILLER_180_1577 VPWR VGND VPWR VGND sky130_ef_sc_hd__decap_12
XFILLER_168_587 VGND VGND VPWR VPWR sky130_fd_sc_hd__fill_1
XTAP_TAPCELL_ROW_219_2997 VGND VPWR sky130_fd_sc_hd__tapvpwrvgnd_1
XFILLER_196_1017 VPWR VGND VPWR VGND sky130_ef_sc_hd__decap_12
XPHY_EDGE_ROW_186_Left_405 VGND VGND VPWR VPWR sky130_fd_sc_hd__decap_3
XFILLER_104_1350 VGND VGND VPWR VPWR sky130_fd_sc_hd__decap_6
XFILLER_6_203 VGND VGND VPWR VPWR sky130_fd_sc_hd__fill_1
XFILLER_13_1244 VPWR VGND VPWR VGND sky130_ef_sc_hd__decap_12
XFILLER_52_1282 VPWR VGND VPWR VGND sky130_ef_sc_hd__decap_12
XFILLER_104_1394 VPWR VGND VPWR VGND sky130_ef_sc_hd__decap_12
XFILLER_40_41 VPWR VGND VPWR VGND sky130_ef_sc_hd__decap_12
XFILLER_174_1315 VGND VGND VPWR VPWR sky130_fd_sc_hd__fill_1
XFILLER_164_793 VPWR VGND VPWR VGND sky130_ef_sc_hd__decap_12
XFILLER_156_41 VPWR VGND VPWR VGND sky130_ef_sc_hd__decap_12
XFILLER_100_1258 VPWR VGND VPWR VGND sky130_ef_sc_hd__decap_12
XFILLER_30_1580 VGND VGND VPWR VPWR sky130_fd_sc_hd__fill_1
XFILLER_40_85 VPWR VGND VPWR VGND sky130_ef_sc_hd__decap_12
XFILLER_163_281 VPWR VGND VPWR VGND sky130_ef_sc_hd__decap_12
XFILLER_156_85 VPWR VGND VPWR VGND sky130_ef_sc_hd__decap_12
XFILLER_87_1378 VGND VGND VPWR VPWR sky130_fd_sc_hd__decap_6
XFILLER_3_965 VPWR VGND VPWR VGND sky130_ef_sc_hd__decap_12
XFILLER_3_943 VGND VGND VPWR VPWR sky130_fd_sc_hd__fill_1
XFILLER_219_1481 VGND VGND VPWR VPWR sky130_fd_sc_hd__decap_3
XFILLER_215_1301 VPWR VGND VPWR VGND sky130_ef_sc_hd__decap_12
XFILLER_152_1602 VGND VGND VPWR VPWR sky130_fd_sc_hd__decap_3
XFILLER_2_475 VGND VGND VPWR VPWR sky130_fd_sc_hd__fill_1
XFILLER_215_1345 VPWR VGND VPWR VGND sky130_ef_sc_hd__decap_12
XFILLER_172_1061 VPWR VGND VPWR VGND sky130_ef_sc_hd__decap_12
XPHY_EDGE_ROW_119_1_Right_705 VGND VGND VPWR VPWR sky130_fd_sc_hd__decap_3
XPHY_EDGE_ROW_195_Left_414 VGND VGND VPWR VPWR sky130_fd_sc_hd__decap_3
XTAP_TAPCELL_ROW_183_1961 VGND VPWR sky130_fd_sc_hd__tapvpwrvgnd_1
XTAP_TAPCELL_ROW_183_1950 VGND VPWR sky130_fd_sc_hd__tapvpwrvgnd_1
XTAP_TAPCELL_ROW_160_2_4019 VGND VPWR sky130_fd_sc_hd__tapvpwrvgnd_1
XFILLER_150_1370 VPWR VGND VPWR VGND sky130_ef_sc_hd__decap_12
XPHY_EDGE_ROW_123_2_Right_180 VGND VGND VPWR VPWR sky130_fd_sc_hd__decap_3
XFILLER_115_1490 VGND VGND VPWR VPWR sky130_fd_sc_hd__decap_6
XFILLER_111_1310 VPWR VGND VPWR VGND sky130_ef_sc_hd__decap_12
XFILLER_207_945 VGND VGND VPWR VPWR sky130_fd_sc_hd__decap_6
XFILLER_111_1354 VPWR VGND VPWR VGND sky130_ef_sc_hd__decap_12
XFILLER_1_57 VPWR VGND VPWR VGND sky130_ef_sc_hd__decap_12
XFILLER_206_433 VPWR VGND VPWR VGND sky130_ef_sc_hd__decap_12
XFILLER_65_93 VPWR VGND VPWR VGND sky130_ef_sc_hd__decap_12
XFILLER_207_989 VPWR VGND VPWR VGND sky130_ef_sc_hd__decap_12
XFILLER_206_477 VPWR VGND VPWR VGND sky130_ef_sc_hd__decap_12
XFILLER_185_1455 VGND VGND VPWR VPWR sky130_fd_sc_hd__fill_1
XFILLER_178_307 VGND VGND VPWR VPWR sky130_fd_sc_hd__fill_1
XFILLER_146_1406 VGND VGND VPWR VPWR sky130_fd_sc_hd__decap_6
XTAP_TAPCELL_ROW_114_1_1245 VGND VPWR sky130_fd_sc_hd__tapvpwrvgnd_1
XFILLER_111_1398 VPWR VGND VPWR VGND sky130_ef_sc_hd__decap_12
XFILLER_94_1338 VPWR VGND VPWR VGND sky130_ef_sc_hd__decap_12
XFILLER_60_121 VGND VGND VPWR VPWR sky130_fd_sc_hd__decap_6
XFILLER_187_841 VPWR VGND VPWR VGND sky130_ef_sc_hd__decap_12
XFILLER_109_1272 VGND VGND VPWR VPWR sky130_fd_sc_hd__fill_1
XFILLER_81_81 VPWR VGND VPWR VGND sky130_ef_sc_hd__decap_12
XANTENNA__554__S net122 VGND VGND VPWR VPWR sky130_fd_sc_hd__diode_2
X_429_ b_addr\[6\] _102_ VGND VGND VPWR VPWR _163_ sky130_fd_sc_hd__and2_1
XFILLER_197_81 VPWR VGND VPWR VGND sky130_ef_sc_hd__decap_12
XTAP_TAPCELL_ROW_177_1776 VGND VPWR sky130_fd_sc_hd__tapvpwrvgnd_1
XFILLER_174_513 VPWR VGND VPWR VGND sky130_ef_sc_hd__decap_12
XFILLER_201_193 VPWR VGND VPWR VGND sky130_ef_sc_hd__decap_12
XTAP_TAPCELL_ROW_177_1798 VGND VPWR sky130_fd_sc_hd__tapvpwrvgnd_1
XTAP_TAPCELL_ROW_177_1787 VGND VPWR sky130_fd_sc_hd__tapvpwrvgnd_1
XFILLER_122_1450 VPWR VGND VPWR VGND sky130_ef_sc_hd__decap_12
XFILLER_70_1382 VPWR VGND VPWR VGND sky130_ef_sc_hd__decap_12
XFILLER_31_1322 VGND VGND VPWR VPWR sky130_fd_sc_hd__decap_6
XTAP_TAPCELL_ROW_62_2_3380 VGND VPWR sky130_fd_sc_hd__tapvpwrvgnd_1
XFILLER_174_557 VPWR VGND VPWR VGND sky130_ef_sc_hd__decap_12
XFILLER_31_1366 VPWR VGND VPWR VGND sky130_ef_sc_hd__decap_12
XFILLER_60_3 VPWR VGND VPWR VGND sky130_ef_sc_hd__decap_12
XFILLER_122_1494 VPWR VGND VPWR VGND sky130_ef_sc_hd__decap_12
XFILLER_6_781 VPWR VGND VPWR VGND sky130_ef_sc_hd__decap_12
XFILLER_196_1595 VGND VGND VPWR VPWR sky130_fd_sc_hd__fill_1
XFILLER_157_1546 VGND VGND VPWR VPWR sky130_fd_sc_hd__decap_6
XPHY_EDGE_ROW_81_1_Right_667 VGND VGND VPWR VPWR sky130_fd_sc_hd__decap_3
XFILLER_216_77 VGND VGND VPWR VPWR sky130_fd_sc_hd__decap_6
XFILLER_190_1161 VPWR VGND VPWR VGND sky130_ef_sc_hd__decap_12
XFILLER_116_1232 VPWR VGND VPWR VGND sky130_ef_sc_hd__decap_12
XTAP_TAPCELL_ROW_54_2_3328 VGND VPWR sky130_fd_sc_hd__tapvpwrvgnd_1
XFILLER_9_1378 VGND VGND VPWR VPWR sky130_fd_sc_hd__decap_6
XFILLER_217_709 VPWR VGND VPWR VGND sky130_ef_sc_hd__decap_12
Xinput1 bist_mode VGND VGND VPWR VPWR net1 sky130_fd_sc_hd__clkbuf_1
XFILLER_42_1462 VGND VGND VPWR VPWR sky130_fd_sc_hd__decap_6
XFILLER_133_1590 VPWR VGND VPWR VGND sky130_ef_sc_hd__decap_12
XFILLER_209_293 VPWR VGND VPWR VGND sky130_ef_sc_hd__decap_12
XFILLER_169_329 VGND VGND VPWR VPWR sky130_fd_sc_hd__decap_6
XFILLER_164_1539 VGND VGND VPWR VPWR sky130_fd_sc_hd__fill_1
XFILLER_212_469 VGND VGND VPWR VPWR sky130_fd_sc_hd__decap_6
XFILLER_205_1525 VPWR VGND VPWR VGND sky130_ef_sc_hd__decap_12
XFILLER_101_69 VPWR VGND VPWR VGND sky130_ef_sc_hd__decap_12
XFILLER_36_1244 VGND VGND VPWR VPWR sky130_fd_sc_hd__fill_1
XFILLER_205_1569 VPWR VGND VPWR VGND sky130_ef_sc_hd__decap_12
XFILLER_177_373 VPWR VGND VPWR VGND sky130_ef_sc_hd__decap_12
XANTENNA_fanout138_X net138 VGND VGND VPWR VPWR sky130_fd_sc_hd__diode_2
XFILLER_193_833 VGND VGND VPWR VPWR sky130_fd_sc_hd__decap_6
XFILLER_192_321 VPWR VGND VPWR VGND sky130_ef_sc_hd__decap_12
XTAP_TAPCELL_ROW_214_2850 VGND VPWR sky130_fd_sc_hd__tapvpwrvgnd_1
XFILLER_197_1337 VGND VGND VPWR VPWR sky130_fd_sc_hd__decap_6
XFILLER_193_877 VPWR VGND VPWR VGND sky130_ef_sc_hd__decap_12
XFILLER_192_365 VPWR VGND VPWR VGND sky130_ef_sc_hd__decap_12
XFILLER_140_1550 VPWR VGND VPWR VGND sky130_ef_sc_hd__decap_12
XFILLER_101_1534 VPWR VGND VPWR VGND sky130_ef_sc_hd__decap_12
XFILLER_10_1406 VGND VGND VPWR VPWR sky130_fd_sc_hd__decap_6
XTAP_TAPCELL_ROW_210_2714 VGND VPWR sky130_fd_sc_hd__tapvpwrvgnd_1
XFILLER_140_1594 VGND VGND VPWR VPWR sky130_fd_sc_hd__decap_8
XTAP_TAPCELL_ROW_210_2736 VGND VPWR sky130_fd_sc_hd__tapvpwrvgnd_1
XTAP_TAPCELL_ROW_210_2725 VGND VPWR sky130_fd_sc_hd__tapvpwrvgnd_1
XFILLER_193_39 VPWR VGND VPWR VGND sky130_ef_sc_hd__decap_12
XFILLER_101_1578 VPWR VGND VPWR VGND sky130_ef_sc_hd__decap_12
XFILLER_84_1518 VGND VGND VPWR VPWR sky130_fd_sc_hd__decap_6
XFILLER_82_1220 VPWR VGND VPWR VGND sky130_ef_sc_hd__decap_12
XFILLER_0_913 VGND VGND VPWR VPWR sky130_fd_sc_hd__decap_4
XTAP_TAPCELL_ROW_187_2083 VGND VPWR sky130_fd_sc_hd__tapvpwrvgnd_1
XTAP_TAPCELL_ROW_187_2072 VGND VPWR sky130_fd_sc_hd__tapvpwrvgnd_1
XTAP_TAPCELL_ROW_187_2061 VGND VPWR sky130_fd_sc_hd__tapvpwrvgnd_1
XFILLER_173_1381 VPWR VGND VPWR VGND sky130_ef_sc_hd__decap_12
XFILLER_126_77 VGND VGND VPWR VPWR sky130_fd_sc_hd__decap_6
XFILLER_86_15 VPWR VGND VPWR VGND sky130_ef_sc_hd__decap_12
XFILLER_0_957 VGND VGND VPWR VPWR sky130_fd_sc_hd__fill_2
XFILLER_0_935 VGND VGND VPWR VPWR sky130_fd_sc_hd__decap_3
XFILLER_10_99 VGND VGND VPWR VPWR sky130_fd_sc_hd__decap_8
XPHY_EDGE_ROW_11_2_Left_443 VGND VGND VPWR VPWR sky130_fd_sc_hd__decap_3
XFILLER_47_1384 VGND VGND VPWR VPWR sky130_fd_sc_hd__fill_1
XFILLER_0_979 VGND VGND VPWR VPWR sky130_fd_sc_hd__fill_1
XTAP_TAPCELL_ROW_208_2665 VGND VPWR sky130_fd_sc_hd__tapvpwrvgnd_1
XTAP_TAPCELL_ROW_208_2654 VGND VPWR sky130_fd_sc_hd__tapvpwrvgnd_1
XTAP_TAPCELL_ROW_131_2_3832 VGND VPWR sky130_fd_sc_hd__tapvpwrvgnd_1
XFILLER_43_1259 VPWR VGND VPWR VGND sky130_ef_sc_hd__decap_12
XFILLER_60_1562 VPWR VGND VPWR VGND sky130_ef_sc_hd__decap_12
XFILLER_210_1253 VGND VGND VPWR VPWR sky130_fd_sc_hd__decap_6
XTAP_TAPCELL_ROW_208_2676 VGND VPWR sky130_fd_sc_hd__tapvpwrvgnd_1
XFILLER_142_65 VPWR VGND VPWR VGND sky130_ef_sc_hd__decap_12
XTAP_TAPCELL_ROW_98_2_3615 VGND VPWR sky130_fd_sc_hd__tapvpwrvgnd_1
XFILLER_21_1546 VGND VGND VPWR VPWR sky130_fd_sc_hd__decap_6
XFILLER_210_1297 VPWR VGND VPWR VGND sky130_ef_sc_hd__decap_12
XFILLER_204_937 VPWR VGND VPWR VGND sky130_ef_sc_hd__decap_12
XTAP_TAPCELL_ROW_196_2319 VGND VPWR sky130_fd_sc_hd__tapvpwrvgnd_1
XFILLER_42_121 VGND VGND VPWR VPWR sky130_fd_sc_hd__decap_6
XFILLER_203_447 VGND VGND VPWR VPWR sky130_fd_sc_hd__fill_1
XFILLER_163_1005 VGND VGND VPWR VPWR sky130_fd_sc_hd__decap_3
XFILLER_35_85 VGND VGND VPWR VPWR sky130_fd_sc_hd__fill_1
XFILLER_54_1300 VGND VGND VPWR VPWR sky130_fd_sc_hd__fill_1
XFILLER_187_137 VPWR VGND VPWR VGND sky130_ef_sc_hd__decap_12
XFILLER_180_1341 VPWR VGND VPWR VGND sky130_ef_sc_hd__decap_12
XFILLER_169_841 VPWR VGND VPWR VGND sky130_ef_sc_hd__decap_12
XFILLER_163_1049 VPWR VGND VPWR VGND sky130_ef_sc_hd__decap_12
XFILLER_106_1412 VGND VGND VPWR VPWR sky130_fd_sc_hd__fill_1
XFILLER_19_1442 VPWR VGND VPWR VGND sky130_ef_sc_hd__decap_12
XFILLER_212_981 VPWR VGND VPWR VGND sky130_ef_sc_hd__decap_12
XFILLER_204_1035 VGND VGND VPWR VPWR sky130_fd_sc_hd__fill_1
XFILLER_184_811 VGND VGND VPWR VPWR sky130_fd_sc_hd__fill_1
XFILLER_15_1328 VGND VGND VPWR VPWR sky130_fd_sc_hd__fill_1
XTAP_TAPCELL_ROW_47_2_3282 VGND VPWR sky130_fd_sc_hd__tapvpwrvgnd_1
XFILLER_196_693 VGND VGND VPWR VPWR sky130_fd_sc_hd__decap_6
XFILLER_195_181 VPWR VGND VPWR VGND sky130_ef_sc_hd__decap_12
XFILLER_180_1385 VPWR VGND VPWR VGND sky130_ef_sc_hd__decap_12
XFILLER_7_501 VGND VGND VPWR VPWR sky130_fd_sc_hd__decap_3
XFILLER_51_51 VGND VGND VPWR VPWR sky130_fd_sc_hd__decap_4
XTAP_TAPCELL_ROW_172_1640 VGND VPWR sky130_fd_sc_hd__tapvpwrvgnd_1
XFILLER_171_505 VPWR VGND VPWR VGND sky130_ef_sc_hd__decap_12
XFILLER_167_51 VGND VGND VPWR VPWR sky130_fd_sc_hd__decap_4
XFILLER_7_545 VPWR VGND VPWR VGND sky130_ef_sc_hd__decap_12
XFILLER_51_95 VPWR VGND VPWR VGND sky130_ef_sc_hd__decap_12
XTAP_TAPCELL_ROW_172_1651 VGND VPWR sky130_fd_sc_hd__tapvpwrvgnd_1
XFILLER_139_1232 VPWR VGND VPWR VGND sky130_ef_sc_hd__decap_12
XPHY_EDGE_ROW_22_2_Right_79 VGND VGND VPWR VPWR sky130_fd_sc_hd__decap_3
XANTENNA__403__A b_addr\[4\] VGND VGND VPWR VPWR sky130_fd_sc_hd__diode_2
XFILLER_65_1440 VGND VGND VPWR VPWR sky130_fd_sc_hd__fill_1
XTAP_TAPCELL_ROW_40_2_3236 VGND VPWR sky130_fd_sc_hd__tapvpwrvgnd_1
XFILLER_139_1298 VPWR VGND VPWR VGND sky130_ef_sc_hd__decap_12
XFILLER_215_1175 VGND VGND VPWR VPWR sky130_fd_sc_hd__fill_1
XFILLER_191_1481 VPWR VGND VPWR VGND sky130_ef_sc_hd__decap_12
XFILLER_117_1552 VGND VGND VPWR VPWR sky130_fd_sc_hd__fill_1
XTAP_TAPCELL_ROW_181_1909 VGND VPWR sky130_fd_sc_hd__tapvpwrvgnd_1
XTAP_TAPCELL_ROW_166_1466 VGND VPWR sky130_fd_sc_hd__tapvpwrvgnd_1
XFILLER_26_1468 VGND VGND VPWR VPWR sky130_fd_sc_hd__fill_1
XTAP_TAPCELL_ROW_166_1477 VGND VPWR sky130_fd_sc_hd__tapvpwrvgnd_1
XPHY_EDGE_ROW_124_2_Right_181 VGND VGND VPWR VPWR sky130_fd_sc_hd__decap_3
XFILLER_4_1253 VGND VGND VPWR VPWR sky130_fd_sc_hd__decap_6
XFILLER_207_753 VPWR VGND VPWR VGND sky130_ef_sc_hd__decap_12
XFILLER_0_1117 VGND VGND VPWR VPWR sky130_fd_sc_hd__decap_3
XFILLER_98_1282 VPWR VGND VPWR VGND sky130_ef_sc_hd__decap_12
XFILLER_4_1297 VPWR VGND VPWR VGND sky130_ef_sc_hd__decap_12
XFILLER_59_1244 VPWR VGND VPWR VGND sky130_ef_sc_hd__decap_12
XFILLER_207_797 VPWR VGND VPWR VGND sky130_ef_sc_hd__decap_12
XTAP_TAPCELL_ROW_179_1838 VGND VPWR sky130_fd_sc_hd__tapvpwrvgnd_1
XPHY_EDGE_ROW_87_2_Left_519 VGND VGND VPWR VPWR sky130_fd_sc_hd__decap_3
XTAP_TAPCELL_ROW_179_1849 VGND VPWR sky130_fd_sc_hd__tapvpwrvgnd_1
XFILLER_146_1258 VPWR VGND VPWR VGND sky130_ef_sc_hd__decap_12
XFILLER_76_1580 VGND VGND VPWR VPWR sky130_fd_sc_hd__fill_1
XTAP_TAPCELL_ROW_50_1_1117 VGND VPWR sky130_fd_sc_hd__tapvpwrvgnd_1
XFILLER_187_671 VGND VGND VPWR VPWR sky130_fd_sc_hd__fill_1
XFILLER_179_1001 VGND VGND VPWR VPWR sky130_fd_sc_hd__decap_6
XFILLER_175_833 VGND VGND VPWR VPWR sky130_fd_sc_hd__decap_6
XFILLER_174_321 VPWR VGND VPWR VGND sky130_ef_sc_hd__decap_12
XFILLER_179_1045 VPWR VGND VPWR VGND sky130_ef_sc_hd__decap_12
XFILLER_175_877 VPWR VGND VPWR VGND sky130_ef_sc_hd__decap_12
XFILLER_190_825 VPWR VGND VPWR VGND sky130_ef_sc_hd__decap_12
XFILLER_174_365 VPWR VGND VPWR VGND sky130_ef_sc_hd__decap_12
XFILLER_200_1477 VGND VGND VPWR VPWR sky130_fd_sc_hd__decap_6
XFILLER_190_869 VPWR VGND VPWR VGND sky130_ef_sc_hd__decap_12
XFILLER_179_1089 VPWR VGND VPWR VGND sky130_ef_sc_hd__decap_12
XFILLER_157_1310 VPWR VGND VPWR VGND sky130_ef_sc_hd__decap_12
XFILLER_157_1354 VPWR VGND VPWR VGND sky130_ef_sc_hd__decap_12
XFILLER_0_209 VPWR VGND VPWR VGND sky130_ef_sc_hd__decap_12
XFILLER_157_1398 VPWR VGND VPWR VGND sky130_ef_sc_hd__decap_12
XFILLER_118_1338 VPWR VGND VPWR VGND sky130_ef_sc_hd__decap_12
XPHY_EDGE_ROW_82_1_Right_668 VGND VGND VPWR VPWR sky130_fd_sc_hd__decap_3
XFILLER_170_1521 VPWR VGND VPWR VGND sky130_ef_sc_hd__decap_12
XPHY_EDGE_ROW_121_1_Left_340 VGND VGND VPWR VPWR sky130_fd_sc_hd__decap_3
XTAP_TAPCELL_ROW_116_2_3734 VGND VPWR sky130_fd_sc_hd__tapvpwrvgnd_1
XFILLER_44_1524 VGND VGND VPWR VPWR sky130_fd_sc_hd__fill_1
XFILLER_170_1565 VPWR VGND VPWR VGND sky130_ef_sc_hd__decap_12
XTAP_TAPCELL_ROW_84_2_3523 VGND VPWR sky130_fd_sc_hd__tapvpwrvgnd_1
XFILLER_56_29 VPWR VGND VPWR VGND sky130_ef_sc_hd__decap_12
XFILLER_217_517 VPWR VGND VPWR VGND sky130_ef_sc_hd__decap_12
XFILLER_186_1005 VPWR VGND VPWR VGND sky130_ef_sc_hd__decap_12
XFILLER_42_1270 VPWR VGND VPWR VGND sky130_ef_sc_hd__decap_12
XFILLER_186_1049 VPWR VGND VPWR VGND sky130_ef_sc_hd__decap_12
XFILLER_77_1322 VGND VGND VPWR VPWR sky130_fd_sc_hd__decap_6
XTAP_TAPCELL_ROW_0_754 VGND VPWR sky130_fd_sc_hd__tapvpwrvgnd_1
XTAP_TAPCELL_ROW_0_765 VGND VPWR sky130_fd_sc_hd__tapvpwrvgnd_1
XFILLER_198_925 VPWR VGND VPWR VGND sky130_ef_sc_hd__decap_12
XFILLER_168_1483 VGND VGND VPWR VPWR sky130_fd_sc_hd__fill_1
XFILLER_129_1434 VGND VGND VPWR VPWR sky130_fd_sc_hd__decap_6
XFILLER_77_1366 VPWR VGND VPWR VGND sky130_ef_sc_hd__decap_12
XTAP_TAPCELL_ROW_0_798 VGND VPWR sky130_fd_sc_hd__tapvpwrvgnd_1
XTAP_TAPCELL_ROW_0_787 VGND VPWR sky130_fd_sc_hd__tapvpwrvgnd_1
XTAP_TAPCELL_ROW_0_776 VGND VPWR sky130_fd_sc_hd__tapvpwrvgnd_1
XFILLER_212_233 VPWR VGND VPWR VGND sky130_ef_sc_hd__decap_12
XFILLER_169_137 VPWR VGND VPWR VGND sky130_ef_sc_hd__decap_12
XFILLER_129_1478 VPWR VGND VPWR VGND sky130_ef_sc_hd__decap_12
XTAP_TAPCELL_ROW_33_2_3190 VGND VPWR sky130_fd_sc_hd__tapvpwrvgnd_1
XTAP_TAPCELL_ROW_216_2901 VGND VPWR sky130_fd_sc_hd__tapvpwrvgnd_1
XFILLER_212_277 VPWR VGND VPWR VGND sky130_ef_sc_hd__decap_12
XFILLER_166_811 VGND VGND VPWR VPWR sky130_fd_sc_hd__fill_1
XFILLER_197_1101 VPWR VGND VPWR VGND sky130_ef_sc_hd__decap_12
XFILLER_178_693 VGND VGND VPWR VPWR sky130_fd_sc_hd__decap_6
XFILLER_177_181 VPWR VGND VPWR VGND sky130_ef_sc_hd__decap_12
XFILLER_205_1399 VGND VGND VPWR VPWR sky130_fd_sc_hd__fill_1
XFILLER_193_641 VPWR VGND VPWR VGND sky130_ef_sc_hd__decap_12
XFILLER_14_1350 VGND VGND VPWR VPWR sky130_fd_sc_hd__decap_6
XFILLER_197_1145 VPWR VGND VPWR VGND sky130_ef_sc_hd__decap_12
XFILLER_193_1009 VPWR VGND VPWR VGND sky130_ef_sc_hd__decap_12
XFILLER_193_685 VPWR VGND VPWR VGND sky130_ef_sc_hd__decap_12
XFILLER_101_1342 VPWR VGND VPWR VGND sky130_ef_sc_hd__decap_12
XFILLER_14_1394 VPWR VGND VPWR VGND sky130_ef_sc_hd__decap_12
XFILLER_21_54 VGND VGND VPWR VPWR sky130_fd_sc_hd__fill_2
XFILLER_197_1189 VPWR VGND VPWR VGND sky130_ef_sc_hd__decap_12
XFILLER_192_195 VGND VGND VPWR VPWR sky130_fd_sc_hd__fill_1
XTAP_TAPCELL_ROW_189_2134 VGND VPWR sky130_fd_sc_hd__tapvpwrvgnd_1
XTAP_TAPCELL_ROW_189_2123 VGND VPWR sky130_fd_sc_hd__tapvpwrvgnd_1
XFILLER_180_357 VGND VGND VPWR VPWR sky130_fd_sc_hd__decap_6
XFILLER_108_3 VPWR VGND VPWR VGND sky130_ef_sc_hd__decap_12
XFILLER_88_1462 VGND VGND VPWR VPWR sky130_fd_sc_hd__decap_6
XFILLER_10_1258 VPWR VGND VPWR VGND sky130_ef_sc_hd__decap_12
XFILLER_21_65 VGND VGND VPWR VPWR sky130_fd_sc_hd__fill_2
XTAP_TAPCELL_ROW_25_2_3138 VGND VPWR sky130_fd_sc_hd__tapvpwrvgnd_1
XTAP_TAPCELL_ROW_185_2009 VGND VPWR sky130_fd_sc_hd__tapvpwrvgnd_1
XFILLER_101_1386 VPWR VGND VPWR VGND sky130_ef_sc_hd__decap_12
XFILLER_84_1326 VPWR VGND VPWR VGND sky130_ef_sc_hd__decap_12
XFILLER_136_1438 VPWR VGND VPWR VGND sky130_ef_sc_hd__decap_12
XFILLER_97_69 VPWR VGND VPWR VGND sky130_ef_sc_hd__decap_12
XFILLER_62_1602 VGND VGND VPWR VPWR sky130_fd_sc_hd__decap_3
XFILLER_0_710 VGND VGND VPWR VPWR sky130_fd_sc_hd__decap_4
XPHY_EDGE_ROW_53_1_Left_272 VGND VGND VPWR VPWR sky130_fd_sc_hd__decap_3
XTAP_TAPCELL_ROW_138_1_1293 VGND VPWR sky130_fd_sc_hd__tapvpwrvgnd_1
XFILLER_212_1315 VGND VGND VPWR VPWR sky130_fd_sc_hd__fill_1
XANTENNA_input28_A func_wdata[24] VGND VGND VPWR VPWR sky130_fd_sc_hd__diode_2
XFILLER_21_1310 VPWR VGND VPWR VGND sky130_ef_sc_hd__decap_12
XFILLER_25_1490 VGND VGND VPWR VPWR sky130_fd_sc_hd__decap_6
XFILLER_60_1370 VPWR VGND VPWR VGND sky130_ef_sc_hd__decap_12
XFILLER_210_1061 VPWR VGND VPWR VGND sky130_ef_sc_hd__decap_12
XFILLER_169_1225 VGND VGND VPWR VPWR sky130_fd_sc_hd__decap_6
XFILLER_21_1354 VPWR VGND VPWR VGND sky130_ef_sc_hd__decap_12
XFILLER_204_701 VPWR VGND VPWR VGND sky130_ef_sc_hd__decap_12
XFILLER_169_1269 VPWR VGND VPWR VGND sky130_ef_sc_hd__decap_12
XFILLER_112_1482 VPWR VGND VPWR VGND sky130_ef_sc_hd__decap_12
XFILLER_95_1422 VPWR VGND VPWR VGND sky130_ef_sc_hd__decap_12
XFILLER_1_1437 VPWR VGND VPWR VGND sky130_ef_sc_hd__decap_12
XFILLER_188_413 VGND VGND VPWR VPWR sky130_fd_sc_hd__decap_6
XFILLER_147_1534 VPWR VGND VPWR VGND sky130_ef_sc_hd__decap_12
XFILLER_95_1466 VPWR VGND VPWR VGND sky130_ef_sc_hd__decap_12
XFILLER_21_1398 VPWR VGND VPWR VGND sky130_ef_sc_hd__decap_12
XPHY_EDGE_ROW_44_1_Right_630 VGND VGND VPWR VPWR sky130_fd_sc_hd__decap_3
XFILLER_56_1406 VGND VGND VPWR VPWR sky130_fd_sc_hd__decap_6
XFILLER_188_457 VPWR VGND VPWR VGND sky130_ef_sc_hd__decap_12
XFILLER_147_1578 VPWR VGND VPWR VGND sky130_ef_sc_hd__decap_12
XFILLER_108_1518 VGND VGND VPWR VPWR sky130_fd_sc_hd__decap_6
XFILLER_169_671 VGND VGND VPWR VPWR sky130_fd_sc_hd__fill_1
XFILLER_106_1220 VPWR VGND VPWR VGND sky130_ef_sc_hd__decap_12
XFILLER_19_1272 VGND VGND VPWR VPWR sky130_fd_sc_hd__fill_1
XFILLER_30_124 VGND VGND VPWR VPWR sky130_fd_sc_hd__decap_3
XTAP_TAPCELL_ROW_174_1713 VGND VPWR sky130_fd_sc_hd__tapvpwrvgnd_1
XTAP_TAPCELL_ROW_174_1702 VGND VPWR sky130_fd_sc_hd__tapvpwrvgnd_1
XFILLER_62_83 VGND VGND VPWR VPWR sky130_fd_sc_hd__fill_1
XFILLER_200_973 VGND VGND VPWR VPWR sky130_fd_sc_hd__decap_6
XFILLER_178_83 VGND VGND VPWR VPWR sky130_fd_sc_hd__fill_1
XFILLER_32_1450 VPWR VGND VPWR VGND sky130_ef_sc_hd__decap_12
XFILLER_172_825 VPWR VGND VPWR VGND sky130_ef_sc_hd__decap_12
XFILLER_7_78 VGND VGND VPWR VPWR sky130_fd_sc_hd__decap_6
XFILLER_176_1229 VPWR VGND VPWR VGND sky130_ef_sc_hd__decap_12
XFILLER_172_869 VPWR VGND VPWR VGND sky130_ef_sc_hd__decap_12
XFILLER_171_335 VGND VGND VPWR VPWR sky130_fd_sc_hd__fill_1
XANTENNA__503__B1 net138 VGND VGND VPWR VPWR sky130_fd_sc_hd__diode_2
XFILLER_7_386 VGND VGND VPWR VPWR sky130_fd_sc_hd__decap_6
XFILLER_32_1494 VPWR VGND VPWR VGND sky130_ef_sc_hd__decap_12
XTAP_TAPCELL_ROW_90_2_3566 VGND VPWR sky130_fd_sc_hd__tapvpwrvgnd_1
XFILLER_67_1546 VGND VGND VPWR VPWR sky130_fd_sc_hd__decap_6
XTAP_TAPCELL_ROW_168_1517 VGND VPWR sky130_fd_sc_hd__tapvpwrvgnd_1
XFILLER_154_1538 VPWR VGND VPWR VGND sky130_ef_sc_hd__decap_12
XTAP_TAPCELL_ROW_102_2_3642 VGND VPWR sky130_fd_sc_hd__tapvpwrvgnd_1
XFILLER_97_113 VPWR VGND VPWR VGND sky130_ef_sc_hd__decap_12
XTAP_TAPCELL_ROW_168_1539 VGND VPWR sky130_fd_sc_hd__tapvpwrvgnd_1
XTAP_TAPCELL_ROW_168_1528 VGND VPWR sky130_fd_sc_hd__tapvpwrvgnd_1
XTAP_TAPCELL_ROW_70_2_3431 VGND VPWR sky130_fd_sc_hd__tapvpwrvgnd_1
XFILLER_26_1232 VPWR VGND VPWR VGND sky130_ef_sc_hd__decap_12
XTAP_TAPCELL_ROW_69_2_3425 VGND VPWR sky130_fd_sc_hd__tapvpwrvgnd_1
XFILLER_6_1315 VGND VGND VPWR VPWR sky130_fd_sc_hd__fill_1
XFILLER_23_3 VPWR VGND VPWR VGND sky130_ef_sc_hd__decap_12
XFILLER_187_1325 VPWR VGND VPWR VGND sky130_ef_sc_hd__decap_12
XFILLER_113_1268 VGND VGND VPWR VPWR sky130_fd_sc_hd__decap_4
XFILLER_4_1061 VPWR VGND VPWR VGND sky130_ef_sc_hd__decap_12
XFILLER_43_1590 VPWR VGND VPWR VGND sky130_ef_sc_hd__decap_12
XFILLER_207_561 VPWR VGND VPWR VGND sky130_ef_sc_hd__decap_12
XFILLER_187_1369 VPWR VGND VPWR VGND sky130_ef_sc_hd__decap_12
XFILLER_130_1582 VPWR VGND VPWR VGND sky130_ef_sc_hd__decap_12
XPHY_EDGE_ROW_125_2_Right_182 VGND VGND VPWR VPWR sky130_fd_sc_hd__decap_3
XFILLER_74_1506 VPWR VGND VPWR VGND sky130_ef_sc_hd__decap_12
XTAP_TAPCELL_ROW_18_2_3092 VGND VPWR sky130_fd_sc_hd__tapvpwrvgnd_1
XFILLER_210_737 VPWR VGND VPWR VGND sky130_ef_sc_hd__decap_12
XFILLER_21_113 VPWR VGND VPWR VGND sky130_ef_sc_hd__decap_12
XFILLER_202_1539 VGND VGND VPWR VPWR sky130_fd_sc_hd__fill_1
XFILLER_198_1421 VGND VGND VPWR VPWR sky130_fd_sc_hd__decap_6
XFILLER_175_641 VPWR VGND VPWR VGND sky130_ef_sc_hd__decap_12
XFILLER_200_1241 VPWR VGND VPWR VGND sky130_ef_sc_hd__decap_12
XFILLER_198_1465 VPWR VGND VPWR VGND sky130_ef_sc_hd__decap_12
XFILLER_175_685 VPWR VGND VPWR VGND sky130_ef_sc_hd__decap_12
XFILLER_163_825 VPWR VGND VPWR VGND sky130_ef_sc_hd__decap_12
XFILLER_50_1550 VPWR VGND VPWR VGND sky130_ef_sc_hd__decap_12
XFILLER_194_1329 VPWR VGND VPWR VGND sky130_ef_sc_hd__decap_12
XFILLER_174_195 VGND VGND VPWR VPWR sky130_fd_sc_hd__fill_1
XFILLER_163_869 VPWR VGND VPWR VGND sky130_ef_sc_hd__decap_12
XFILLER_85_1602 VGND VGND VPWR VPWR sky130_fd_sc_hd__decap_3
XFILLER_11_1534 VPWR VGND VPWR VGND sky130_ef_sc_hd__decap_12
XFILLER_50_1594 VGND VGND VPWR VPWR sky130_fd_sc_hd__decap_8
XFILLER_200_1285 VPWR VGND VPWR VGND sky130_ef_sc_hd__decap_12
XFILLER_11_1578 VPWR VGND VPWR VGND sky130_ef_sc_hd__decap_12
XFILLER_190_699 VGND VGND VPWR VPWR sky130_fd_sc_hd__fill_1
XFILLER_107_57 VPWR VGND VPWR VGND sky130_ef_sc_hd__decap_12
XPHY_EDGE_ROW_83_1_Right_669 VGND VGND VPWR VPWR sky130_fd_sc_hd__decap_3
XFILLER_67_39 VPWR VGND VPWR VGND sky130_ef_sc_hd__decap_12
XFILLER_190_29 VPWR VGND VPWR VGND sky130_ef_sc_hd__decap_12
XFILLER_218_837 VPWR VGND VPWR VGND sky130_ef_sc_hd__decap_12
XFILLER_170_1373 VPWR VGND VPWR VGND sky130_ef_sc_hd__decap_12
XTAP_TAPCELL_ROW_161_2_4024 VGND VPWR sky130_fd_sc_hd__tapvpwrvgnd_1
XFILLER_211_1381 VPWR VGND VPWR VGND sky130_ef_sc_hd__decap_12
XFILLER_166_1409 VPWR VGND VPWR VGND sky130_ef_sc_hd__decap_12
XFILLER_83_27 VPWR VGND VPWR VGND sky130_ef_sc_hd__decap_12
XFILLER_199_27 VPWR VGND VPWR VGND sky130_ef_sc_hd__decap_12
XFILLER_129_1220 VPWR VGND VPWR VGND sky130_ef_sc_hd__decap_12
XFILLER_213_553 VGND VGND VPWR VPWR sky130_fd_sc_hd__decap_6
XFILLER_198_755 VGND VGND VPWR VPWR sky130_fd_sc_hd__fill_1
XFILLER_0_1481 VGND VGND VPWR VPWR sky130_fd_sc_hd__decap_3
XFILLER_16_65 VGND VGND VPWR VPWR sky130_fd_sc_hd__decap_4
XTAP_TAPCELL_ROW_19_1_1055 VGND VPWR sky130_fd_sc_hd__tapvpwrvgnd_1
XFILLER_213_597 VPWR VGND VPWR VGND sky130_ef_sc_hd__decap_12
XFILLER_186_917 VGND VGND VPWR VPWR sky130_fd_sc_hd__decap_6
XFILLER_185_405 VPWR VGND VPWR VGND sky130_ef_sc_hd__decap_12
XFILLER_129_1286 VPWR VGND VPWR VGND sky130_ef_sc_hd__decap_12
XFILLER_16_1412 VGND VGND VPWR VPWR sky130_fd_sc_hd__fill_1
XFILLER_185_449 VPWR VGND VPWR VGND sky130_ef_sc_hd__decap_12
XFILLER_194_961 VPWR VGND VPWR VGND sky130_ef_sc_hd__decap_12
XFILLER_177_1505 VGND VGND VPWR VPWR sky130_fd_sc_hd__decap_6
XFILLER_148_53 VPWR VGND VPWR VGND sky130_ef_sc_hd__decap_12
XFILLER_180_121 VPWR VGND VPWR VGND sky130_ef_sc_hd__decap_12
XFILLER_177_1549 VPWR VGND VPWR VGND sky130_ef_sc_hd__decap_12
XFILLER_148_97 VPWR VGND VPWR VGND sky130_ef_sc_hd__decap_12
XTAP_TAPCELL_ROW_75_2_3468 VGND VPWR sky130_fd_sc_hd__tapvpwrvgnd_1
XFILLER_180_165 VPWR VGND VPWR VGND sky130_ef_sc_hd__decap_12
XFILLER_88_1270 VPWR VGND VPWR VGND sky130_ef_sc_hd__decap_12
XFILLER_49_1232 VPWR VGND VPWR VGND sky130_ef_sc_hd__decap_12
XFILLER_164_41 VPWR VGND VPWR VGND sky130_ef_sc_hd__decap_12
XFILLER_79_113 VPWR VGND VPWR VGND sky130_ef_sc_hd__decap_12
XFILLER_4_389 VGND VGND VPWR VPWR sky130_fd_sc_hd__decap_6
XFILLER_164_85 VPWR VGND VPWR VGND sky130_ef_sc_hd__decap_12
XFILLER_136_1246 VPWR VGND VPWR VGND sky130_ef_sc_hd__decap_12
XFILLER_49_1298 VPWR VGND VPWR VGND sky130_ef_sc_hd__decap_12
XTAP_TAPCELL_ROW_55_2_3333 VGND VPWR sky130_fd_sc_hd__tapvpwrvgnd_1
XTAP_TAPCELL_ROW_74_1_1165 VGND VPWR sky130_fd_sc_hd__tapvpwrvgnd_1
XFILLER_27_1552 VGND VGND VPWR VPWR sky130_fd_sc_hd__fill_1
XFILLER_1_1201 VPWR VGND VPWR VGND sky130_ef_sc_hd__decap_12
XFILLER_184_1509 VPWR VGND VPWR VGND sky130_ef_sc_hd__decap_12
XFILLER_169_1033 VPWR VGND VPWR VGND sky130_ef_sc_hd__decap_12
XFILLER_5_1381 VPWR VGND VPWR VGND sky130_ef_sc_hd__decap_12
XFILLER_169_1077 VPWR VGND VPWR VGND sky130_ef_sc_hd__decap_12
XFILLER_1_1245 VPWR VGND VPWR VGND sky130_ef_sc_hd__decap_12
XFILLER_204_531 VGND VGND VPWR VPWR sky130_fd_sc_hd__fill_1
XFILLER_188_221 VPWR VGND VPWR VGND sky130_ef_sc_hd__decap_12
XFILLER_147_1342 VPWR VGND VPWR VGND sky130_ef_sc_hd__decap_12
XFILLER_95_1274 VPWR VGND VPWR VGND sky130_ef_sc_hd__decap_12
XFILLER_1_1289 VPWR VGND VPWR VGND sky130_ef_sc_hd__decap_12
XPHY_EDGE_ROW_45_1_Right_631 VGND VGND VPWR VPWR sky130_fd_sc_hd__decap_3
XFILLER_189_777 VGND VGND VPWR VPWR sky130_fd_sc_hd__decap_6
XFILLER_188_265 VPWR VGND VPWR VGND sky130_ef_sc_hd__decap_12
XFILLER_147_1386 VPWR VGND VPWR VGND sky130_ef_sc_hd__decap_12
XFILLER_108_1326 VPWR VGND VPWR VGND sky130_ef_sc_hd__decap_12
XFILLER_73_93 VPWR VGND VPWR VGND sky130_ef_sc_hd__decap_12
XFILLER_56_1258 VPWR VGND VPWR VGND sky130_ef_sc_hd__decap_12
XFILLER_189_93 VPWR VGND VPWR VGND sky130_ef_sc_hd__decap_12
XANTENNA__562__S net122 VGND VGND VPWR VPWR sky130_fd_sc_hd__diode_2
XFILLER_200_781 VPWR VGND VPWR VGND sky130_ef_sc_hd__decap_12
XFILLER_201_1561 VGND VGND VPWR VPWR sky130_fd_sc_hd__decap_6
XFILLER_217_1001 VGND VGND VPWR VPWR sky130_fd_sc_hd__decap_6
XFILLER_176_1037 VPWR VGND VPWR VGND sky130_ef_sc_hd__decap_12
XFILLER_67_1310 VPWR VGND VPWR VGND sky130_ef_sc_hd__decap_12
XFILLER_172_699 VGND VGND VPWR VPWR sky130_fd_sc_hd__fill_1
XFILLER_158_1482 VPWR VGND VPWR VGND sky130_ef_sc_hd__decap_12
XFILLER_154_1302 VPWR VGND VPWR VGND sky130_ef_sc_hd__decap_12
XFILLER_119_1422 VPWR VGND VPWR VGND sky130_ef_sc_hd__decap_12
XFILLER_67_1354 VPWR VGND VPWR VGND sky130_ef_sc_hd__decap_12
XFILLER_217_1045 VPWR VGND VPWR VGND sky130_ef_sc_hd__decap_12
XFILLER_119_1466 VPWR VGND VPWR VGND sky130_ef_sc_hd__decap_12
XFILLER_67_1398 VPWR VGND VPWR VGND sky130_ef_sc_hd__decap_12
XFILLER_28_1338 VPWR VGND VPWR VGND sky130_ef_sc_hd__decap_12
XFILLER_217_1089 VPWR VGND VPWR VGND sky130_ef_sc_hd__decap_12
XTAP_TAPCELL_ROW_121_1_1260 VGND VPWR sky130_fd_sc_hd__tapvpwrvgnd_1
XFILLER_85_105 VGND VGND VPWR VPWR sky130_fd_sc_hd__decap_6
XTAP_TAPCELL_ROW_99_2_3620 VGND VPWR sky130_fd_sc_hd__tapvpwrvgnd_1
XTAP_TAPCELL_ROW_2_849 VGND VPWR sky130_fd_sc_hd__tapvpwrvgnd_1
XTAP_TAPCELL_ROW_2_838 VGND VPWR sky130_fd_sc_hd__tapvpwrvgnd_1
XFILLER_187_1133 VPWR VGND VPWR VGND sky130_ef_sc_hd__decap_12
XFILLER_208_881 VPWR VGND VPWR VGND sky130_ef_sc_hd__decap_12
XFILLER_187_1177 VPWR VGND VPWR VGND sky130_ef_sc_hd__decap_12
XPHY_EDGE_ROW_126_2_Right_183 VGND VGND VPWR VPWR sky130_fd_sc_hd__decap_3
XFILLER_78_1450 VPWR VGND VPWR VGND sky130_ef_sc_hd__decap_12
XFILLER_207_391 VGND VGND VPWR VPWR sky130_fd_sc_hd__fill_1
XTAP_TAPCELL_ROW_99_1_1216 VGND VPWR sky130_fd_sc_hd__tapvpwrvgnd_1
XFILLER_78_1494 VPWR VGND VPWR VGND sky130_ef_sc_hd__decap_12
XFILLER_74_1314 VPWR VGND VPWR VGND sky130_ef_sc_hd__decap_12
XFILLER_39_1434 VGND VGND VPWR VPWR sky130_fd_sc_hd__decap_6
XFILLER_210_501 VPWR VGND VPWR VGND sky130_ef_sc_hd__decap_12
XFILLER_168_917 VGND VGND VPWR VPWR sky130_fd_sc_hd__decap_6
XFILLER_167_405 VPWR VGND VPWR VGND sky130_ef_sc_hd__decap_12
XFILLER_126_1426 VPWR VGND VPWR VGND sky130_ef_sc_hd__decap_12
XFILLER_74_1358 VPWR VGND VPWR VGND sky130_ef_sc_hd__decap_12
XFILLER_39_1478 VPWR VGND VPWR VGND sky130_ef_sc_hd__decap_12
XFILLER_210_545 VPWR VGND VPWR VGND sky130_ef_sc_hd__decap_12
XFILLER_161_1328 VGND VGND VPWR VPWR sky130_fd_sc_hd__fill_1
XPHY_EDGE_ROW_20_2_Left_452 VGND VGND VPWR VPWR sky130_fd_sc_hd__decap_3
XFILLER_210_589 VPWR VGND VPWR VGND sky130_ef_sc_hd__decap_12
XFILLER_206_1483 VGND VGND VPWR VPWR sky130_fd_sc_hd__fill_1
XFILLER_183_909 VPWR VGND VPWR VGND sky130_ef_sc_hd__decap_12
XFILLER_176_961 VPWR VGND VPWR VGND sky130_ef_sc_hd__decap_12
XFILLER_167_449 VPWR VGND VPWR VGND sky130_ef_sc_hd__decap_12
XFILLER_182_419 VGND VGND VPWR VPWR sky130_fd_sc_hd__fill_1
XTAP_TAPCELL_ROW_61_2_3376 VGND VPWR sky130_fd_sc_hd__tapvpwrvgnd_1
XFILLER_198_1273 VPWR VGND VPWR VGND sky130_ef_sc_hd__decap_12
XFILLER_191_953 VPWR VGND VPWR VGND sky130_ef_sc_hd__decap_12
XFILLER_162_121 VGND VGND VPWR VPWR sky130_fd_sc_hd__decap_6
XFILLER_11_1342 VPWR VGND VPWR VGND sky130_ef_sc_hd__decap_12
XFILLER_159_1268 VGND VGND VPWR VPWR sky130_fd_sc_hd__decap_4
XFILLER_102_1470 VPWR VGND VPWR VGND sky130_ef_sc_hd__decap_12
XFILLER_89_1590 VPWR VGND VPWR VGND sky130_ef_sc_hd__decap_12
XFILLER_85_1410 VPWR VGND VPWR VGND sky130_ef_sc_hd__decap_12
XFILLER_200_1093 VPWR VGND VPWR VGND sky130_ef_sc_hd__decap_12
XFILLER_137_1522 VPWR VGND VPWR VGND sky130_ef_sc_hd__decap_12
XFILLER_85_1454 VPWR VGND VPWR VGND sky130_ef_sc_hd__decap_12
XFILLER_78_27 VGND VGND VPWR VPWR sky130_fd_sc_hd__fill_1
XFILLER_11_1386 VPWR VGND VPWR VGND sky130_ef_sc_hd__decap_12
XFILLER_137_1566 VPWR VGND VPWR VGND sky130_ef_sc_hd__decap_12
XFILLER_85_1498 VPWR VGND VPWR VGND sky130_ef_sc_hd__decap_12
XFILLER_46_1438 VPWR VGND VPWR VGND sky130_ef_sc_hd__decap_12
XFILLER_218_601 VPWR VGND VPWR VGND sky130_ef_sc_hd__decap_12
XFILLER_134_77 VGND VGND VPWR VPWR sky130_fd_sc_hd__decap_6
XFILLER_94_15 VPWR VGND VPWR VGND sky130_ef_sc_hd__decap_12
XFILLER_218_645 VPWR VGND VPWR VGND sky130_ef_sc_hd__decap_12
XFILLER_217_111 VGND VGND VPWR VPWR sky130_fd_sc_hd__fill_1
X_600_ clknet_3_1_0_clk _034_ VGND VGND VPWR VPWR net87 sky130_fd_sc_hd__dfxtp_1
XFILLER_175_3 VPWR VGND VPWR VGND sky130_ef_sc_hd__decap_12
XFILLER_2_1521 VPWR VGND VPWR VGND sky130_ef_sc_hd__decap_12
X_531_ net150 _193_ net128 net137 _239_ VGND VGND VPWR VPWR _049_ sky130_fd_sc_hd__o311a_1
XFILLER_205_317 VPWR VGND VPWR VGND sky130_ef_sc_hd__decap_12
XFILLER_166_1217 VPWR VGND VPWR VGND sky130_ef_sc_hd__decap_12
XFILLER_150_65 VPWR VGND VPWR VGND sky130_ef_sc_hd__decap_12
XFILLER_96_1550 VPWR VGND VPWR VGND sky130_ef_sc_hd__decap_12
XFILLER_2_1565 VPWR VGND VPWR VGND sky130_ef_sc_hd__decap_12
XFILLER_22_1482 VPWR VGND VPWR VGND sky130_ef_sc_hd__decap_12
XFILLER_109_1602 VGND VGND VPWR VPWR sky130_fd_sc_hd__decap_3
XFILLER_96_1594 VGND VGND VPWR VPWR sky130_fd_sc_hd__decap_8
XFILLER_92_1414 VPWR VGND VPWR VGND sky130_ef_sc_hd__decap_12
X_462_ net146 net94 VGND VGND VPWR VPWR _194_ sky130_fd_sc_hd__xor2_1
XPHY_EDGE_ROW_31_2_Right_88 VGND VGND VPWR VPWR sky130_fd_sc_hd__decap_3
XFILLER_57_1534 VPWR VGND VPWR VGND sky130_ef_sc_hd__decap_12
XFILLER_213_361 VPWR VGND VPWR VGND sky130_ef_sc_hd__decap_12
XFILLER_207_1225 VGND VGND VPWR VPWR sky130_fd_sc_hd__decap_6
XFILLER_144_1526 VPWR VGND VPWR VGND sky130_ef_sc_hd__decap_12
XFILLER_18_1518 VGND VGND VPWR VPWR sky130_fd_sc_hd__decap_6
X_393_ _108_ _130_ _117_ VGND VGND VPWR VPWR _131_ sky130_fd_sc_hd__a21oi_1
XFILLER_57_1578 VPWR VGND VPWR VGND sky130_ef_sc_hd__decap_12
XFILLER_207_1269 VPWR VGND VPWR VGND sky130_ef_sc_hd__decap_12
XFILLER_186_725 VPWR VGND VPWR VGND sky130_ef_sc_hd__decap_12
XFILLER_16_1220 VPWR VGND VPWR VGND sky130_ef_sc_hd__decap_12
XFILLER_186_769 VPWR VGND VPWR VGND sky130_ef_sc_hd__decap_12
XTAP_TAPCELL_ROW_157_2_3998 VGND VPWR sky130_fd_sc_hd__tapvpwrvgnd_1
XFILLER_185_279 VGND VGND VPWR VPWR sky130_fd_sc_hd__fill_1
XFILLER_177_1313 VPWR VGND VPWR VGND sky130_ef_sc_hd__decap_12
XFILLER_142_1294 VGND VGND VPWR VPWR sky130_fd_sc_hd__decap_6
XFILLER_103_1256 VPWR VGND VPWR VGND sky130_ef_sc_hd__decap_12
XFILLER_5_610 VGND VGND VPWR VPWR sky130_fd_sc_hd__decap_6
XFILLER_181_441 VGND VGND VPWR VPWR sky130_fd_sc_hd__decap_6
XFILLER_177_1357 VPWR VGND VPWR VGND sky130_ef_sc_hd__decap_12
XFILLER_175_51 VGND VGND VPWR VPWR sky130_fd_sc_hd__decap_4
XFILLER_5_643 VGND VGND VPWR VPWR sky130_fd_sc_hd__decap_6
XFILLER_181_485 VPWR VGND VPWR VGND sky130_ef_sc_hd__decap_12
XFILLER_4_164 VPWR VGND VPWR VGND sky130_ef_sc_hd__decap_12
XFILLER_218_1365 VGND VGND VPWR VPWR sky130_fd_sc_hd__decap_6
XFILLER_64_1538 VPWR VGND VPWR VGND sky130_ef_sc_hd__decap_12
XFILLER_4_197 VPWR VGND VPWR VGND sky130_ef_sc_hd__decap_12
XFILLER_214_1229 VPWR VGND VPWR VGND sky130_ef_sc_hd__decap_12
XPHY_EDGE_ROW_96_2_Left_528 VGND VGND VPWR VPWR sky130_fd_sc_hd__decap_3
XFILLER_67_105 VGND VGND VPWR VPWR sky130_fd_sc_hd__decap_6
XPHY_EDGE_ROW_16_1_Left_235 VGND VGND VPWR VPWR sky130_fd_sc_hd__decap_3
XFILLER_208_133 VGND VGND VPWR VPWR sky130_fd_sc_hd__decap_6
XFILLER_188_1453 VPWR VGND VPWR VGND sky130_ef_sc_hd__decap_12
XFILLER_23_1268 VGND VGND VPWR VPWR sky130_fd_sc_hd__decap_4
XFILLER_208_177 VPWR VGND VPWR VGND sky130_ef_sc_hd__decap_12
XFILLER_188_1497 VPWR VGND VPWR VGND sky130_ef_sc_hd__decap_12
XFILLER_184_1317 VPWR VGND VPWR VGND sky130_ef_sc_hd__decap_12
XFILLER_40_1582 VPWR VGND VPWR VGND sky130_ef_sc_hd__decap_12
XFILLER_205_895 VGND VGND VPWR VPWR sky130_fd_sc_hd__fill_1
XFILLER_189_541 VPWR VGND VPWR VGND sky130_ef_sc_hd__decap_12
XPHY_EDGE_ROW_46_1_Right_632 VGND VGND VPWR VPWR sky130_fd_sc_hd__decap_3
XFILLER_189_585 VPWR VGND VPWR VGND sky130_ef_sc_hd__decap_12
XFILLER_182_1085 VGND VGND VPWR VPWR sky130_fd_sc_hd__decap_6
XFILLER_90_3 VPWR VGND VPWR VGND sky130_ef_sc_hd__decap_12
XFILLER_165_909 VPWR VGND VPWR VGND sky130_ef_sc_hd__decap_12
XFILLER_191_205 VPWR VGND VPWR VGND sky130_ef_sc_hd__decap_12
XFILLER_164_419 VGND VGND VPWR VPWR sky130_fd_sc_hd__fill_1
XFILLER_160_1350 VGND VGND VPWR VPWR sky130_fd_sc_hd__decap_6
XTAP_TAPCELL_ROW_46_2_3278 VGND VPWR sky130_fd_sc_hd__tapvpwrvgnd_1
XFILLER_199_1593 VPWR VGND VPWR VGND sky130_ef_sc_hd__decap_12
XFILLER_195_1413 VPWR VGND VPWR VGND sky130_ef_sc_hd__decap_12
XFILLER_191_249 VPWR VGND VPWR VGND sky130_ef_sc_hd__decap_12
XFILLER_173_953 VPWR VGND VPWR VGND sky130_ef_sc_hd__decap_12
XFILLER_160_1394 VPWR VGND VPWR VGND sky130_ef_sc_hd__decap_12
XFILLER_144_121 VGND VGND VPWR VPWR sky130_fd_sc_hd__decap_6
XFILLER_195_1457 VPWR VGND VPWR VGND sky130_ef_sc_hd__decap_12
XFILLER_121_1378 VGND VGND VPWR VPWR sky130_fd_sc_hd__decap_6
XTAP_TAPCELL_ROW_152_1_1321 VGND VPWR sky130_fd_sc_hd__tapvpwrvgnd_1
XFILLER_119_1274 VPWR VGND VPWR VGND sky130_ef_sc_hd__decap_12
XFILLER_215_615 VGND VGND VPWR VPWR sky130_fd_sc_hd__fill_1
XFILLER_199_305 VPWR VGND VPWR VGND sky130_ef_sc_hd__decap_12
XFILLER_167_1537 VPWR VGND VPWR VGND sky130_ef_sc_hd__decap_12
XFILLER_64_29 VPWR VGND VPWR VGND sky130_ef_sc_hd__decap_12
XFILLER_199_349 VPWR VGND VPWR VGND sky130_ef_sc_hd__decap_12
XFILLER_39_1220 VPWR VGND VPWR VGND sky130_ef_sc_hd__decap_12
XFILLER_202_309 VPWR VGND VPWR VGND sky130_ef_sc_hd__decap_12
XPHY_EDGE_ROW_127_2_Right_184 VGND VGND VPWR VPWR sky130_fd_sc_hd__decap_3
XFILLER_211_821 VPWR VGND VPWR VGND sky130_ef_sc_hd__decap_12
XFILLER_204_1409 VPWR VGND VPWR VGND sky130_ef_sc_hd__decap_12
XFILLER_168_725 VPWR VGND VPWR VGND sky130_ef_sc_hd__decap_12
XFILLER_39_1286 VPWR VGND VPWR VGND sky130_ef_sc_hd__decap_12
XFILLER_211_865 VPWR VGND VPWR VGND sky130_ef_sc_hd__decap_12
XFILLER_208_1589 VGND VGND VPWR VPWR sky130_fd_sc_hd__decap_6
XFILLER_168_769 VPWR VGND VPWR VGND sky130_ef_sc_hd__decap_12
XPHY_EDGE_ROW_62_1_Left_281 VGND VGND VPWR VPWR sky130_fd_sc_hd__decap_3
XFILLER_167_279 VGND VGND VPWR VPWR sky130_fd_sc_hd__fill_1
XFILLER_129_55 VGND VGND VPWR VPWR sky130_fd_sc_hd__fill_1
XFILLER_89_15 VPWR VGND VPWR VGND sky130_ef_sc_hd__decap_12
XFILLER_191_783 VGND VGND VPWR VPWR sky130_fd_sc_hd__fill_1
XTAP_TAPCELL_ROW_91_2_3571 VGND VPWR sky130_fd_sc_hd__tapvpwrvgnd_1
XFILLER_2_613 VGND VGND VPWR VPWR sky130_fd_sc_hd__decap_6
XFILLER_215_1505 VGND VGND VPWR VPWR sky130_fd_sc_hd__decap_6
XFILLER_137_1330 VPWR VGND VPWR VGND sky130_ef_sc_hd__decap_12
XFILLER_215_1549 VPWR VGND VPWR VGND sky130_ef_sc_hd__decap_12
XFILLER_1_145 VGND VGND VPWR VPWR sky130_fd_sc_hd__fill_1
XFILLER_46_1246 VPWR VGND VPWR VGND sky130_ef_sc_hd__decap_12
XPHY_EDGE_ROW_189_Right_34 VGND VGND VPWR VPWR sky130_fd_sc_hd__decap_3
XTAP_TAPCELL_ROW_6_952 VGND VPWR sky130_fd_sc_hd__tapvpwrvgnd_1
XTAP_TAPCELL_ROW_6_963 VGND VPWR sky130_fd_sc_hd__tapvpwrvgnd_1
XFILLER_219_921 VGND VGND VPWR VPWR sky130_fd_sc_hd__decap_3
XTAP_TAPCELL_ROW_6_974 VGND VPWR sky130_fd_sc_hd__tapvpwrvgnd_1
XFILLER_38_41 VPWR VGND VPWR VGND sky130_ef_sc_hd__decap_12
XFILLER_219_965 VPWR VGND VPWR VGND sky130_ef_sc_hd__decap_12
XFILLER_150_1574 VGND VGND VPWR VPWR sky130_fd_sc_hd__decap_6
XTAP_TAPCELL_ROW_83_2_3519 VGND VPWR sky130_fd_sc_hd__tapvpwrvgnd_1
XFILLER_38_85 VPWR VGND VPWR VGND sky130_ef_sc_hd__decap_12
XFILLER_218_475 VGND VGND VPWR VPWR sky130_fd_sc_hd__fill_1
XFILLER_206_637 VGND VGND VPWR VPWR sky130_fd_sc_hd__decap_6
XANTENNA_input10_A func_addr[7] VGND VGND VPWR VPWR sky130_fd_sc_hd__diode_2
XFILLER_205_125 VPWR VGND VPWR VGND sky130_ef_sc_hd__decap_12
XFILLER_2_1373 VPWR VGND VPWR VGND sky130_ef_sc_hd__decap_12
X_514_ net63 net124 VGND VGND VPWR VPWR _231_ sky130_fd_sc_hd__or2_1
XFILLER_205_169 VPWR VGND VPWR VGND sky130_ef_sc_hd__decap_12
XFILLER_148_1470 VPWR VGND VPWR VGND sky130_ef_sc_hd__decap_12
XFILLER_109_1410 VPWR VGND VPWR VGND sky130_ef_sc_hd__decap_12
XFILLER_57_1342 VPWR VGND VPWR VGND sky130_ef_sc_hd__decap_12
XFILLER_214_681 VPWR VGND VPWR VGND sky130_ef_sc_hd__decap_12
XFILLER_207_1033 VPWR VGND VPWR VGND sky130_ef_sc_hd__decap_12
XPHY_EDGE_ROW_198_Right_43 VGND VGND VPWR VPWR sky130_fd_sc_hd__decap_3
XFILLER_109_1454 VPWR VGND VPWR VGND sky130_ef_sc_hd__decap_12
XFILLER_92_1244 VGND VGND VPWR VPWR sky130_fd_sc_hd__fill_1
X_445_ net145 net98 VGND VGND VPWR VPWR _177_ sky130_fd_sc_hd__xor2_1
XFILLER_18_1326 VPWR VGND VPWR VGND sky130_ef_sc_hd__decap_12
XFILLER_57_1386 VPWR VGND VPWR VGND sky130_ef_sc_hd__decap_12
XFILLER_207_1077 VPWR VGND VPWR VGND sky130_ef_sc_hd__decap_12
XFILLER_186_533 VPWR VGND VPWR VGND sky130_ef_sc_hd__decap_12
XFILLER_144_1356 VGND VGND VPWR VPWR sky130_fd_sc_hd__fill_1
XFILLER_109_1498 VPWR VGND VPWR VGND sky130_ef_sc_hd__decap_12
X_376_ _069_ u_ctrl.elem_idx\[1\] _108_ VGND VGND VPWR VPWR _116_ sky130_fd_sc_hd__a21oi_1
XTAP_TAPCELL_ROW_32_2_3186 VGND VPWR sky130_fd_sc_hd__tapvpwrvgnd_1
XFILLER_173_205 VPWR VGND VPWR VGND sky130_ef_sc_hd__decap_12
XTAP_TAPCELL_ROW_8_2_3027 VGND VPWR sky130_fd_sc_hd__tapvpwrvgnd_1
XFILLER_173_249 VPWR VGND VPWR VGND sky130_ef_sc_hd__decap_12
XFILLER_70_83 VGND VGND VPWR VPWR sky130_fd_sc_hd__fill_1
XFILLER_186_83 VGND VGND VPWR VPWR sky130_fd_sc_hd__fill_1
XFILLER_177_1121 VPWR VGND VPWR VGND sky130_ef_sc_hd__decap_12
XFILLER_126_121 VGND VGND VPWR VPWR sky130_fd_sc_hd__decap_6
XFILLER_173_1007 VGND VGND VPWR VPWR sky130_fd_sc_hd__fill_1
XFILLER_170_923 VGND VGND VPWR VPWR sky130_fd_sc_hd__fill_1
XANTENNA__574__CLK clknet_3_3_0_clk VGND VGND VPWR VPWR sky130_fd_sc_hd__diode_2
XFILLER_181_293 VPWR VGND VPWR VGND sky130_ef_sc_hd__decap_12
XFILLER_141_113 VPWR VGND VPWR VGND sky130_ef_sc_hd__decap_12
XFILLER_79_81 VPWR VGND VPWR VGND sky130_ef_sc_hd__decap_12
XFILLER_68_1482 VPWR VGND VPWR VGND sky130_ef_sc_hd__decap_12
XFILLER_64_1302 VPWR VGND VPWR VGND sky130_ef_sc_hd__decap_12
XFILLER_29_1422 VPWR VGND VPWR VGND sky130_ef_sc_hd__decap_12
XFILLER_218_1173 VPWR VGND VPWR VGND sky130_ef_sc_hd__decap_12
XFILLER_116_1414 VPWR VGND VPWR VGND sky130_ef_sc_hd__decap_12
XFILLER_29_1466 VPWR VGND VPWR VGND sky130_ef_sc_hd__decap_12
XFILLER_214_1037 VPWR VGND VPWR VGND sky130_ef_sc_hd__decap_12
XFILLER_190_1365 VGND VGND VPWR VPWR sky130_fd_sc_hd__decap_6
XFILLER_155_1496 VGND VGND VPWR VPWR sky130_fd_sc_hd__fill_1
XFILLER_205_57 VPWR VGND VPWR VGND sky130_ef_sc_hd__decap_12
XFILLER_7_1273 VPWR VGND VPWR VGND sky130_ef_sc_hd__decap_12
XFILLER_209_497 VGND VGND VPWR VPWR sky130_fd_sc_hd__decap_6
XFILLER_188_1261 VPWR VGND VPWR VGND sky130_ef_sc_hd__decap_12
XFILLER_149_1256 VPWR VGND VPWR VGND sky130_ef_sc_hd__decap_12
XANTENNA__584__Q b_addr\[0\] VGND VGND VPWR VPWR sky130_fd_sc_hd__diode_2
XFILLER_197_809 VPWR VGND VPWR VGND sky130_ef_sc_hd__decap_12
XFILLER_184_1147 VGND VGND VPWR VPWR sky130_fd_sc_hd__fill_1
XFILLER_127_1510 VPWR VGND VPWR VGND sky130_ef_sc_hd__decap_12
XFILLER_75_1442 VPWR VGND VPWR VGND sky130_ef_sc_hd__decap_12
XFILLER_162_1412 VGND VGND VPWR VPWR sky130_fd_sc_hd__fill_1
XFILLER_127_1554 VPWR VGND VPWR VGND sky130_ef_sc_hd__decap_12
XFILLER_36_1426 VPWR VGND VPWR VGND sky130_ef_sc_hd__decap_12
XFILLER_189_393 VPWR VGND VPWR VGND sky130_ef_sc_hd__decap_12
XFILLER_71_1328 VGND VGND VPWR VPWR sky130_fd_sc_hd__fill_1
XPHY_EDGE_ROW_47_1_Right_633 VGND VGND VPWR VPWR sky130_fd_sc_hd__decap_3
XPHY_EDGE_ROW_202_Right_47 VGND VGND VPWR VPWR sky130_fd_sc_hd__decap_3
XFILLER_192_525 VGND VGND VPWR VPWR sky130_fd_sc_hd__decap_6
XANTENNA_fanout128_A net129 VGND VGND VPWR VPWR sky130_fd_sc_hd__diode_2
XFILLER_192_569 VPWR VGND VPWR VGND sky130_ef_sc_hd__decap_12
XTAP_TAPCELL_ROW_76_2_3473 VGND VPWR sky130_fd_sc_hd__tapvpwrvgnd_1
XFILLER_173_783 VGND VGND VPWR VPWR sky130_fd_sc_hd__fill_1
XFILLER_69_1268 VGND VGND VPWR VPWR sky130_fd_sc_hd__decap_4
XFILLER_12_1470 VPWR VGND VPWR VGND sky130_ef_sc_hd__decap_12
XFILLER_195_1287 VGND VGND VPWR VPWR sky130_fd_sc_hd__fill_1
XFILLER_86_1582 VPWR VGND VPWR VGND sky130_ef_sc_hd__decap_12
XFILLER_47_1522 VPWR VGND VPWR VGND sky130_ef_sc_hd__decap_12
XFILLER_47_1566 VPWR VGND VPWR VGND sky130_ef_sc_hd__decap_12
XFILLER_82_1468 VGND VGND VPWR VPWR sky130_fd_sc_hd__fill_1
XFILLER_115_57 VPWR VGND VPWR VGND sky130_ef_sc_hd__decap_12
XANTENNA_input2_A bist_start VGND VGND VPWR VPWR sky130_fd_sc_hd__diode_2
XPHY_EDGE_ROW_211_Right_56 VGND VGND VPWR VPWR sky130_fd_sc_hd__decap_3
XFILLER_75_39 VPWR VGND VPWR VGND sky130_ef_sc_hd__decap_12
XFILLER_167_1301 VPWR VGND VPWR VGND sky130_ef_sc_hd__decap_12
XFILLER_132_1282 VPWR VGND VPWR VGND sky130_ef_sc_hd__decap_12
XFILLER_216_979 VGND VGND VPWR VPWR sky130_fd_sc_hd__fill_1
XFILLER_199_113 VPWR VGND VPWR VGND sky130_ef_sc_hd__decap_12
XFILLER_167_1345 VPWR VGND VPWR VGND sky130_ef_sc_hd__decap_12
XFILLER_203_629 VPWR VGND VPWR VGND sky130_ef_sc_hd__decap_12
XTAP_TAPCELL_ROW_198_2372 VGND VPWR sky130_fd_sc_hd__tapvpwrvgnd_1
XFILLER_110_1580 VGND VGND VPWR VPWR sky130_fd_sc_hd__fill_1
XFILLER_91_27 VPWR VGND VPWR VGND sky130_ef_sc_hd__decap_12
XFILLER_19_1602 VGND VGND VPWR VPWR sky130_fd_sc_hd__decap_3
XFILLER_208_1353 VPWR VGND VPWR VGND sky130_ef_sc_hd__decap_12
XFILLER_202_139 VGND VGND VPWR VPWR sky130_fd_sc_hd__fill_1
XTAP_TAPCELL_ROW_198_2394 VGND VPWR sky130_fd_sc_hd__tapvpwrvgnd_1
XTAP_TAPCELL_ROW_198_2383 VGND VPWR sky130_fd_sc_hd__tapvpwrvgnd_1
XPHY_EDGE_ROW_128_2_Right_185 VGND VGND VPWR VPWR sky130_fd_sc_hd__decap_3
XTAP_TAPCELL_ROW_17_2_3088 VGND VPWR sky130_fd_sc_hd__tapvpwrvgnd_1
XFILLER_54_1526 VPWR VGND VPWR VGND sky130_ef_sc_hd__decap_12
XFILLER_208_1397 VPWR VGND VPWR VGND sky130_ef_sc_hd__decap_12
XFILLER_204_1217 VPWR VGND VPWR VGND sky130_ef_sc_hd__decap_12
XTAP_TAPCELL_ROW_194_2269 VGND VPWR sky130_fd_sc_hd__tapvpwrvgnd_1
XTAP_TAPCELL_ROW_194_2258 VGND VPWR sky130_fd_sc_hd__tapvpwrvgnd_1
XFILLER_168_533 VPWR VGND VPWR VGND sky130_ef_sc_hd__decap_12
XFILLER_24_65 VGND VGND VPWR VPWR sky130_fd_sc_hd__decap_4
XTAP_TAPCELL_ROW_219_2987 VGND VPWR sky130_fd_sc_hd__tapvpwrvgnd_1
XTAP_TAPCELL_ROW_219_2976 VGND VPWR sky130_fd_sc_hd__tapvpwrvgnd_1
XFILLER_211_673 VPWR VGND VPWR VGND sky130_ef_sc_hd__decap_12
XFILLER_183_503 VGND VGND VPWR VPWR sky130_fd_sc_hd__fill_1
XFILLER_180_1589 VGND VGND VPWR VPWR sky130_fd_sc_hd__decap_6
XFILLER_138_3 VPWR VGND VPWR VGND sky130_ef_sc_hd__decap_12
XTAP_TAPCELL_ROW_219_2998 VGND VPWR sky130_fd_sc_hd__tapvpwrvgnd_1
XFILLER_195_385 VGND VGND VPWR VPWR sky130_fd_sc_hd__decap_6
XFILLER_196_1029 VGND VGND VPWR VPWR sky130_fd_sc_hd__decap_6
XFILLER_178_1441 VPWR VGND VPWR VGND sky130_ef_sc_hd__decap_12
XFILLER_171_709 VPWR VGND VPWR VGND sky130_ef_sc_hd__decap_12
XFILLER_108_121 VGND VGND VPWR VPWR sky130_fd_sc_hd__decap_6
XFILLER_13_1256 VPWR VGND VPWR VGND sky130_ef_sc_hd__decap_12
XFILLER_40_53 VPWR VGND VPWR VGND sky130_ef_sc_hd__decap_12
XFILLER_52_1294 VGND VGND VPWR VPWR sky130_fd_sc_hd__decap_6
XFILLER_156_53 VPWR VGND VPWR VGND sky130_ef_sc_hd__decap_12
XFILLER_40_97 VPWR VGND VPWR VGND sky130_ef_sc_hd__decap_12
XFILLER_178_1485 VPWR VGND VPWR VGND sky130_ef_sc_hd__decap_12
XFILLER_163_293 VPWR VGND VPWR VGND sky130_ef_sc_hd__decap_12
XFILLER_156_97 VPWR VGND VPWR VGND sky130_ef_sc_hd__decap_12
XFILLER_123_113 VPWR VGND VPWR VGND sky130_ef_sc_hd__decap_12
XPHY_EDGE_ROW_108_2_Left_540 VGND VGND VPWR VPWR sky130_fd_sc_hd__decap_3
XFILLER_215_1313 VPWR VGND VPWR VGND sky130_ef_sc_hd__decap_12
XTAP_TAPCELL_ROW_170_1590 VGND VPWR sky130_fd_sc_hd__tapvpwrvgnd_1
XFILLER_3_977 VPWR VGND VPWR VGND sky130_ef_sc_hd__decap_12
XFILLER_2_454 VGND VGND VPWR VPWR sky130_fd_sc_hd__decap_3
XFILLER_215_1357 VPWR VGND VPWR VGND sky130_ef_sc_hd__decap_12
XFILLER_172_1073 VPWR VGND VPWR VGND sky130_ef_sc_hd__decap_12
XFILLER_172_41 VPWR VGND VPWR VGND sky130_ef_sc_hd__decap_12
XTAP_TAPCELL_ROW_26_1_1070 VGND VPWR sky130_fd_sc_hd__tapvpwrvgnd_1
XFILLER_49_84 VPWR VGND VPWR VGND sky130_ef_sc_hd__decap_12
XTAP_TAPCELL_ROW_183_1951 VGND VPWR sky130_fd_sc_hd__tapvpwrvgnd_1
XFILLER_172_85 VPWR VGND VPWR VGND sky130_ef_sc_hd__decap_12
XFILLER_8_1582 VPWR VGND VPWR VGND sky130_ef_sc_hd__decap_12
XFILLER_206_401 VPWR VGND VPWR VGND sky130_ef_sc_hd__decap_12
XFILLER_185_1401 VPWR VGND VPWR VGND sky130_ef_sc_hd__decap_12
XTAP_TAPCELL_ROW_183_1962 VGND VPWR sky130_fd_sc_hd__tapvpwrvgnd_1
XFILLER_150_1382 VPWR VGND VPWR VGND sky130_ef_sc_hd__decap_12
XFILLER_111_1322 VGND VGND VPWR VPWR sky130_fd_sc_hd__decap_6
XFILLER_1_69 VPWR VGND VPWR VGND sky130_ef_sc_hd__decap_12
XFILLER_206_445 VPWR VGND VPWR VGND sky130_ef_sc_hd__decap_12
XFILLER_189_1581 VPWR VGND VPWR VGND sky130_ef_sc_hd__decap_12
XFILLER_111_1366 VPWR VGND VPWR VGND sky130_ef_sc_hd__decap_12
XFILLER_206_489 VPWR VGND VPWR VGND sky130_ef_sc_hd__decap_12
XFILLER_179_809 VPWR VGND VPWR VGND sky130_ef_sc_hd__decap_12
XTAP_TAPCELL_ROW_114_1_1246 VGND VPWR sky130_fd_sc_hd__tapvpwrvgnd_1
XFILLER_187_853 VPWR VGND VPWR VGND sky130_ef_sc_hd__decap_12
X_428_ _108_ _161_ _117_ VGND VGND VPWR VPWR _162_ sky130_fd_sc_hd__a21oi_1
XFILLER_201_161 VGND VGND VPWR VPWR sky130_fd_sc_hd__decap_6
XFILLER_187_897 VPWR VGND VPWR VGND sky130_ef_sc_hd__decap_12
XFILLER_186_363 VGND VGND VPWR VPWR sky130_fd_sc_hd__fill_1
XTAP_TAPCELL_ROW_177_1777 VGND VPWR sky130_fd_sc_hd__tapvpwrvgnd_1
XFILLER_81_93 VPWR VGND VPWR VGND sky130_ef_sc_hd__decap_12
XFILLER_197_93 VPWR VGND VPWR VGND sky130_ef_sc_hd__decap_12
XTAP_TAPCELL_ROW_177_1788 VGND VPWR sky130_fd_sc_hd__tapvpwrvgnd_1
XFILLER_174_525 VGND VGND VPWR VPWR sky130_fd_sc_hd__decap_6
XTAP_TAPCELL_ROW_81_1_1180 VGND VPWR sky130_fd_sc_hd__tapvpwrvgnd_1
XFILLER_70_1350 VGND VGND VPWR VPWR sky130_fd_sc_hd__decap_6
X_359_ _099_ _100_ VGND VGND VPWR VPWR _102_ sky130_fd_sc_hd__or2_2
XTAP_TAPCELL_ROW_62_2_3381 VGND VPWR sky130_fd_sc_hd__tapvpwrvgnd_1
XFILLER_174_569 VPWR VGND VPWR VGND sky130_ef_sc_hd__decap_12
XFILLER_122_1462 VGND VGND VPWR VPWR sky130_fd_sc_hd__decap_6
XFILLER_70_1394 VPWR VGND VPWR VGND sky130_ef_sc_hd__decap_12
XFILLER_196_1541 VPWR VGND VPWR VGND sky130_ef_sc_hd__decap_12
XFILLER_31_1378 VGND VGND VPWR VPWR sky130_fd_sc_hd__decap_6
XFILLER_53_3 VPWR VGND VPWR VGND sky130_ef_sc_hd__decap_12
XFILLER_192_1427 VGND VGND VPWR VPWR sky130_fd_sc_hd__fill_1
XFILLER_5_281 VGND VGND VPWR VPWR sky130_fd_sc_hd__decap_6
XFILLER_6_793 VPWR VGND VPWR VGND sky130_ef_sc_hd__decap_12
XFILLER_29_1274 VPWR VGND VPWR VGND sky130_ef_sc_hd__decap_12
XTAP_TAPCELL_ROW_54_2_3329 VGND VPWR sky130_fd_sc_hd__tapvpwrvgnd_1
XFILLER_190_1173 VPWR VGND VPWR VGND sky130_ef_sc_hd__decap_12
XFILLER_116_1244 VGND VGND VPWR VPWR sky130_fd_sc_hd__fill_1
XFILLER_81_1490 VGND VGND VPWR VPWR sky130_fd_sc_hd__decap_6
Xinput2 bist_start VGND VGND VPWR VPWR net2 sky130_fd_sc_hd__buf_1
XFILLER_216_209 VPWR VGND VPWR VGND sky130_ef_sc_hd__decap_12
XFILLER_209_261 VPWR VGND VPWR VGND sky130_ef_sc_hd__decap_12
XFILLER_188_1091 VGND VGND VPWR VPWR sky130_fd_sc_hd__fill_1
XFILLER_101_15 VPWR VGND VPWR VGND sky130_ef_sc_hd__decap_12
XFILLER_51_111 VGND VGND VPWR VPWR sky130_fd_sc_hd__fill_1
XFILLER_197_617 VPWR VGND VPWR VGND sky130_ef_sc_hd__decap_12
XFILLER_162_1220 VPWR VGND VPWR VGND sky130_ef_sc_hd__decap_12
XFILLER_75_1272 VGND VGND VPWR VPWR sky130_fd_sc_hd__fill_1
XFILLER_205_1537 VPWR VGND VPWR VGND sky130_ef_sc_hd__decap_12
XFILLER_165_503 VGND VGND VPWR VPWR sky130_fd_sc_hd__fill_1
XFILLER_127_1384 VGND VGND VPWR VPWR sky130_fd_sc_hd__fill_1
XPHY_EDGE_ROW_48_1_Right_634 VGND VGND VPWR VPWR sky130_fd_sc_hd__decap_3
XFILLER_177_385 VGND VGND VPWR VPWR sky130_fd_sc_hd__decap_6
XTAP_TAPCELL_ROW_214_2840 VGND VPWR sky130_fd_sc_hd__tapvpwrvgnd_1
XFILLER_193_889 VGND VGND VPWR VPWR sky130_fd_sc_hd__decap_6
XFILLER_192_333 VPWR VGND VPWR VGND sky130_ef_sc_hd__decap_12
XFILLER_140_1562 VPWR VGND VPWR VGND sky130_ef_sc_hd__decap_12
XFILLER_4_708 VGND VGND VPWR VPWR sky130_fd_sc_hd__decap_3
XTAP_TAPCELL_ROW_214_2851 VGND VPWR sky130_fd_sc_hd__tapvpwrvgnd_1
XTAP_TAPCELL_ROW_210_2715 VGND VPWR sky130_fd_sc_hd__tapvpwrvgnd_1
XFILLER_192_377 VPWR VGND VPWR VGND sky130_ef_sc_hd__decap_12
XFILLER_101_1546 VGND VGND VPWR VPWR sky130_fd_sc_hd__decap_6
XFILLER_4_719 VGND VGND VPWR VPWR sky130_fd_sc_hd__decap_8
XTAP_TAPCELL_ROW_210_2737 VGND VPWR sky130_fd_sc_hd__tapvpwrvgnd_1
XTAP_TAPCELL_ROW_210_2726 VGND VPWR sky130_fd_sc_hd__tapvpwrvgnd_1
XFILLER_105_113 VPWR VGND VPWR VGND sky130_ef_sc_hd__decap_12
XTAP_TAPCELL_ROW_151_2_3957 VGND VPWR sky130_fd_sc_hd__tapvpwrvgnd_1
XFILLER_47_1330 VPWR VGND VPWR VGND sky130_ef_sc_hd__decap_12
XTAP_TAPCELL_ROW_187_2073 VGND VPWR sky130_fd_sc_hd__tapvpwrvgnd_1
XTAP_TAPCELL_ROW_187_2062 VGND VPWR sky130_fd_sc_hd__tapvpwrvgnd_1
XFILLER_134_1300 VGND VGND VPWR VPWR sky130_fd_sc_hd__fill_1
XFILLER_86_27 VGND VGND VPWR VPWR sky130_fd_sc_hd__fill_1
XFILLER_82_1232 VPWR VGND VPWR VGND sky130_ef_sc_hd__decap_12
XPHY_EDGE_ROW_40_2_Right_97 VGND VGND VPWR VPWR sky130_fd_sc_hd__decap_3
XFILLER_173_1393 VGND VGND VPWR VPWR sky130_fd_sc_hd__decap_6
XTAP_TAPCELL_ROW_208_2666 VGND VPWR sky130_fd_sc_hd__tapvpwrvgnd_1
XTAP_TAPCELL_ROW_208_2655 VGND VPWR sky130_fd_sc_hd__tapvpwrvgnd_1
XTAP_TAPCELL_ROW_208_2677 VGND VPWR sky130_fd_sc_hd__tapvpwrvgnd_1
XFILLER_60_1574 VGND VGND VPWR VPWR sky130_fd_sc_hd__decap_6
XFILLER_142_77 VGND VGND VPWR VPWR sky130_fd_sc_hd__decap_6
XTAP_TAPCELL_ROW_98_2_3616 VGND VPWR sky130_fd_sc_hd__tapvpwrvgnd_1
XFILLER_204_905 VPWR VGND VPWR VGND sky130_ef_sc_hd__decap_12
XFILLER_204_949 VPWR VGND VPWR VGND sky130_ef_sc_hd__decap_12
XFILLER_187_105 VGND VGND VPWR VPWR sky130_fd_sc_hd__decap_6
XFILLER_167_1175 VGND VGND VPWR VPWR sky130_fd_sc_hd__fill_1
XFILLER_19_1410 VPWR VGND VPWR VGND sky130_ef_sc_hd__decap_12
XFILLER_58_1470 VPWR VGND VPWR VGND sky130_ef_sc_hd__decap_12
XFILLER_208_1161 VPWR VGND VPWR VGND sky130_ef_sc_hd__decap_12
XFILLER_187_149 VPWR VGND VPWR VGND sky130_ef_sc_hd__decap_12
XFILLER_169_853 VPWR VGND VPWR VGND sky130_ef_sc_hd__decap_12
XFILLER_145_1440 VGND VGND VPWR VPWR sky130_fd_sc_hd__fill_1
XFILLER_19_1454 VPWR VGND VPWR VGND sky130_ef_sc_hd__decap_12
XFILLER_212_993 VPWR VGND VPWR VGND sky130_ef_sc_hd__decap_12
XFILLER_180_1353 VPWR VGND VPWR VGND sky130_ef_sc_hd__decap_12
XFILLER_168_363 VGND VGND VPWR VPWR sky130_fd_sc_hd__fill_1
XPHY_EDGE_ROW_129_2_Right_186 VGND VGND VPWR VPWR sky130_fd_sc_hd__decap_3
XFILLER_19_1498 VPWR VGND VPWR VGND sky130_ef_sc_hd__decap_12
XTAP_TAPCELL_ROW_47_2_3283 VGND VPWR sky130_fd_sc_hd__tapvpwrvgnd_1
XFILLER_54_1356 VGND VGND VPWR VPWR sky130_fd_sc_hd__fill_1
XFILLER_180_1397 VPWR VGND VPWR VGND sky130_ef_sc_hd__decap_12
XFILLER_169_897 VPWR VGND VPWR VGND sky130_ef_sc_hd__decap_12
XFILLER_106_1468 VGND VGND VPWR VPWR sky130_fd_sc_hd__fill_1
XFILLER_195_193 VPWR VGND VPWR VGND sky130_ef_sc_hd__decap_12
XFILLER_184_867 VGND VGND VPWR VPWR sky130_fd_sc_hd__fill_1
XTAP_TAPCELL_ROW_172_1630 VGND VPWR sky130_fd_sc_hd__tapvpwrvgnd_1
XFILLER_7_557 VGND VGND VPWR VPWR sky130_fd_sc_hd__decap_3
XTAP_TAPCELL_ROW_172_1652 VGND VPWR sky130_fd_sc_hd__tapvpwrvgnd_1
XTAP_TAPCELL_ROW_172_1641 VGND VPWR sky130_fd_sc_hd__tapvpwrvgnd_1
XFILLER_171_517 VPWR VGND VPWR VGND sky130_ef_sc_hd__decap_12
XPHY_EDGE_ROW_25_1_Left_244 VGND VGND VPWR VPWR sky130_fd_sc_hd__decap_3
XFILLER_139_1244 VPWR VGND VPWR VGND sky130_ef_sc_hd__decap_12
XFILLER_183_51 VGND VGND VPWR VPWR sky130_fd_sc_hd__decap_4
XTAP_TAPCELL_ROW_40_2_3237 VGND VPWR sky130_fd_sc_hd__tapvpwrvgnd_1
XFILLER_215_1121 VPWR VGND VPWR VGND sky130_ef_sc_hd__decap_12
XFILLER_156_1580 VGND VGND VPWR VPWR sky130_fd_sc_hd__fill_1
XFILLER_111_105 VGND VGND VPWR VPWR sky130_fd_sc_hd__decap_6
XFILLER_3_785 VGND VGND VPWR VPWR sky130_fd_sc_hd__fill_1
XFILLER_2_251 VGND VGND VPWR VPWR sky130_fd_sc_hd__fill_1
XPHY_EDGE_ROW_10_1_Right_596 VGND VGND VPWR VPWR sky130_fd_sc_hd__decap_3
XFILLER_26_1414 VPWR VGND VPWR VGND sky130_ef_sc_hd__decap_12
XFILLER_191_1493 VPWR VGND VPWR VGND sky130_ef_sc_hd__decap_12
XFILLER_65_1496 VGND VGND VPWR VPWR sky130_fd_sc_hd__fill_1
XTAP_TAPCELL_ROW_57_1_1131 VGND VPWR sky130_fd_sc_hd__tapvpwrvgnd_1
XFILLER_211_1007 VGND VGND VPWR VPWR sky130_fd_sc_hd__fill_1
XTAP_TAPCELL_ROW_166_1478 VGND VPWR sky130_fd_sc_hd__tapvpwrvgnd_1
XTAP_TAPCELL_ROW_166_1467 VGND VPWR sky130_fd_sc_hd__tapvpwrvgnd_1
XFILLER_207_721 VGND VGND VPWR VPWR sky130_fd_sc_hd__decap_6
XFILLER_207_765 VPWR VGND VPWR VGND sky130_ef_sc_hd__decap_12
XFILLER_206_253 VPWR VGND VPWR VGND sky130_ef_sc_hd__decap_12
XFILLER_185_1231 VGND VGND VPWR VPWR sky130_fd_sc_hd__fill_1
XFILLER_98_1294 VGND VGND VPWR VPWR sky130_fd_sc_hd__decap_6
XFILLER_59_1256 VPWR VGND VPWR VGND sky130_ef_sc_hd__decap_12
XFILLER_179_617 VPWR VGND VPWR VGND sky130_ef_sc_hd__decap_12
XTAP_TAPCELL_ROW_179_1828 VGND VPWR sky130_fd_sc_hd__tapvpwrvgnd_1
XTAP_TAPCELL_ROW_145_1_1307 VGND VPWR sky130_fd_sc_hd__tapvpwrvgnd_1
XFILLER_37_1510 VPWR VGND VPWR VGND sky130_ef_sc_hd__decap_12
XTAP_TAPCELL_ROW_179_1839 VGND VPWR sky130_fd_sc_hd__tapvpwrvgnd_1
XFILLER_72_1412 VGND VGND VPWR VPWR sky130_fd_sc_hd__fill_1
XFILLER_37_1554 VPWR VGND VPWR VGND sky130_ef_sc_hd__decap_12
XTAP_TAPCELL_ROW_50_1_1118 VGND VPWR sky130_fd_sc_hd__tapvpwrvgnd_1
XFILLER_124_1524 VGND VGND VPWR VPWR sky130_fd_sc_hd__fill_1
XFILLER_174_333 VPWR VGND VPWR VGND sky130_ef_sc_hd__decap_12
XFILLER_190_837 VPWR VGND VPWR VGND sky130_ef_sc_hd__decap_12
XFILLER_179_1057 VGND VGND VPWR VPWR sky130_fd_sc_hd__decap_6
XFILLER_175_889 VGND VGND VPWR VPWR sky130_fd_sc_hd__decap_6
XFILLER_174_377 VPWR VGND VPWR VGND sky130_ef_sc_hd__decap_12
XFILLER_122_1270 VPWR VGND VPWR VGND sky130_ef_sc_hd__decap_12
XFILLER_196_1371 VGND VGND VPWR VPWR sky130_fd_sc_hd__fill_1
XFILLER_157_1322 VGND VGND VPWR VPWR sky130_fd_sc_hd__decap_6
XTAP_TAPCELL_ROW_136_2_3859 VGND VPWR sky130_fd_sc_hd__tapvpwrvgnd_1
XFILLER_157_1366 VPWR VGND VPWR VGND sky130_ef_sc_hd__decap_12
XFILLER_83_1552 VGND VGND VPWR VPWR sky130_fd_sc_hd__fill_1
XFILLER_170_1533 VGND VGND VPWR VPWR sky130_fd_sc_hd__decap_6
XTAP_TAPCELL_ROW_116_2_3735 VGND VPWR sky130_fd_sc_hd__tapvpwrvgnd_1
XFILLER_170_1577 VPWR VGND VPWR VGND sky130_ef_sc_hd__decap_12
XPHY_EDGE_ROW_71_1_Left_290 VGND VGND VPWR VPWR sky130_fd_sc_hd__decap_3
XFILLER_5_1007 VGND VGND VPWR VPWR sky130_fd_sc_hd__fill_1
XFILLER_217_529 VPWR VGND VPWR VGND sky130_ef_sc_hd__decap_12
XTAP_TAPCELL_ROW_84_2_3524 VGND VPWR sky130_fd_sc_hd__tapvpwrvgnd_1
XFILLER_186_1017 VPWR VGND VPWR VGND sky130_ef_sc_hd__decap_12
XFILLER_42_1282 VPWR VGND VPWR VGND sky130_ef_sc_hd__decap_12
XTAP_TAPCELL_ROW_203_2530 VGND VPWR sky130_fd_sc_hd__tapvpwrvgnd_1
XTAP_TAPCELL_ROW_0_755 VGND VPWR sky130_fd_sc_hd__tapvpwrvgnd_1
XFILLER_198_937 VPWR VGND VPWR VGND sky130_ef_sc_hd__decap_12
XFILLER_169_105 VGND VGND VPWR VPWR sky130_fd_sc_hd__decap_6
XFILLER_164_1315 VGND VGND VPWR VPWR sky130_fd_sc_hd__fill_1
XFILLER_77_1378 VGND VGND VPWR VPWR sky130_fd_sc_hd__decap_6
XFILLER_72_29 VPWR VGND VPWR VGND sky130_ef_sc_hd__decap_12
XTAP_TAPCELL_ROW_0_788 VGND VPWR sky130_fd_sc_hd__tapvpwrvgnd_1
XTAP_TAPCELL_ROW_0_777 VGND VPWR sky130_fd_sc_hd__tapvpwrvgnd_1
XTAP_TAPCELL_ROW_0_766 VGND VPWR sky130_fd_sc_hd__tapvpwrvgnd_1
XFILLER_20_1580 VGND VGND VPWR VPWR sky130_fd_sc_hd__fill_1
XFILLER_212_245 VGND VGND VPWR VPWR sky130_fd_sc_hd__decap_6
XFILLER_205_1301 VPWR VGND VPWR VGND sky130_ef_sc_hd__decap_12
XFILLER_197_447 VGND VGND VPWR VPWR sky130_fd_sc_hd__fill_1
XFILLER_188_29 VPWR VGND VPWR VGND sky130_ef_sc_hd__decap_12
XFILLER_169_149 VPWR VGND VPWR VGND sky130_ef_sc_hd__decap_12
XTAP_TAPCELL_ROW_0_799 VGND VPWR sky130_fd_sc_hd__tapvpwrvgnd_1
XTAP_TAPCELL_ROW_33_2_3191 VGND VPWR sky130_fd_sc_hd__tapvpwrvgnd_1
XFILLER_212_289 VPWR VGND VPWR VGND sky130_ef_sc_hd__decap_12
XFILLER_209_1481 VPWR VGND VPWR VGND sky130_ef_sc_hd__decap_12
XFILLER_185_609 VGND VGND VPWR VPWR sky130_fd_sc_hd__decap_6
XFILLER_142_1602 VGND VGND VPWR VPWR sky130_fd_sc_hd__decap_3
XPHY_EDGE_ROW_90_1_Left_309 VGND VGND VPWR VPWR sky130_fd_sc_hd__decap_3
XTAP_TAPCELL_ROW_216_2902 VGND VPWR sky130_fd_sc_hd__tapvpwrvgnd_1
XFILLER_205_1345 VPWR VGND VPWR VGND sky130_ef_sc_hd__decap_12
XFILLER_197_1113 VGND VGND VPWR VPWR sky130_fd_sc_hd__decap_6
XFILLER_193_653 VPWR VGND VPWR VGND sky130_ef_sc_hd__decap_12
XFILLER_177_193 VPWR VGND VPWR VGND sky130_ef_sc_hd__decap_12
XFILLER_166_867 VGND VGND VPWR VPWR sky130_fd_sc_hd__fill_1
XPHY_EDGE_ROW_49_1_Right_635 VGND VGND VPWR VPWR sky130_fd_sc_hd__decap_3
XFILLER_197_1157 VPWR VGND VPWR VGND sky130_ef_sc_hd__decap_12
XFILLER_193_697 VPWR VGND VPWR VGND sky130_ef_sc_hd__decap_12
XFILLER_192_141 VPWR VGND VPWR VGND sky130_ef_sc_hd__decap_12
XFILLER_140_1370 VPWR VGND VPWR VGND sky130_ef_sc_hd__decap_12
XFILLER_105_1490 VGND VGND VPWR VPWR sky130_fd_sc_hd__decap_6
XFILLER_101_1310 VPWR VGND VPWR VGND sky130_ef_sc_hd__decap_12
XTAP_TAPCELL_ROW_189_2135 VGND VPWR sky130_fd_sc_hd__tapvpwrvgnd_1
XTAP_TAPCELL_ROW_189_2124 VGND VPWR sky130_fd_sc_hd__tapvpwrvgnd_1
XTAP_TAPCELL_ROW_189_2113 VGND VPWR sky130_fd_sc_hd__tapvpwrvgnd_1
XFILLER_137_55 VGND VGND VPWR VPWR sky130_fd_sc_hd__fill_1
XFILLER_101_1354 VPWR VGND VPWR VGND sky130_ef_sc_hd__decap_12
XFILLER_4_549 VGND VGND VPWR VPWR sky130_fd_sc_hd__fill_1
XTAP_TAPCELL_ROW_25_2_3139 VGND VPWR sky130_fd_sc_hd__tapvpwrvgnd_1
XFILLER_175_1455 VGND VGND VPWR VPWR sky130_fd_sc_hd__fill_1
XFILLER_136_1406 VGND VGND VPWR VPWR sky130_fd_sc_hd__decap_6
XFILLER_101_1398 VPWR VGND VPWR VGND sky130_ef_sc_hd__decap_12
XFILLER_97_15 VPWR VGND VPWR VGND sky130_ef_sc_hd__decap_12
XFILLER_84_1338 VPWR VGND VPWR VGND sky130_ef_sc_hd__decap_12
XFILLER_216_1441 VPWR VGND VPWR VGND sky130_ef_sc_hd__decap_12
XTAP_TAPCELL_ROW_138_1_1294 VGND VPWR sky130_fd_sc_hd__tapvpwrvgnd_1
XFILLER_216_1485 VPWR VGND VPWR VGND sky130_ef_sc_hd__decap_12
XFILLER_112_1450 VPWR VGND VPWR VGND sky130_ef_sc_hd__decap_12
XFILLER_21_1322 VGND VGND VPWR VPWR sky130_fd_sc_hd__decap_6
XFILLER_46_41 VPWR VGND VPWR VGND sky130_ef_sc_hd__decap_12
XFILLER_60_1382 VPWR VGND VPWR VGND sky130_ef_sc_hd__decap_12
XFILLER_210_1073 VPWR VGND VPWR VGND sky130_ef_sc_hd__decap_12
XFILLER_112_1494 VPWR VGND VPWR VGND sky130_ef_sc_hd__decap_12
XFILLER_95_1434 VGND VGND VPWR VPWR sky130_fd_sc_hd__decap_6
XFILLER_1_1449 VGND VGND VPWR VPWR sky130_fd_sc_hd__decap_6
XFILLER_21_1366 VPWR VGND VPWR VGND sky130_ef_sc_hd__decap_12
XFILLER_46_85 VPWR VGND VPWR VGND sky130_ef_sc_hd__decap_12
XFILLER_204_713 VPWR VGND VPWR VGND sky130_ef_sc_hd__decap_12
XFILLER_186_1595 VGND VGND VPWR VPWR sky130_fd_sc_hd__fill_1
XFILLER_147_1546 VGND VGND VPWR VPWR sky130_fd_sc_hd__decap_6
XFILLER_95_1478 VPWR VGND VPWR VGND sky130_ef_sc_hd__decap_12
XFILLER_204_757 VPWR VGND VPWR VGND sky130_ef_sc_hd__decap_12
XFILLER_203_223 VGND VGND VPWR VPWR sky130_fd_sc_hd__fill_1
XFILLER_188_469 VGND VGND VPWR VPWR sky130_fd_sc_hd__decap_6
XFILLER_180_1161 VPWR VGND VPWR VGND sky130_ef_sc_hd__decap_12
XTAP_TAPCELL_ROW_174_1703 VGND VPWR sky130_fd_sc_hd__tapvpwrvgnd_1
XFILLER_106_1232 VPWR VGND VPWR VGND sky130_ef_sc_hd__decap_12
XFILLER_7_321 VPWR VGND VPWR VGND sky130_ef_sc_hd__decap_12
XFILLER_172_837 VPWR VGND VPWR VGND sky130_ef_sc_hd__decap_12
XFILLER_123_1590 VPWR VGND VPWR VGND sky130_ef_sc_hd__decap_12
XFILLER_7_365 VGND VGND VPWR VPWR sky130_fd_sc_hd__decap_6
XANTENNA__414__A b_addr\[5\] VGND VGND VPWR VPWR sky130_fd_sc_hd__diode_2
XFILLER_32_1462 VGND VGND VPWR VPWR sky130_fd_sc_hd__decap_6
XFILLER_193_1511 VGND VGND VPWR VPWR sky130_fd_sc_hd__fill_1
XANTENNA__503__A1 net151 VGND VGND VPWR VPWR sky130_fd_sc_hd__diode_2
XFILLER_194_83 VGND VGND VPWR VPWR sky130_fd_sc_hd__fill_1
XFILLER_154_1506 VPWR VGND VPWR VGND sky130_ef_sc_hd__decap_12
XFILLER_180_881 VPWR VGND VPWR VGND sky130_ef_sc_hd__decap_12
XTAP_TAPCELL_ROW_102_2_3643 VGND VPWR sky130_fd_sc_hd__tapvpwrvgnd_1
XFILLER_97_125 VGND VGND VPWR VPWR sky130_fd_sc_hd__fill_2
XTAP_TAPCELL_ROW_168_1529 VGND VPWR sky130_fd_sc_hd__tapvpwrvgnd_1
XTAP_TAPCELL_ROW_168_1518 VGND VPWR sky130_fd_sc_hd__tapvpwrvgnd_1
XPHY_EDGE_ROW_11_1_Right_597 VGND VGND VPWR VPWR sky130_fd_sc_hd__decap_3
XFILLER_87_81 VPWR VGND VPWR VGND sky130_ef_sc_hd__decap_12
XTAP_TAPCELL_ROW_70_2_3432 VGND VPWR sky130_fd_sc_hd__tapvpwrvgnd_1
XTAP_TAPCELL_ROW_69_2_3426 VGND VPWR sky130_fd_sc_hd__tapvpwrvgnd_1
XFILLER_26_1244 VGND VGND VPWR VPWR sky130_fd_sc_hd__fill_1
XFILLER_16_3 VPWR VGND VPWR VGND sky130_ef_sc_hd__decap_12
XFILLER_213_57 VPWR VGND VPWR VGND sky130_ef_sc_hd__decap_12
XFILLER_187_1337 VGND VGND VPWR VPWR sky130_fd_sc_hd__decap_6
XFILLER_130_1550 VPWR VGND VPWR VGND sky130_ef_sc_hd__decap_12
XFILLER_130_1594 VGND VGND VPWR VPWR sky130_fd_sc_hd__decap_8
XFILLER_4_1073 VPWR VGND VPWR VGND sky130_ef_sc_hd__decap_12
XFILLER_207_573 VPWR VGND VPWR VGND sky130_ef_sc_hd__decap_12
XFILLER_74_1518 VGND VGND VPWR VPWR sky130_fd_sc_hd__decap_6
XFILLER_179_447 VGND VGND VPWR VPWR sky130_fd_sc_hd__fill_1
XTAP_TAPCELL_ROW_18_2_3093 VGND VPWR sky130_fd_sc_hd__tapvpwrvgnd_1
XFILLER_21_103 VGND VGND VPWR VPWR sky130_fd_sc_hd__fill_1
XFILLER_167_609 VGND VGND VPWR VPWR sky130_fd_sc_hd__decap_6
XFILLER_72_1220 VPWR VGND VPWR VGND sky130_ef_sc_hd__decap_12
XFILLER_21_125 VGND VGND VPWR VPWR sky130_fd_sc_hd__fill_2
XFILLER_210_749 VGND VGND VPWR VPWR sky130_fd_sc_hd__decap_6
XFILLER_188_981 VPWR VGND VPWR VGND sky130_ef_sc_hd__decap_12
XFILLER_37_1384 VGND VGND VPWR VPWR sky130_fd_sc_hd__fill_1
XFILLER_175_653 VPWR VGND VPWR VGND sky130_ef_sc_hd__decap_12
XFILLER_190_601 VPWR VGND VPWR VGND sky130_ef_sc_hd__decap_12
XFILLER_175_697 VPWR VGND VPWR VGND sky130_ef_sc_hd__decap_12
XFILLER_174_141 VPWR VGND VPWR VGND sky130_ef_sc_hd__decap_12
XFILLER_163_837 VGND VGND VPWR VPWR sky130_fd_sc_hd__decap_3
XFILLER_50_1562 VPWR VGND VPWR VGND sky130_ef_sc_hd__decap_12
XFILLER_200_1253 VGND VGND VPWR VPWR sky130_fd_sc_hd__decap_6
XFILLER_198_1477 VGND VGND VPWR VPWR sky130_fd_sc_hd__decap_6
XFILLER_190_645 VPWR VGND VPWR VGND sky130_ef_sc_hd__decap_12
XTAP_TAPCELL_ROW_11_2_3047 VGND VPWR sky130_fd_sc_hd__tapvpwrvgnd_1
XFILLER_11_1546 VGND VGND VPWR VPWR sky130_fd_sc_hd__decap_6
XFILLER_200_1297 VPWR VGND VPWR VGND sky130_ef_sc_hd__decap_12
XFILLER_107_69 VPWR VGND VPWR VGND sky130_ef_sc_hd__decap_12
XFILLER_44_1300 VGND VGND VPWR VPWR sky130_fd_sc_hd__fill_1
XFILLER_170_1341 VPWR VGND VPWR VGND sky130_ef_sc_hd__decap_12
XFILLER_218_805 VGND VGND VPWR VPWR sky130_fd_sc_hd__decap_6
XFILLER_170_1385 VPWR VGND VPWR VGND sky130_ef_sc_hd__decap_12
XTAP_TAPCELL_ROW_161_2_4025 VGND VPWR sky130_fd_sc_hd__tapvpwrvgnd_1
XTAP_TAPCELL_ROW_146_2_3930 VGND VPWR sky130_fd_sc_hd__tapvpwrvgnd_1
XFILLER_218_849 VPWR VGND VPWR VGND sky130_ef_sc_hd__decap_12
XFILLER_217_337 VPWR VGND VPWR VGND sky130_ef_sc_hd__decap_12
XFILLER_123_57 VPWR VGND VPWR VGND sky130_ef_sc_hd__decap_12
XFILLER_211_1393 VGND VGND VPWR VPWR sky130_fd_sc_hd__decap_6
XFILLER_83_39 VPWR VGND VPWR VGND sky130_ef_sc_hd__decap_12
XFILLER_199_39 VPWR VGND VPWR VGND sky130_ef_sc_hd__decap_12
XFILLER_198_701 VPWR VGND VPWR VGND sky130_ef_sc_hd__decap_12
XFILLER_129_1232 VPWR VGND VPWR VGND sky130_ef_sc_hd__decap_12
XANTENNA__430__B1 net157 VGND VGND VPWR VPWR sky130_fd_sc_hd__diode_2
XFILLER_201_727 VGND VGND VPWR VPWR sky130_fd_sc_hd__fill_1
XFILLER_129_1298 VPWR VGND VPWR VGND sky130_ef_sc_hd__decap_12
XFILLER_12_125 VGND VGND VPWR VPWR sky130_fd_sc_hd__fill_2
XTAP_TAPCELL_ROW_19_1_1056 VGND VPWR sky130_fd_sc_hd__tapvpwrvgnd_1
XFILLER_55_1440 VGND VGND VPWR VPWR sky130_fd_sc_hd__fill_1
XFILLER_185_417 VPWR VGND VPWR VGND sky130_ef_sc_hd__decap_12
XFILLER_181_1481 VPWR VGND VPWR VGND sky130_ef_sc_hd__decap_12
XFILLER_107_1552 VGND VGND VPWR VPWR sky130_fd_sc_hd__fill_1
XFILLER_205_1175 VGND VGND VPWR VPWR sky130_fd_sc_hd__fill_1
XFILLER_16_1468 VGND VGND VPWR VPWR sky130_fd_sc_hd__fill_1
XFILLER_218_3 VPWR VGND VPWR VGND sky130_ef_sc_hd__decap_12
XFILLER_194_973 VGND VGND VPWR VPWR sky130_fd_sc_hd__decap_6
XFILLER_193_461 VPWR VGND VPWR VGND sky130_ef_sc_hd__decap_12
XFILLER_148_65 VPWR VGND VPWR VGND sky130_ef_sc_hd__decap_12
XFILLER_120_3 VPWR VGND VPWR VGND sky130_ef_sc_hd__decap_12
XFILLER_180_133 VGND VGND VPWR VPWR sky130_fd_sc_hd__decap_6
XFILLER_88_1282 VPWR VGND VPWR VGND sky130_ef_sc_hd__decap_12
XANTENNA__497__B1 net138 VGND VGND VPWR VPWR sky130_fd_sc_hd__diode_2
XFILLER_5_869 VPWR VGND VPWR VGND sky130_ef_sc_hd__decap_12
XFILLER_49_1244 VPWR VGND VPWR VGND sky130_ef_sc_hd__decap_12
XFILLER_180_177 VPWR VGND VPWR VGND sky130_ef_sc_hd__decap_12
XPHY_EDGE_ROW_170_Right_15 VGND VGND VPWR VPWR sky130_fd_sc_hd__decap_3
XFILLER_164_53 VPWR VGND VPWR VGND sky130_ef_sc_hd__decap_12
XFILLER_136_1258 VPWR VGND VPWR VGND sky130_ef_sc_hd__decap_12
XFILLER_79_125 VGND VGND VPWR VPWR sky130_fd_sc_hd__fill_2
XFILLER_66_1580 VGND VGND VPWR VPWR sky130_fd_sc_hd__fill_1
XANTENNA_input40_A func_wdata[6] VGND VGND VPWR VPWR sky130_fd_sc_hd__diode_2
XTAP_TAPCELL_ROW_55_2_3334 VGND VPWR sky130_fd_sc_hd__tapvpwrvgnd_1
XFILLER_164_97 VPWR VGND VPWR VGND sky130_ef_sc_hd__decap_12
XTAP_TAPCELL_ROW_74_1_1166 VGND VPWR sky130_fd_sc_hd__tapvpwrvgnd_1
XFILLER_0_585 VGND VGND VPWR VPWR sky130_fd_sc_hd__fill_1
XFILLER_180_41 VPWR VGND VPWR VGND sky130_ef_sc_hd__decap_12
XFILLER_169_1001 VGND VGND VPWR VPWR sky130_fd_sc_hd__decap_6
XFILLER_180_85 VPWR VGND VPWR VGND sky130_ef_sc_hd__decap_12
XFILLER_169_1045 VPWR VGND VPWR VGND sky130_ef_sc_hd__decap_12
XFILLER_1_1213 VPWR VGND VPWR VGND sky130_ef_sc_hd__decap_12
XFILLER_5_1393 VGND VGND VPWR VPWR sky130_fd_sc_hd__decap_6
XFILLER_169_1089 VPWR VGND VPWR VGND sky130_ef_sc_hd__decap_12
XFILLER_147_1310 VPWR VGND VPWR VGND sky130_ef_sc_hd__decap_12
XFILLER_95_1220 VPWR VGND VPWR VGND sky130_ef_sc_hd__decap_12
XFILLER_1_1257 VPWR VGND VPWR VGND sky130_ef_sc_hd__decap_12
XFILLER_147_1354 VPWR VGND VPWR VGND sky130_ef_sc_hd__decap_12
XFILLER_95_1286 VPWR VGND VPWR VGND sky130_ef_sc_hd__decap_12
XPHY_EDGE_ROW_49_2_Left_481 VGND VGND VPWR VPWR sky130_fd_sc_hd__decap_3
XFILLER_204_587 VGND VGND VPWR VPWR sky130_fd_sc_hd__fill_1
XFILLER_188_233 VPWR VGND VPWR VGND sky130_ef_sc_hd__decap_12
XFILLER_108_1338 VPWR VGND VPWR VGND sky130_ef_sc_hd__decap_12
XFILLER_188_277 VPWR VGND VPWR VGND sky130_ef_sc_hd__decap_12
XFILLER_147_1398 VPWR VGND VPWR VGND sky130_ef_sc_hd__decap_12
XFILLER_34_1524 VGND VGND VPWR VPWR sky130_fd_sc_hd__fill_1
XFILLER_185_951 VGND VGND VPWR VPWR sky130_fd_sc_hd__fill_1
XFILLER_200_793 VPWR VGND VPWR VGND sky130_ef_sc_hd__decap_12
XFILLER_172_601 VPWR VGND VPWR VGND sky130_ef_sc_hd__decap_12
XFILLER_176_1005 VPWR VGND VPWR VGND sky130_ef_sc_hd__decap_12
XFILLER_172_645 VPWR VGND VPWR VGND sky130_ef_sc_hd__decap_12
XFILLER_171_111 VGND VGND VPWR VPWR sky130_fd_sc_hd__fill_1
XFILLER_32_1270 VPWR VGND VPWR VGND sky130_ef_sc_hd__decap_12
XFILLER_176_1049 VPWR VGND VPWR VGND sky130_ef_sc_hd__decap_12
XFILLER_158_1450 VPWR VGND VPWR VGND sky130_ef_sc_hd__decap_12
XFILLER_67_1322 VGND VGND VPWR VPWR sky130_fd_sc_hd__decap_6
XFILLER_154_1314 VPWR VGND VPWR VGND sky130_ef_sc_hd__decap_12
XFILLER_119_1434 VGND VGND VPWR VPWR sky130_fd_sc_hd__decap_6
XFILLER_67_1366 VPWR VGND VPWR VGND sky130_ef_sc_hd__decap_12
XFILLER_217_1057 VGND VGND VPWR VPWR sky130_fd_sc_hd__decap_6
XFILLER_158_1494 VPWR VGND VPWR VGND sky130_ef_sc_hd__decap_12
XFILLER_154_1358 VPWR VGND VPWR VGND sky130_ef_sc_hd__decap_12
XFILLER_119_1478 VPWR VGND VPWR VGND sky130_ef_sc_hd__decap_12
XPHY_EDGE_ROW_12_1_Right_598 VGND VGND VPWR VPWR sky130_fd_sc_hd__decap_3
XANTENNA__587__Q b_addr\[3\] VGND VGND VPWR VPWR sky130_fd_sc_hd__diode_2
XFILLER_187_1101 VPWR VGND VPWR VGND sky130_ef_sc_hd__decap_12
XTAP_TAPCELL_ROW_99_2_3621 VGND VPWR sky130_fd_sc_hd__tapvpwrvgnd_1
XTAP_TAPCELL_ROW_2_839 VGND VPWR sky130_fd_sc_hd__tapvpwrvgnd_1
XFILLER_187_1145 VPWR VGND VPWR VGND sky130_ef_sc_hd__decap_12
XFILLER_214_307 VGND VGND VPWR VPWR sky130_fd_sc_hd__fill_1
XFILLER_208_893 VPWR VGND VPWR VGND sky130_ef_sc_hd__decap_12
XFILLER_187_1189 VPWR VGND VPWR VGND sky130_ef_sc_hd__decap_12
XFILLER_183_1009 VPWR VGND VPWR VGND sky130_ef_sc_hd__decap_12
XFILLER_78_1462 VGND VGND VPWR VPWR sky130_fd_sc_hd__decap_6
XPHY_EDGE_ROW_102_1_Left_321 VGND VGND VPWR VPWR sky130_fd_sc_hd__decap_3
XFILLER_74_1326 VPWR VGND VPWR VGND sky130_ef_sc_hd__decap_12
XFILLER_210_513 VPWR VGND VPWR VGND sky130_ef_sc_hd__decap_12
XFILLER_126_1438 VPWR VGND VPWR VGND sky130_ef_sc_hd__decap_12
XFILLER_167_417 VPWR VGND VPWR VGND sky130_ef_sc_hd__decap_12
XFILLER_52_1602 VGND VGND VPWR VPWR sky130_fd_sc_hd__decap_3
XFILLER_210_557 VPWR VGND VPWR VGND sky130_ef_sc_hd__decap_12
XFILLER_202_1315 VGND VGND VPWR VPWR sky130_fd_sc_hd__fill_1
XFILLER_198_1241 VPWR VGND VPWR VGND sky130_ef_sc_hd__decap_12
XFILLER_191_921 VPWR VGND VPWR VGND sky130_ef_sc_hd__decap_12
XFILLER_176_973 VGND VGND VPWR VPWR sky130_fd_sc_hd__decap_6
XFILLER_175_461 VPWR VGND VPWR VGND sky130_ef_sc_hd__decap_12
XFILLER_163_601 VPWR VGND VPWR VGND sky130_ef_sc_hd__decap_12
XTAP_TAPCELL_ROW_61_2_3377 VGND VPWR sky130_fd_sc_hd__tapvpwrvgnd_1
XFILLER_198_1285 VPWR VGND VPWR VGND sky130_ef_sc_hd__decap_12
XFILLER_194_1105 VPWR VGND VPWR VGND sky130_ef_sc_hd__decap_12
XFILLER_163_645 VPWR VGND VPWR VGND sky130_ef_sc_hd__decap_12
XFILLER_11_1310 VPWR VGND VPWR VGND sky130_ef_sc_hd__decap_12
XFILLER_15_1490 VGND VGND VPWR VPWR sky130_fd_sc_hd__decap_6
XFILLER_50_1370 VPWR VGND VPWR VGND sky130_ef_sc_hd__decap_12
XFILLER_200_1061 VPWR VGND VPWR VGND sky130_ef_sc_hd__decap_12
XFILLER_194_1149 VPWR VGND VPWR VGND sky130_ef_sc_hd__decap_12
XFILLER_191_965 VPWR VGND VPWR VGND sky130_ef_sc_hd__decap_12
XFILLER_102_1482 VPWR VGND VPWR VGND sky130_ef_sc_hd__decap_12
XFILLER_85_1422 VPWR VGND VPWR VGND sky130_ef_sc_hd__decap_12
XFILLER_11_1354 VPWR VGND VPWR VGND sky130_ef_sc_hd__decap_12
XFILLER_190_475 VGND VGND VPWR VPWR sky130_fd_sc_hd__fill_1
XFILLER_1_316 VGND VGND VPWR VPWR sky130_fd_sc_hd__decap_4
XFILLER_11_1398 VPWR VGND VPWR VGND sky130_ef_sc_hd__decap_12
XTAP_TAPCELL_ROW_41_2_3242 VGND VPWR sky130_fd_sc_hd__tapvpwrvgnd_1
XFILLER_46_1406 VGND VGND VPWR VPWR sky130_fd_sc_hd__decap_6
XFILLER_137_1534 VPWR VGND VPWR VGND sky130_ef_sc_hd__decap_12
XFILLER_85_1466 VPWR VGND VPWR VGND sky130_ef_sc_hd__decap_12
XFILLER_137_1578 VPWR VGND VPWR VGND sky130_ef_sc_hd__decap_12
XFILLER_218_613 VPWR VGND VPWR VGND sky130_ef_sc_hd__decap_12
XFILLER_213_1455 VGND VGND VPWR VPWR sky130_fd_sc_hd__fill_1
XFILLER_94_27 VGND VGND VPWR VPWR sky130_fd_sc_hd__fill_1
XFILLER_218_657 VPWR VGND VPWR VGND sky130_ef_sc_hd__decap_12
XFILLER_2_1533 VGND VGND VPWR VPWR sky130_fd_sc_hd__decap_6
X_530_ net72 net123 VGND VGND VPWR VPWR _239_ sky130_fd_sc_hd__or2_1
XFILLER_22_1450 VPWR VGND VPWR VGND sky130_ef_sc_hd__decap_12
XFILLER_217_167 VGND VGND VPWR VPWR sky130_fd_sc_hd__fill_1
XFILLER_205_329 VGND VGND VPWR VPWR sky130_fd_sc_hd__decap_6
XFILLER_166_1229 VPWR VGND VPWR VGND sky130_ef_sc_hd__decap_12
XFILLER_22_1494 VPWR VGND VPWR VGND sky130_ef_sc_hd__decap_12
XPHY_EDGE_ROW_34_1_Left_253 VGND VGND VPWR VPWR sky130_fd_sc_hd__decap_3
XFILLER_198_531 VGND VGND VPWR VPWR sky130_fd_sc_hd__fill_1
XFILLER_168_3 VPWR VGND VPWR VGND sky130_ef_sc_hd__decap_12
XFILLER_150_77 VGND VGND VPWR VPWR sky130_fd_sc_hd__decap_6
XFILLER_96_1562 VPWR VGND VPWR VGND sky130_ef_sc_hd__decap_12
XFILLER_92_1426 VPWR VGND VPWR VGND sky130_ef_sc_hd__decap_12
X_461_ net145 net104 VGND VGND VPWR VPWR _193_ sky130_fd_sc_hd__xor2_1
XFILLER_2_1577 VPWR VGND VPWR VGND sky130_ef_sc_hd__decap_12
XFILLER_57_1546 VGND VGND VPWR VPWR sky130_fd_sc_hd__decap_6
X_392_ _128_ _129_ VGND VGND VPWR VPWR _130_ sky130_fd_sc_hd__xnor2_1
XFILLER_213_373 VPWR VGND VPWR VGND sky130_ef_sc_hd__decap_12
XFILLER_186_737 VPWR VGND VPWR VGND sky130_ef_sc_hd__decap_12
XFILLER_144_1538 VPWR VGND VPWR VGND sky130_ef_sc_hd__decap_12
XFILLER_185_225 VPWR VGND VPWR VGND sky130_ef_sc_hd__decap_12
XFILLER_167_951 VGND VGND VPWR VPWR sky130_fd_sc_hd__fill_1
XTAP_TAPCELL_ROW_157_2_3999 VGND VPWR sky130_fd_sc_hd__tapvpwrvgnd_1
XFILLER_16_1232 VPWR VGND VPWR VGND sky130_ef_sc_hd__decap_12
XFILLER_194_781 VPWR VGND VPWR VGND sky130_ef_sc_hd__decap_12
XFILLER_177_1325 VPWR VGND VPWR VGND sky130_ef_sc_hd__decap_12
XFILLER_153_111 VGND VGND VPWR VPWR sky130_fd_sc_hd__fill_1
XFILLER_103_1268 VGND VGND VPWR VPWR sky130_fd_sc_hd__decap_4
XFILLER_33_1590 VPWR VGND VPWR VGND sky130_ef_sc_hd__decap_12
XFILLER_120_1582 VPWR VGND VPWR VGND sky130_ef_sc_hd__decap_12
XFILLER_5_655 VGND VGND VPWR VPWR sky130_fd_sc_hd__decap_6
XFILLER_181_497 VGND VGND VPWR VPWR sky130_fd_sc_hd__decap_6
XFILLER_177_1369 VPWR VGND VPWR VGND sky130_ef_sc_hd__decap_12
XFILLER_64_1506 VPWR VGND VPWR VGND sky130_ef_sc_hd__decap_12
XFILLER_4_176 VPWR VGND VPWR VGND sky130_ef_sc_hd__decap_12
XTAP_TAPCELL_ROW_117_2_3740 VGND VPWR sky130_fd_sc_hd__tapvpwrvgnd_1
XFILLER_191_51 VGND VGND VPWR VPWR sky130_fd_sc_hd__decap_4
XFILLER_68_83 VGND VGND VPWR VPWR sky130_fd_sc_hd__fill_1
XFILLER_1_883 VPWR VGND VPWR VGND sky130_ef_sc_hd__decap_12
XFILLER_0_382 VGND VGND VPWR VPWR sky130_fd_sc_hd__fill_1
XFILLER_188_1421 VGND VGND VPWR VPWR sky130_fd_sc_hd__decap_6
XFILLER_82_109 VPWR VGND VPWR VGND sky130_ef_sc_hd__decap_12
XFILLER_40_1550 VPWR VGND VPWR VGND sky130_ef_sc_hd__decap_12
XFILLER_208_189 VGND VGND VPWR VPWR sky130_fd_sc_hd__decap_6
XFILLER_188_1465 VPWR VGND VPWR VGND sky130_ef_sc_hd__decap_12
XFILLER_184_1329 VPWR VGND VPWR VGND sky130_ef_sc_hd__decap_12
XFILLER_75_1602 VGND VGND VPWR VPWR sky130_fd_sc_hd__decap_3
XFILLER_1_1021 VPWR VGND VPWR VGND sky130_ef_sc_hd__decap_12
XFILLER_40_1594 VGND VGND VPWR VPWR sky130_fd_sc_hd__decap_8
XFILLER_205_841 VPWR VGND VPWR VGND sky130_ef_sc_hd__decap_12
XFILLER_1_1065 VPWR VGND VPWR VGND sky130_ef_sc_hd__decap_12
XFILLER_189_553 VGND VGND VPWR VPWR sky130_fd_sc_hd__decap_6
XFILLER_189_597 VPWR VGND VPWR VGND sky130_ef_sc_hd__decap_12
XFILLER_83_3 VPWR VGND VPWR VGND sky130_ef_sc_hd__decap_12
XTAP_TAPCELL_ROW_46_2_3279 VGND VPWR sky130_fd_sc_hd__tapvpwrvgnd_1
XFILLER_199_1561 VGND VGND VPWR VPWR sky130_fd_sc_hd__decap_6
XFILLER_191_217 VGND VGND VPWR VPWR sky130_fd_sc_hd__decap_6
XFILLER_173_921 VPWR VGND VPWR VGND sky130_ef_sc_hd__decap_12
XFILLER_201_1381 VPWR VGND VPWR VGND sky130_ef_sc_hd__decap_12
XFILLER_195_1425 VPWR VGND VPWR VGND sky130_ef_sc_hd__decap_12
XFILLER_173_965 VPWR VGND VPWR VGND sky130_ef_sc_hd__decap_12
XTAP_TAPCELL_ROW_26_2_3144 VGND VPWR sky130_fd_sc_hd__tapvpwrvgnd_1
XFILLER_195_1469 VPWR VGND VPWR VGND sky130_ef_sc_hd__decap_12
XFILLER_172_475 VGND VGND VPWR VPWR sky130_fd_sc_hd__fill_1
XFILLER_119_1220 VPWR VGND VPWR VGND sky130_ef_sc_hd__decap_12
XTAP_TAPCELL_ROW_152_1_1322 VGND VPWR sky130_fd_sc_hd__tapvpwrvgnd_1
XFILLER_119_1286 VPWR VGND VPWR VGND sky130_ef_sc_hd__decap_12
XFILLER_104_15 VPWR VGND VPWR VGND sky130_ef_sc_hd__decap_12
XPHY_EDGE_ROW_13_1_Right_599 VGND VGND VPWR VPWR sky130_fd_sc_hd__decap_3
XFILLER_167_1505 VGND VGND VPWR VPWR sky130_fd_sc_hd__decap_6
XFILLER_199_317 VPWR VGND VPWR VGND sky130_ef_sc_hd__decap_12
XFILLER_167_1549 VPWR VGND VPWR VGND sky130_ef_sc_hd__decap_12
XFILLER_78_1270 VPWR VGND VPWR VGND sky130_ef_sc_hd__decap_12
XFILLER_39_1232 VPWR VGND VPWR VGND sky130_ef_sc_hd__decap_12
XFILLER_211_833 VGND VGND VPWR VPWR sky130_fd_sc_hd__decap_6
XFILLER_210_321 VPWR VGND VPWR VGND sky130_ef_sc_hd__decap_12
XFILLER_168_737 VPWR VGND VPWR VGND sky130_ef_sc_hd__decap_12
XFILLER_126_1246 VPWR VGND VPWR VGND sky130_ef_sc_hd__decap_12
XFILLER_80_29 VPWR VGND VPWR VGND sky130_ef_sc_hd__decap_12
XFILLER_39_1298 VPWR VGND VPWR VGND sky130_ef_sc_hd__decap_12
XFILLER_211_877 VPWR VGND VPWR VGND sky130_ef_sc_hd__decap_12
XFILLER_196_29 VPWR VGND VPWR VGND sky130_ef_sc_hd__decap_12
XFILLER_167_225 VPWR VGND VPWR VGND sky130_ef_sc_hd__decap_12
XFILLER_17_1552 VGND VGND VPWR VPWR sky130_fd_sc_hd__fill_1
XFILLER_210_365 VPWR VGND VPWR VGND sky130_ef_sc_hd__decap_12
XFILLER_183_729 VPWR VGND VPWR VGND sky130_ef_sc_hd__decap_12
XFILLER_7_909 VPWR VGND VPWR VGND sky130_ef_sc_hd__decap_12
XFILLER_176_781 VPWR VGND VPWR VGND sky130_ef_sc_hd__decap_12
XFILLER_135_111 VGND VGND VPWR VPWR sky130_fd_sc_hd__fill_1
XFILLER_6_419 VGND VGND VPWR VPWR sky130_fd_sc_hd__fill_1
XANTENNA_clkbuf_3_5_0_clk_A clknet_0_clk VGND VGND VPWR VPWR sky130_fd_sc_hd__diode_2
XFILLER_13_89 VGND VGND VPWR VPWR sky130_fd_sc_hd__fill_1
XFILLER_198_1093 VPWR VGND VPWR VGND sky130_ef_sc_hd__decap_12
XFILLER_89_27 VPWR VGND VPWR VGND sky130_ef_sc_hd__decap_12
XFILLER_174_1509 VPWR VGND VPWR VGND sky130_ef_sc_hd__decap_12
XTAP_TAPCELL_ROW_91_2_3572 VGND VPWR sky130_fd_sc_hd__tapvpwrvgnd_1
XFILLER_137_1342 VPWR VGND VPWR VGND sky130_ef_sc_hd__decap_12
XFILLER_85_1274 VPWR VGND VPWR VGND sky130_ef_sc_hd__decap_12
XFILLER_2_636 VGND VGND VPWR VPWR sky130_fd_sc_hd__decap_8
XFILLER_1_113 VPWR VGND VPWR VGND sky130_ef_sc_hd__decap_12
XFILLER_145_55 VGND VGND VPWR VPWR sky130_fd_sc_hd__fill_1
XFILLER_2_669 VGND VGND VPWR VPWR sky130_fd_sc_hd__fill_2
XFILLER_46_1258 VPWR VGND VPWR VGND sky130_ef_sc_hd__decap_12
XFILLER_137_1386 VPWR VGND VPWR VGND sky130_ef_sc_hd__decap_12
XTAP_TAPCELL_ROW_6_953 VGND VPWR sky130_fd_sc_hd__tapvpwrvgnd_1
XTAP_TAPCELL_ROW_6_964 VGND VPWR sky130_fd_sc_hd__tapvpwrvgnd_1
XFILLER_218_421 VPWR VGND VPWR VGND sky130_ef_sc_hd__decap_12
XFILLER_98_1602 VGND VGND VPWR VPWR sky130_fd_sc_hd__decap_3
XTAP_TAPCELL_ROW_6_975 VGND VPWR sky130_fd_sc_hd__tapvpwrvgnd_1
XFILLER_38_53 VPWR VGND VPWR VGND sky130_ef_sc_hd__decap_12
XFILLER_219_977 VGND VGND VPWR VPWR sky130_fd_sc_hd__decap_3
XFILLER_64_109 VPWR VGND VPWR VGND sky130_ef_sc_hd__decap_12
XFILLER_38_97 VPWR VGND VPWR VGND sky130_ef_sc_hd__decap_12
XFILLER_2_1341 VPWR VGND VPWR VGND sky130_ef_sc_hd__decap_12
XFILLER_205_137 VPWR VGND VPWR VGND sky130_ef_sc_hd__decap_12
XTAP_TAPCELL_ROW_181_1890 VGND VPWR sky130_fd_sc_hd__tapvpwrvgnd_1
XFILLER_166_1037 VPWR VGND VPWR VGND sky130_ef_sc_hd__decap_12
X_513_ net150 _194_ net128 net137 _230_ VGND VGND VPWR VPWR _040_ sky130_fd_sc_hd__o311a_1
XFILLER_54_41 VPWR VGND VPWR VGND sky130_ef_sc_hd__decap_12
XFILLER_57_1310 VPWR VGND VPWR VGND sky130_ef_sc_hd__decap_12
XFILLER_207_1001 VGND VGND VPWR VPWR sky130_fd_sc_hd__decap_6
XFILLER_202_811 VGND VGND VPWR VPWR sky130_fd_sc_hd__fill_1
XFILLER_144_1302 VPWR VGND VPWR VGND sky130_ef_sc_hd__decap_12
XFILLER_109_1422 VPWR VGND VPWR VGND sky130_ef_sc_hd__decap_12
XFILLER_96_1370 VPWR VGND VPWR VGND sky130_ef_sc_hd__decap_12
X_444_ net146 net117 VGND VGND VPWR VPWR _176_ sky130_fd_sc_hd__xor2_1
XFILLER_2_1385 VPWR VGND VPWR VGND sky130_ef_sc_hd__decap_12
XFILLER_57_1354 VPWR VGND VPWR VGND sky130_ef_sc_hd__decap_12
XFILLER_214_693 VGND VGND VPWR VPWR sky130_fd_sc_hd__decap_6
XFILLER_207_1045 VPWR VGND VPWR VGND sky130_ef_sc_hd__decap_12
XFILLER_199_895 VGND VGND VPWR VPWR sky130_fd_sc_hd__fill_1
XFILLER_186_501 VPWR VGND VPWR VGND sky130_ef_sc_hd__decap_12
XFILLER_148_1482 VPWR VGND VPWR VGND sky130_ef_sc_hd__decap_12
XFILLER_18_1338 VPWR VGND VPWR VGND sky130_ef_sc_hd__decap_12
XFILLER_213_181 VPWR VGND VPWR VGND sky130_ef_sc_hd__decap_12
XFILLER_207_1089 VPWR VGND VPWR VGND sky130_ef_sc_hd__decap_12
XFILLER_186_545 VPWR VGND VPWR VGND sky130_ef_sc_hd__decap_12
XFILLER_109_1466 VPWR VGND VPWR VGND sky130_ef_sc_hd__decap_12
X_375_ net155 _115_ VGND VGND VPWR VPWR _017_ sky130_fd_sc_hd__and2_1
XTAP_TAPCELL_ROW_32_2_3187 VGND VPWR sky130_fd_sc_hd__tapvpwrvgnd_1
XFILLER_57_1398 VPWR VGND VPWR VGND sky130_ef_sc_hd__decap_12
XFILLER_186_589 VPWR VGND VPWR VGND sky130_ef_sc_hd__decap_12
XTAP_TAPCELL_ROW_8_2_3028 VGND VPWR sky130_fd_sc_hd__tapvpwrvgnd_1
XFILLER_173_217 VGND VGND VPWR VPWR sky130_fd_sc_hd__decap_6
XFILLER_177_1133 VPWR VGND VPWR VGND sky130_ef_sc_hd__decap_12
XFILLER_181_261 VPWR VGND VPWR VGND sky130_ef_sc_hd__decap_12
XFILLER_68_1450 VPWR VGND VPWR VGND sky130_ef_sc_hd__decap_12
XFILLER_218_1141 VGND VGND VPWR VPWR sky130_fd_sc_hd__decap_6
XFILLER_177_1177 VPWR VGND VPWR VGND sky130_ef_sc_hd__decap_12
XFILLER_170_979 VGND VGND VPWR VPWR sky130_fd_sc_hd__fill_1
XFILLER_141_125 VGND VGND VPWR VPWR sky130_fd_sc_hd__fill_2
XFILLER_64_1314 VPWR VGND VPWR VGND sky130_ef_sc_hd__decap_12
XFILLER_29_1434 VGND VGND VPWR VPWR sky130_fd_sc_hd__decap_6
XFILLER_214_1005 VPWR VGND VPWR VGND sky130_ef_sc_hd__decap_12
XFILLER_155_1442 VPWR VGND VPWR VGND sky130_ef_sc_hd__decap_12
XFILLER_79_93 VPWR VGND VPWR VGND sky130_ef_sc_hd__decap_12
XFILLER_68_1494 VPWR VGND VPWR VGND sky130_ef_sc_hd__decap_12
XFILLER_218_1185 VPWR VGND VPWR VGND sky130_ef_sc_hd__decap_12
XFILLER_214_1049 VPWR VGND VPWR VGND sky130_ef_sc_hd__decap_12
XFILLER_151_1328 VGND VGND VPWR VPWR sky130_fd_sc_hd__fill_1
XFILLER_116_1426 VPWR VGND VPWR VGND sky130_ef_sc_hd__decap_12
XFILLER_64_1358 VPWR VGND VPWR VGND sky130_ef_sc_hd__decap_12
XFILLER_29_1478 VPWR VGND VPWR VGND sky130_ef_sc_hd__decap_12
XFILLER_205_69 VPWR VGND VPWR VGND sky130_ef_sc_hd__decap_12
XTAP_TAPCELL_ROW_162_2_4030 VGND VPWR sky130_fd_sc_hd__tapvpwrvgnd_1
XFILLER_95_81 VPWR VGND VPWR VGND sky130_ef_sc_hd__decap_12
XFILLER_7_1285 VGND VGND VPWR VPWR sky130_fd_sc_hd__decap_3
XFILLER_188_1273 VPWR VGND VPWR VGND sky130_ef_sc_hd__decap_12
XFILLER_75_1410 VPWR VGND VPWR VGND sky130_ef_sc_hd__decap_12
XFILLER_149_1268 VGND VGND VPWR VPWR sky130_fd_sc_hd__decap_4
XFILLER_79_1590 VPWR VGND VPWR VGND sky130_ef_sc_hd__decap_12
XFILLER_205_671 VGND VGND VPWR VPWR sky130_fd_sc_hd__fill_1
XFILLER_196_309 VPWR VGND VPWR VGND sky130_ef_sc_hd__decap_12
XFILLER_189_361 VPWR VGND VPWR VGND sky130_ef_sc_hd__decap_12
XFILLER_127_1522 VPWR VGND VPWR VGND sky130_ef_sc_hd__decap_12
XFILLER_75_1454 VPWR VGND VPWR VGND sky130_ef_sc_hd__decap_12
XFILLER_162_1468 VGND VGND VPWR VPWR sky130_fd_sc_hd__fill_1
XFILLER_127_1566 VPWR VGND VPWR VGND sky130_ef_sc_hd__decap_12
XFILLER_75_1498 VPWR VGND VPWR VGND sky130_ef_sc_hd__decap_12
XFILLER_36_1438 VPWR VGND VPWR VGND sky130_ef_sc_hd__decap_12
XFILLER_165_729 VPWR VGND VPWR VGND sky130_ef_sc_hd__decap_12
XFILLER_117_111 VGND VGND VPWR VPWR sky130_fd_sc_hd__fill_1
XTAP_TAPCELL_ROW_76_2_3474 VGND VPWR sky130_fd_sc_hd__tapvpwrvgnd_1
XFILLER_195_1233 VPWR VGND VPWR VGND sky130_ef_sc_hd__decap_12
XFILLER_12_1482 VPWR VGND VPWR VGND sky130_ef_sc_hd__decap_12
XTAP_TAPCELL_ROW_212_2790 VGND VPWR sky130_fd_sc_hd__tapvpwrvgnd_1
XFILLER_191_1119 VGND VGND VPWR VPWR sky130_fd_sc_hd__fill_1
XFILLER_86_1550 VPWR VGND VPWR VGND sky130_ef_sc_hd__decap_12
XFILLER_86_1594 VGND VGND VPWR VPWR sky130_fd_sc_hd__decap_8
XFILLER_82_1414 VPWR VGND VPWR VGND sky130_ef_sc_hd__decap_12
XFILLER_47_1534 VPWR VGND VPWR VGND sky130_ef_sc_hd__decap_12
XFILLER_134_1526 VPWR VGND VPWR VGND sky130_ef_sc_hd__decap_12
XFILLER_47_1578 VPWR VGND VPWR VGND sky130_ef_sc_hd__decap_12
XFILLER_115_69 VPWR VGND VPWR VGND sky130_ef_sc_hd__decap_12
XFILLER_46_109 VPWR VGND VPWR VGND sky130_ef_sc_hd__decap_12
XFILLER_216_925 VPWR VGND VPWR VGND sky130_ef_sc_hd__decap_12
XFILLER_167_1313 VPWR VGND VPWR VGND sky130_ef_sc_hd__decap_12
XFILLER_132_1294 VGND VGND VPWR VPWR sky130_fd_sc_hd__decap_6
XFILLER_199_125 VPWR VGND VPWR VGND sky130_ef_sc_hd__decap_12
XFILLER_131_57 VPWR VGND VPWR VGND sky130_ef_sc_hd__decap_12
XFILLER_167_1357 VPWR VGND VPWR VGND sky130_ef_sc_hd__decap_12
XFILLER_93_1510 VPWR VGND VPWR VGND sky130_ef_sc_hd__decap_12
XFILLER_91_39 VPWR VGND VPWR VGND sky130_ef_sc_hd__decap_12
XFILLER_199_169 VPWR VGND VPWR VGND sky130_ef_sc_hd__decap_12
XTAP_TAPCELL_ROW_198_2395 VGND VPWR sky130_fd_sc_hd__tapvpwrvgnd_1
XTAP_TAPCELL_ROW_198_2384 VGND VPWR sky130_fd_sc_hd__tapvpwrvgnd_1
XTAP_TAPCELL_ROW_198_2373 VGND VPWR sky130_fd_sc_hd__tapvpwrvgnd_1
XFILLER_168_501 VPWR VGND VPWR VGND sky130_ef_sc_hd__decap_12
XFILLER_93_1554 VPWR VGND VPWR VGND sky130_ef_sc_hd__decap_12
XTAP_TAPCELL_ROW_17_2_3089 VGND VPWR sky130_fd_sc_hd__tapvpwrvgnd_1
XFILLER_211_641 VPWR VGND VPWR VGND sky130_ef_sc_hd__decap_12
XFILLER_208_1365 VGND VGND VPWR VPWR sky130_fd_sc_hd__decap_6
XTAP_TAPCELL_ROW_194_2259 VGND VPWR sky130_fd_sc_hd__tapvpwrvgnd_1
XFILLER_168_545 VPWR VGND VPWR VGND sky130_ef_sc_hd__decap_12
XFILLER_24_55 VGND VGND VPWR VPWR sky130_fd_sc_hd__decap_3
XFILLER_54_1538 VPWR VGND VPWR VGND sky130_ef_sc_hd__decap_12
XTAP_TAPCELL_ROW_219_2977 VGND VPWR sky130_fd_sc_hd__tapvpwrvgnd_1
XFILLER_211_685 VPWR VGND VPWR VGND sky130_ef_sc_hd__decap_12
XFILLER_204_1229 VPWR VGND VPWR VGND sky130_ef_sc_hd__decap_12
XTAP_TAPCELL_ROW_219_2999 VGND VPWR sky130_fd_sc_hd__tapvpwrvgnd_1
XTAP_TAPCELL_ROW_219_2988 VGND VPWR sky130_fd_sc_hd__tapvpwrvgnd_1
XFILLER_210_195 VGND VGND VPWR VPWR sky130_fd_sc_hd__fill_1
XFILLER_168_589 VPWR VGND VPWR VGND sky130_ef_sc_hd__decap_12
XFILLER_183_559 VGND VGND VPWR VPWR sky130_fd_sc_hd__fill_1
XPHY_EDGE_ROW_12_2_Right_69 VGND VGND VPWR VPWR sky130_fd_sc_hd__decap_3
XFILLER_13_1268 VGND VGND VPWR VPWR sky130_fd_sc_hd__decap_4
XFILLER_200_3 VPWR VGND VPWR VGND sky130_ef_sc_hd__decap_12
XFILLER_178_1453 VPWR VGND VPWR VGND sky130_ef_sc_hd__decap_12
XFILLER_170_209 VPWR VGND VPWR VGND sky130_ef_sc_hd__decap_12
XFILLER_40_65 VPWR VGND VPWR VGND sky130_ef_sc_hd__decap_12
XFILLER_178_1497 VPWR VGND VPWR VGND sky130_ef_sc_hd__decap_12
XFILLER_174_1317 VPWR VGND VPWR VGND sky130_ef_sc_hd__decap_12
XTAP_TAPCELL_ROW_170_1580 VGND VPWR sky130_fd_sc_hd__tapvpwrvgnd_1
XFILLER_156_65 VPWR VGND VPWR VGND sky130_ef_sc_hd__decap_12
XFILLER_123_125 VGND VGND VPWR VPWR sky130_fd_sc_hd__fill_2
XFILLER_30_1582 VPWR VGND VPWR VGND sky130_ef_sc_hd__decap_12
XTAP_TAPCELL_ROW_170_1591 VGND VPWR sky130_fd_sc_hd__tapvpwrvgnd_1
XFILLER_3_989 VPWR VGND VPWR VGND sky130_ef_sc_hd__decap_12
XPHY_EDGE_ROW_58_2_Left_490 VGND VGND VPWR VPWR sky130_fd_sc_hd__decap_3
XFILLER_215_1325 VPWR VGND VPWR VGND sky130_ef_sc_hd__decap_12
XFILLER_215_1369 VPWR VGND VPWR VGND sky130_ef_sc_hd__decap_12
XFILLER_172_1085 VGND VGND VPWR VPWR sky130_fd_sc_hd__decap_6
XFILLER_172_53 VPWR VGND VPWR VGND sky130_ef_sc_hd__decap_12
XFILLER_8_1550 VPWR VGND VPWR VGND sky130_ef_sc_hd__decap_12
XFILLER_49_96 VPWR VGND VPWR VGND sky130_ef_sc_hd__decap_12
XFILLER_219_741 VPWR VGND VPWR VGND sky130_ef_sc_hd__decap_12
XTAP_TAPCELL_ROW_183_1952 VGND VPWR sky130_fd_sc_hd__tapvpwrvgnd_1
XFILLER_172_97 VPWR VGND VPWR VGND sky130_ef_sc_hd__decap_12
XFILLER_150_1350 VGND VGND VPWR VPWR sky130_fd_sc_hd__decap_6
XFILLER_1_15 VPWR VGND VPWR VGND sky130_ef_sc_hd__decap_12
XFILLER_8_1594 VGND VGND VPWR VPWR sky130_fd_sc_hd__decap_8
XFILLER_219_785 VPWR VGND VPWR VGND sky130_ef_sc_hd__decap_12
XFILLER_218_251 VGND VGND VPWR VPWR sky130_fd_sc_hd__fill_1
XFILLER_206_413 VGND VGND VPWR VPWR sky130_fd_sc_hd__decap_6
XTAP_TAPCELL_ROW_183_1963 VGND VPWR sky130_fd_sc_hd__tapvpwrvgnd_1
XFILLER_150_1394 VPWR VGND VPWR VGND sky130_ef_sc_hd__decap_12
XFILLER_65_51 VGND VGND VPWR VPWR sky130_fd_sc_hd__decap_4
XFILLER_189_1593 VPWR VGND VPWR VGND sky130_ef_sc_hd__decap_12
XFILLER_185_1413 VPWR VGND VPWR VGND sky130_ef_sc_hd__decap_12
XFILLER_111_1378 VGND VGND VPWR VPWR sky130_fd_sc_hd__decap_6
XFILLER_206_457 VPWR VGND VPWR VGND sky130_ef_sc_hd__decap_12
XFILLER_185_1457 VPWR VGND VPWR VGND sky130_ef_sc_hd__decap_12
XPHY_EDGE_ROW_77_2_Left_509 VGND VGND VPWR VPWR sky130_fd_sc_hd__decap_3
XFILLER_187_821 VPWR VGND VPWR VGND sky130_ef_sc_hd__decap_12
XFILLER_178_309 VPWR VGND VPWR VGND sky130_ef_sc_hd__decap_12
X_427_ _156_ _159_ VGND VGND VPWR VPWR _161_ sky130_fd_sc_hd__xnor2_1
XFILLER_187_865 VPWR VGND VPWR VGND sky130_ef_sc_hd__decap_12
XFILLER_109_1274 VPWR VGND VPWR VGND sky130_ef_sc_hd__decap_12
X_358_ net155 _101_ VGND VGND VPWR VPWR _014_ sky130_fd_sc_hd__and2_1
XTAP_TAPCELL_ROW_177_1789 VGND VPWR sky130_fd_sc_hd__tapvpwrvgnd_1
XTAP_TAPCELL_ROW_177_1778 VGND VPWR sky130_fd_sc_hd__tapvpwrvgnd_1
XFILLER_161_1490 VGND VGND VPWR VPWR sky130_fd_sc_hd__decap_6
XTAP_TAPCELL_ROW_62_2_3382 VGND VPWR sky130_fd_sc_hd__tapvpwrvgnd_1
X_289_ u_ctrl.elem_idx\[1\] u_ctrl.elem_idx\[0\] u_ctrl.elem_idx\[2\] VGND VGND VPWR
+ VPWR _084_ sky130_fd_sc_hd__o21ai_4
XFILLER_196_1553 VPWR VGND VPWR VGND sky130_ef_sc_hd__decap_12
XFILLER_196_1597 VGND VGND VPWR VPWR sky130_fd_sc_hd__decap_8
XFILLER_182_581 VGND VGND VPWR VPWR sky130_fd_sc_hd__decap_6
XFILLER_29_1220 VPWR VGND VPWR VGND sky130_ef_sc_hd__decap_12
XFILLER_190_1141 VGND VGND VPWR VPWR sky130_fd_sc_hd__decap_6
XFILLER_155_1272 VGND VGND VPWR VPWR sky130_fd_sc_hd__fill_1
XPHY_EDGE_ROW_111_1_Left_330 VGND VGND VPWR VPWR sky130_fd_sc_hd__decap_3
XFILLER_190_1185 VPWR VGND VPWR VGND sky130_ef_sc_hd__decap_12
XFILLER_29_1286 VPWR VGND VPWR VGND sky130_ef_sc_hd__decap_12
Xinput3 func_addr[0] VGND VGND VPWR VPWR net3 sky130_fd_sc_hd__clkbuf_1
XFILLER_7_1093 VPWR VGND VPWR VGND sky130_ef_sc_hd__decap_12
XFILLER_209_273 VGND VGND VPWR VPWR sky130_fd_sc_hd__decap_6
XPHY_EDGE_ROW_50_2_Right_107 VGND VGND VPWR VPWR sky130_fd_sc_hd__decap_3
XFILLER_197_629 VPWR VGND VPWR VGND sky130_ef_sc_hd__decap_12
XFILLER_101_27 VPWR VGND VPWR VGND sky130_ef_sc_hd__decap_12
XFILLER_205_1505 VGND VGND VPWR VPWR sky130_fd_sc_hd__decap_6
XTAP_TAPCELL_ROW_201_2480 VGND VPWR sky130_fd_sc_hd__tapvpwrvgnd_1
XFILLER_196_139 VGND VGND VPWR VPWR sky130_fd_sc_hd__fill_1
XFILLER_162_1232 VPWR VGND VPWR VGND sky130_ef_sc_hd__decap_12
XFILLER_127_1330 VPWR VGND VPWR VGND sky130_ef_sc_hd__decap_12
XFILLER_36_1246 VPWR VGND VPWR VGND sky130_ef_sc_hd__decap_12
XFILLER_205_1549 VPWR VGND VPWR VGND sky130_ef_sc_hd__decap_12
XANTENNA_fanout140_A _083_ VGND VGND VPWR VPWR sky130_fd_sc_hd__diode_2
XFILLER_192_301 VGND VGND VPWR VPWR sky130_fd_sc_hd__decap_6
XTAP_TAPCELL_ROW_214_2841 VGND VPWR sky130_fd_sc_hd__tapvpwrvgnd_1
XTAP_TAPCELL_ROW_214_2830 VGND VPWR sky130_fd_sc_hd__tapvpwrvgnd_1
XFILLER_192_345 VPWR VGND VPWR VGND sky130_ef_sc_hd__decap_12
XFILLER_165_559 VGND VGND VPWR VPWR sky130_fd_sc_hd__fill_1
XFILLER_140_1574 VGND VGND VPWR VPWR sky130_fd_sc_hd__decap_6
XTAP_TAPCELL_ROW_32_1_1081 VGND VPWR sky130_fd_sc_hd__tapvpwrvgnd_1
XTAP_TAPCELL_ROW_214_2852 VGND VPWR sky130_fd_sc_hd__tapvpwrvgnd_1
XFILLER_192_389 VPWR VGND VPWR VGND sky130_ef_sc_hd__decap_12
XTAP_TAPCELL_ROW_210_2738 VGND VPWR sky130_fd_sc_hd__tapvpwrvgnd_1
XTAP_TAPCELL_ROW_210_2727 VGND VPWR sky130_fd_sc_hd__tapvpwrvgnd_1
XTAP_TAPCELL_ROW_210_2716 VGND VPWR sky130_fd_sc_hd__tapvpwrvgnd_1
XFILLER_195_1063 VGND VGND VPWR VPWR sky130_fd_sc_hd__fill_1
XFILLER_105_125 VGND VGND VPWR VPWR sky130_fd_sc_hd__fill_2
XTAP_TAPCELL_ROW_151_2_3958 VGND VPWR sky130_fd_sc_hd__tapvpwrvgnd_1
XPHY_EDGE_ROW_43_1_Left_262 VGND VGND VPWR VPWR sky130_fd_sc_hd__decap_3
XTAP_TAPCELL_ROW_187_2074 VGND VPWR sky130_fd_sc_hd__tapvpwrvgnd_1
XTAP_TAPCELL_ROW_187_2063 VGND VPWR sky130_fd_sc_hd__tapvpwrvgnd_1
XFILLER_138_1470 VPWR VGND VPWR VGND sky130_ef_sc_hd__decap_12
XFILLER_82_1244 VGND VGND VPWR VPWR sky130_fd_sc_hd__fill_1
XFILLER_47_1342 VPWR VGND VPWR VGND sky130_ef_sc_hd__decap_12
XFILLER_212_1509 VPWR VGND VPWR VGND sky130_ef_sc_hd__decap_12
XFILLER_134_1356 VGND VGND VPWR VPWR sky130_fd_sc_hd__fill_1
XTAP_TAPCELL_ROW_120_1_1257 VGND VPWR sky130_fd_sc_hd__tapvpwrvgnd_1
XFILLER_47_1386 VPWR VGND VPWR VGND sky130_ef_sc_hd__decap_12
XTAP_TAPCELL_ROW_208_2656 VGND VPWR sky130_fd_sc_hd__tapvpwrvgnd_1
XFILLER_19_55 VGND VGND VPWR VPWR sky130_fd_sc_hd__fill_1
XTAP_TAPCELL_ROW_208_2678 VGND VPWR sky130_fd_sc_hd__tapvpwrvgnd_1
XTAP_TAPCELL_ROW_208_2667 VGND VPWR sky130_fd_sc_hd__tapvpwrvgnd_1
XFILLER_167_1121 VPWR VGND VPWR VGND sky130_ef_sc_hd__decap_12
XTAP_TAPCELL_ROW_98_2_3617 VGND VPWR sky130_fd_sc_hd__tapvpwrvgnd_1
XFILLER_216_755 VGND VGND VPWR VPWR sky130_fd_sc_hd__fill_1
XFILLER_204_917 VGND VGND VPWR VPWR sky130_fd_sc_hd__decap_6
XFILLER_203_405 VPWR VGND VPWR VGND sky130_ef_sc_hd__decap_12
XFILLER_150_3 VPWR VGND VPWR VGND sky130_ef_sc_hd__decap_12
XFILLER_54_1302 VPWR VGND VPWR VGND sky130_ef_sc_hd__decap_12
XFILLER_212_961 VPWR VGND VPWR VGND sky130_ef_sc_hd__decap_12
XFILLER_203_449 VPWR VGND VPWR VGND sky130_ef_sc_hd__decap_12
XFILLER_169_821 VPWR VGND VPWR VGND sky130_ef_sc_hd__decap_12
XFILLER_93_1384 VGND VGND VPWR VPWR sky130_fd_sc_hd__fill_1
XFILLER_19_1422 VPWR VGND VPWR VGND sky130_ef_sc_hd__decap_12
XFILLER_58_1482 VPWR VGND VPWR VGND sky130_ef_sc_hd__decap_12
XFILLER_208_1173 VPWR VGND VPWR VGND sky130_ef_sc_hd__decap_12
XFILLER_204_1037 VPWR VGND VPWR VGND sky130_ef_sc_hd__decap_12
XFILLER_180_1365 VGND VGND VPWR VPWR sky130_fd_sc_hd__decap_6
XFILLER_169_865 VPWR VGND VPWR VGND sky130_ef_sc_hd__decap_12
XFILLER_106_1414 VPWR VGND VPWR VGND sky130_ef_sc_hd__decap_12
XFILLER_19_1466 VPWR VGND VPWR VGND sky130_ef_sc_hd__decap_12
XTAP_TAPCELL_ROW_47_2_3284 VGND VPWR sky130_fd_sc_hd__tapvpwrvgnd_1
XFILLER_195_161 VGND VGND VPWR VPWR sky130_fd_sc_hd__decap_6
XFILLER_184_813 VPWR VGND VPWR VGND sky130_ef_sc_hd__decap_12
XFILLER_145_1496 VGND VGND VPWR VPWR sky130_fd_sc_hd__fill_1
XTAP_TAPCELL_ROW_172_1631 VGND VPWR sky130_fd_sc_hd__tapvpwrvgnd_1
XFILLER_7_525 VGND VGND VPWR VPWR sky130_fd_sc_hd__decap_6
XTAP_TAPCELL_ROW_172_1653 VGND VPWR sky130_fd_sc_hd__tapvpwrvgnd_1
XTAP_TAPCELL_ROW_172_1642 VGND VPWR sky130_fd_sc_hd__tapvpwrvgnd_1
XFILLER_171_529 VPWR VGND VPWR VGND sky130_ef_sc_hd__decap_12
XFILLER_178_1261 VPWR VGND VPWR VGND sky130_ef_sc_hd__decap_12
XFILLER_164_581 VGND VGND VPWR VPWR sky130_fd_sc_hd__decap_6
XFILLER_3_731 VGND VGND VPWR VPWR sky130_fd_sc_hd__decap_3
XFILLER_174_1147 VGND VGND VPWR VPWR sky130_fd_sc_hd__fill_1
XFILLER_139_1256 VPWR VGND VPWR VGND sky130_ef_sc_hd__decap_12
XTAP_TAPCELL_ROW_40_2_3238 VGND VPWR sky130_fd_sc_hd__tapvpwrvgnd_1
XFILLER_152_1412 VGND VGND VPWR VPWR sky130_fd_sc_hd__fill_1
XFILLER_117_1510 VPWR VGND VPWR VGND sky130_ef_sc_hd__decap_12
XFILLER_65_1442 VPWR VGND VPWR VGND sky130_ef_sc_hd__decap_12
XFILLER_3_797 VPWR VGND VPWR VGND sky130_ef_sc_hd__decap_12
XFILLER_215_1133 VPWR VGND VPWR VGND sky130_ef_sc_hd__decap_12
XFILLER_117_1554 VPWR VGND VPWR VGND sky130_ef_sc_hd__decap_12
XFILLER_6_1509 VPWR VGND VPWR VGND sky130_ef_sc_hd__decap_12
XFILLER_26_1426 VPWR VGND VPWR VGND sky130_ef_sc_hd__decap_12
XTAP_TAPCELL_ROW_57_1_1132 VGND VPWR sky130_fd_sc_hd__tapvpwrvgnd_1
XFILLER_61_1328 VGND VGND VPWR VPWR sky130_fd_sc_hd__fill_1
XFILLER_215_1177 VPWR VGND VPWR VGND sky130_ef_sc_hd__decap_12
XTAP_TAPCELL_ROW_166_1457 VGND VPWR sky130_fd_sc_hd__tapvpwrvgnd_1
XTAP_TAPCELL_ROW_166_1479 VGND VPWR sky130_fd_sc_hd__tapvpwrvgnd_1
XTAP_TAPCELL_ROW_166_1468 VGND VPWR sky130_fd_sc_hd__tapvpwrvgnd_1
XFILLER_76_83 VGND VGND VPWR VPWR sky130_fd_sc_hd__fill_1
XFILLER_206_221 VPWR VGND VPWR VGND sky130_ef_sc_hd__decap_12
XFILLER_202_15 VPWR VGND VPWR VGND sky130_ef_sc_hd__decap_12
XFILLER_207_777 VGND VGND VPWR VPWR sky130_fd_sc_hd__decap_6
XFILLER_206_265 VPWR VGND VPWR VGND sky130_ef_sc_hd__decap_12
XFILLER_185_1287 VGND VGND VPWR VPWR sky130_fd_sc_hd__fill_1
XFILLER_179_629 VPWR VGND VPWR VGND sky130_ef_sc_hd__decap_12
XTAP_TAPCELL_ROW_179_1829 VGND VPWR sky130_fd_sc_hd__tapvpwrvgnd_1
XTAP_TAPCELL_ROW_145_1_1308 VGND VPWR sky130_fd_sc_hd__tapvpwrvgnd_1
XFILLER_59_1268 VGND VGND VPWR VPWR sky130_fd_sc_hd__decap_4
XFILLER_178_139 VGND VGND VPWR VPWR sky130_fd_sc_hd__fill_1
XFILLER_163_1541 VPWR VGND VPWR VGND sky130_ef_sc_hd__decap_12
XFILLER_76_1582 VPWR VGND VPWR VGND sky130_ef_sc_hd__decap_12
XFILLER_37_1522 VPWR VGND VPWR VGND sky130_ef_sc_hd__decap_12
XFILLER_72_1468 VGND VGND VPWR VPWR sky130_fd_sc_hd__fill_1
XFILLER_37_1566 VPWR VGND VPWR VGND sky130_ef_sc_hd__decap_12
XFILLER_187_673 VPWR VGND VPWR VGND sky130_ef_sc_hd__decap_12
XFILLER_174_301 VGND VGND VPWR VPWR sky130_fd_sc_hd__decap_6
XFILLER_190_805 VGND VGND VPWR VPWR sky130_fd_sc_hd__decap_6
XFILLER_174_345 VPWR VGND VPWR VGND sky130_ef_sc_hd__decap_12
XFILLER_174_389 VPWR VGND VPWR VGND sky130_ef_sc_hd__decap_12
XFILLER_122_1282 VPWR VGND VPWR VGND sky130_ef_sc_hd__decap_12
XFILLER_192_1203 VGND VGND VPWR VPWR sky130_fd_sc_hd__fill_1
XFILLER_190_849 VPWR VGND VPWR VGND sky130_ef_sc_hd__decap_12
XFILLER_100_1580 VGND VGND VPWR VPWR sky130_fd_sc_hd__fill_1
XFILLER_157_1378 VGND VGND VPWR VPWR sky130_fd_sc_hd__decap_6
XFILLER_44_1526 VPWR VGND VPWR VGND sky130_ef_sc_hd__decap_12
XFILLER_170_1589 VGND VGND VPWR VPWR sky130_fd_sc_hd__decap_6
XTAP_TAPCELL_ROW_84_2_3525 VGND VPWR sky130_fd_sc_hd__tapvpwrvgnd_1
XTAP_TAPCELL_ROW_203_2520 VGND VPWR sky130_fd_sc_hd__tapvpwrvgnd_1
XFILLER_186_1029 VGND VGND VPWR VPWR sky130_fd_sc_hd__decap_6
XFILLER_112_15 VPWR VGND VPWR VGND sky130_ef_sc_hd__decap_12
XANTENNA__587__CLK clknet_3_2_0_clk VGND VGND VPWR VPWR sky130_fd_sc_hd__diode_2
XFILLER_42_1294 VGND VGND VPWR VPWR sky130_fd_sc_hd__decap_6
XTAP_TAPCELL_ROW_203_2531 VGND VPWR sky130_fd_sc_hd__tapvpwrvgnd_1
XFILLER_198_905 VPWR VGND VPWR VGND sky130_ef_sc_hd__decap_12
XFILLER_168_1441 VPWR VGND VPWR VGND sky130_ef_sc_hd__decap_12
XTAP_TAPCELL_ROW_0_756 VGND VPWR sky130_fd_sc_hd__tapvpwrvgnd_1
XPHY_EDGE_ROW_51_2_Right_108 VGND VGND VPWR VPWR sky130_fd_sc_hd__decap_3
XTAP_TAPCELL_ROW_195_2310 VGND VPWR sky130_fd_sc_hd__tapvpwrvgnd_1
XFILLER_168_1485 VPWR VGND VPWR VGND sky130_ef_sc_hd__decap_12
XTAP_TAPCELL_ROW_0_789 VGND VPWR sky130_fd_sc_hd__tapvpwrvgnd_1
XTAP_TAPCELL_ROW_0_778 VGND VPWR sky130_fd_sc_hd__tapvpwrvgnd_1
XTAP_TAPCELL_ROW_0_767 VGND VPWR sky130_fd_sc_hd__tapvpwrvgnd_1
XFILLER_201_909 VPWR VGND VPWR VGND sky130_ef_sc_hd__decap_12
XFILLER_198_949 VPWR VGND VPWR VGND sky130_ef_sc_hd__decap_12
XFILLER_90_1524 VGND VGND VPWR VPWR sky130_fd_sc_hd__fill_1
XFILLER_209_1493 VPWR VGND VPWR VGND sky130_ef_sc_hd__decap_12
XFILLER_205_1313 VPWR VGND VPWR VGND sky130_ef_sc_hd__decap_12
XFILLER_200_419 VGND VGND VPWR VPWR sky130_fd_sc_hd__fill_1
XTAP_TAPCELL_ROW_33_2_3192 VGND VPWR sky130_fd_sc_hd__tapvpwrvgnd_1
XTAP_TAPCELL_ROW_216_2903 VGND VPWR sky130_fd_sc_hd__tapvpwrvgnd_1
XFILLER_205_1357 VPWR VGND VPWR VGND sky130_ef_sc_hd__decap_12
XFILLER_184_109 VPWR VGND VPWR VGND sky130_ef_sc_hd__decap_12
XFILLER_177_161 VGND VGND VPWR VPWR sky130_fd_sc_hd__decap_6
XFILLER_166_813 VPWR VGND VPWR VGND sky130_ef_sc_hd__decap_12
XFILLER_193_665 VGND VGND VPWR VPWR sky130_fd_sc_hd__decap_6
XFILLER_192_153 VPWR VGND VPWR VGND sky130_ef_sc_hd__decap_12
XFILLER_140_1382 VPWR VGND VPWR VGND sky130_ef_sc_hd__decap_12
XFILLER_101_1322 VGND VGND VPWR VPWR sky130_fd_sc_hd__decap_6
XFILLER_21_23 VGND VGND VPWR VPWR sky130_fd_sc_hd__fill_2
XFILLER_197_1169 VGND VGND VPWR VPWR sky130_fd_sc_hd__decap_6
XFILLER_192_197 VPWR VGND VPWR VGND sky130_ef_sc_hd__decap_12
XTAP_TAPCELL_ROW_189_2136 VGND VPWR sky130_fd_sc_hd__tapvpwrvgnd_1
XTAP_TAPCELL_ROW_189_2125 VGND VPWR sky130_fd_sc_hd__tapvpwrvgnd_1
XTAP_TAPCELL_ROW_189_2114 VGND VPWR sky130_fd_sc_hd__tapvpwrvgnd_1
XFILLER_179_1581 VPWR VGND VPWR VGND sky130_ef_sc_hd__decap_12
XFILLER_175_1401 VPWR VGND VPWR VGND sky130_ef_sc_hd__decap_12
XFILLER_101_1366 VPWR VGND VPWR VGND sky130_ef_sc_hd__decap_12
XFILLER_97_27 VPWR VGND VPWR VGND sky130_ef_sc_hd__decap_12
XFILLER_216_1453 VPWR VGND VPWR VGND sky130_ef_sc_hd__decap_12
XFILLER_0_745 VGND VGND VPWR VPWR sky130_fd_sc_hd__decap_4
XFILLER_0_734 VGND VGND VPWR VPWR sky130_fd_sc_hd__fill_1
XFILLER_216_1497 VPWR VGND VPWR VGND sky130_ef_sc_hd__decap_12
XFILLER_212_1317 VPWR VGND VPWR VGND sky130_ef_sc_hd__decap_12
XFILLER_198_3 VPWR VGND VPWR VGND sky130_ef_sc_hd__decap_12
XFILLER_153_55 VGND VGND VPWR VPWR sky130_fd_sc_hd__fill_1
XFILLER_0_767 VGND VGND VPWR VPWR sky130_fd_sc_hd__decap_3
XFILLER_60_1350 VGND VGND VPWR VPWR sky130_fd_sc_hd__decap_6
XFILLER_112_1462 VGND VGND VPWR VPWR sky130_fd_sc_hd__decap_6
XFILLER_46_20 VGND VGND VPWR VPWR sky130_fd_sc_hd__decap_8
XFILLER_60_1394 VPWR VGND VPWR VGND sky130_ef_sc_hd__decap_12
XFILLER_210_1085 VGND VGND VPWR VPWR sky130_fd_sc_hd__decap_6
XFILLER_186_1541 VPWR VGND VPWR VGND sky130_ef_sc_hd__decap_12
XFILLER_21_1378 VGND VGND VPWR VPWR sky130_fd_sc_hd__decap_6
XFILLER_46_53 VPWR VGND VPWR VGND sky130_ef_sc_hd__decap_12
XFILLER_204_725 VPWR VGND VPWR VGND sky130_ef_sc_hd__decap_12
XFILLER_46_97 VPWR VGND VPWR VGND sky130_ef_sc_hd__decap_12
XFILLER_204_769 VPWR VGND VPWR VGND sky130_ef_sc_hd__decap_12
XFILLER_182_1427 VGND VGND VPWR VPWR sky130_fd_sc_hd__fill_1
XFILLER_203_279 VGND VGND VPWR VPWR sky130_fd_sc_hd__fill_1
XFILLER_62_41 VPWR VGND VPWR VGND sky130_ef_sc_hd__decap_12
XFILLER_180_1173 VPWR VGND VPWR VGND sky130_ef_sc_hd__decap_12
XFILLER_178_41 VPWR VGND VPWR VGND sky130_ef_sc_hd__decap_12
XTAP_TAPCELL_ROW_174_1704 VGND VPWR sky130_fd_sc_hd__tapvpwrvgnd_1
XFILLER_169_673 VPWR VGND VPWR VGND sky130_ef_sc_hd__decap_12
XFILLER_106_1244 VGND VGND VPWR VPWR sky130_fd_sc_hd__fill_1
XPHY_EDGE_ROW_104_1_Right_690 VGND VGND VPWR VPWR sky130_fd_sc_hd__decap_3
XFILLER_19_1274 VPWR VGND VPWR VGND sky130_ef_sc_hd__decap_12
XFILLER_62_85 VPWR VGND VPWR VGND sky130_ef_sc_hd__decap_12
XFILLER_184_643 VGND VGND VPWR VPWR sky130_fd_sc_hd__fill_1
XFILLER_178_85 VPWR VGND VPWR VGND sky130_ef_sc_hd__decap_12
XFILLER_71_1490 VGND VGND VPWR VPWR sky130_fd_sc_hd__decap_6
XFILLER_7_333 VGND VGND VPWR VPWR sky130_fd_sc_hd__decap_3
XFILLER_172_805 VGND VGND VPWR VPWR sky130_fd_sc_hd__decap_6
XTAP_TAPCELL_ROW_122_2_3768 VGND VPWR sky130_fd_sc_hd__tapvpwrvgnd_1
XFILLER_172_849 VPWR VGND VPWR VGND sky130_ef_sc_hd__decap_12
XFILLER_171_337 VPWR VGND VPWR VGND sky130_ef_sc_hd__decap_12
XFILLER_178_1091 VGND VGND VPWR VPWR sky130_fd_sc_hd__fill_1
XFILLER_193_1567 VGND VGND VPWR VPWR sky130_fd_sc_hd__fill_1
XFILLER_180_893 VPWR VGND VPWR VGND sky130_ef_sc_hd__decap_12
XFILLER_154_1518 VGND VGND VPWR VPWR sky130_fd_sc_hd__decap_6
XTAP_TAPCELL_ROW_102_2_3644 VGND VPWR sky130_fd_sc_hd__tapvpwrvgnd_1
XFILLER_3_561 VGND VGND VPWR VPWR sky130_fd_sc_hd__decap_8
XTAP_TAPCELL_ROW_168_1519 VGND VPWR sky130_fd_sc_hd__tapvpwrvgnd_1
XFILLER_152_1220 VPWR VGND VPWR VGND sky130_ef_sc_hd__decap_12
XFILLER_65_1272 VGND VGND VPWR VPWR sky130_fd_sc_hd__fill_1
XFILLER_87_93 VPWR VGND VPWR VGND sky130_ef_sc_hd__decap_12
XTAP_TAPCELL_ROW_70_2_3433 VGND VPWR sky130_fd_sc_hd__tapvpwrvgnd_1
XTAP_TAPCELL_ROW_69_2_3427 VGND VPWR sky130_fd_sc_hd__tapvpwrvgnd_1
XFILLER_6_1317 VPWR VGND VPWR VGND sky130_ef_sc_hd__decap_12
XFILLER_117_1384 VGND VGND VPWR VPWR sky130_fd_sc_hd__fill_1
XFILLER_213_69 VPWR VGND VPWR VGND sky130_ef_sc_hd__decap_12
XFILLER_207_541 VPWR VGND VPWR VGND sky130_ef_sc_hd__decap_12
XFILLER_130_1562 VPWR VGND VPWR VGND sky130_ef_sc_hd__decap_12
XFILLER_4_1085 VGND VGND VPWR VPWR sky130_fd_sc_hd__decap_6
XFILLER_207_585 VPWR VGND VPWR VGND sky130_ef_sc_hd__decap_12
XTAP_TAPCELL_ROW_18_2_3094 VGND VPWR sky130_fd_sc_hd__tapvpwrvgnd_1
XFILLER_124_1300 VGND VGND VPWR VPWR sky130_fd_sc_hd__fill_1
XFILLER_72_1232 VPWR VGND VPWR VGND sky130_ef_sc_hd__decap_12
XPHY_EDGE_ROW_10_2_Left_442 VGND VGND VPWR VPWR sky130_fd_sc_hd__decap_3
XFILLER_37_1330 VPWR VGND VPWR VGND sky130_ef_sc_hd__decap_12
XFILLER_188_993 VPWR VGND VPWR VGND sky130_ef_sc_hd__decap_12
XFILLER_166_109 VPWR VGND VPWR VGND sky130_ef_sc_hd__decap_12
XFILLER_190_613 VPWR VGND VPWR VGND sky130_ef_sc_hd__decap_12
XFILLER_175_665 VGND VGND VPWR VPWR sky130_fd_sc_hd__decap_6
XFILLER_174_153 VPWR VGND VPWR VGND sky130_ef_sc_hd__decap_12
XFILLER_194_1309 VGND VGND VPWR VPWR sky130_fd_sc_hd__decap_6
XFILLER_174_197 VPWR VGND VPWR VGND sky130_ef_sc_hd__decap_12
XTAP_TAPCELL_ROW_11_2_3048 VGND VPWR sky130_fd_sc_hd__tapvpwrvgnd_1
XFILLER_50_1574 VGND VGND VPWR VPWR sky130_fd_sc_hd__decap_6
XFILLER_190_657 VPWR VGND VPWR VGND sky130_ef_sc_hd__decap_12
XFILLER_107_15 VPWR VGND VPWR VGND sky130_ef_sc_hd__decap_12
XFILLER_48_1470 VPWR VGND VPWR VGND sky130_ef_sc_hd__decap_12
XFILLER_170_1353 VPWR VGND VPWR VGND sky130_ef_sc_hd__decap_12
XFILLER_135_1440 VGND VGND VPWR VPWR sky130_fd_sc_hd__fill_1
XFILLER_44_1356 VGND VGND VPWR VPWR sky130_fd_sc_hd__fill_1
XFILLER_217_305 VPWR VGND VPWR VGND sky130_ef_sc_hd__decap_12
XTAP_TAPCELL_ROW_161_2_4026 VGND VPWR sky130_fd_sc_hd__tapvpwrvgnd_1
XFILLER_170_1397 VPWR VGND VPWR VGND sky130_ef_sc_hd__decap_12
XFILLER_217_349 VPWR VGND VPWR VGND sky130_ef_sc_hd__decap_12
XFILLER_123_69 VPWR VGND VPWR VGND sky130_ef_sc_hd__decap_12
XFILLER_198_713 VPWR VGND VPWR VGND sky130_ef_sc_hd__decap_12
XPHY_EDGE_ROW_21_2_Right_78 VGND VGND VPWR VPWR sky130_fd_sc_hd__decap_3
XFILLER_197_223 VGND VGND VPWR VPWR sky130_fd_sc_hd__fill_1
XFILLER_129_1244 VPWR VGND VPWR VGND sky130_ef_sc_hd__decap_12
XPHY_EDGE_ROW_0_Right_0 VGND VGND VPWR VPWR sky130_fd_sc_hd__decap_3
XPHY_EDGE_ROW_52_2_Right_109 VGND VGND VPWR VPWR sky130_fd_sc_hd__decap_3
XFILLER_198_757 VPWR VGND VPWR VGND sky130_ef_sc_hd__decap_12
XFILLER_205_1121 VPWR VGND VPWR VGND sky130_ef_sc_hd__decap_12
XPHY_EDGE_ROW_205_Left_424 VGND VGND VPWR VPWR sky130_fd_sc_hd__decap_3
XFILLER_185_429 VPWR VGND VPWR VGND sky130_ef_sc_hd__decap_12
XFILLER_146_1580 VGND VGND VPWR VPWR sky130_fd_sc_hd__fill_1
XFILLER_16_1414 VPWR VGND VPWR VGND sky130_ef_sc_hd__decap_12
XFILLER_201_1007 VGND VGND VPWR VPWR sky130_fd_sc_hd__fill_1
XFILLER_181_1493 VPWR VGND VPWR VGND sky130_ef_sc_hd__decap_12
XFILLER_166_643 VGND VGND VPWR VPWR sky130_fd_sc_hd__fill_1
XANTENNA__602__CLK clknet_3_7_0_clk VGND VGND VPWR VPWR sky130_fd_sc_hd__diode_2
XFILLER_32_55 VGND VGND VPWR VPWR sky130_fd_sc_hd__decap_4
XFILLER_55_1496 VGND VGND VPWR VPWR sky130_fd_sc_hd__fill_1
XFILLER_32_77 VGND VGND VPWR VPWR sky130_fd_sc_hd__decap_6
XFILLER_193_473 VPWR VGND VPWR VGND sky130_ef_sc_hd__decap_12
XFILLER_148_77 VGND VGND VPWR VPWR sky130_fd_sc_hd__decap_6
XFILLER_113_3 VPWR VGND VPWR VGND sky130_ef_sc_hd__decap_12
XFILLER_175_1231 VGND VGND VPWR VPWR sky130_fd_sc_hd__fill_1
XANTENNA__497__A1 net151 VGND VGND VPWR VPWR sky130_fd_sc_hd__diode_2
XFILLER_180_189 VGND VGND VPWR VPWR sky130_fd_sc_hd__decap_6
XFILLER_88_1294 VGND VGND VPWR VPWR sky130_fd_sc_hd__decap_6
XPHY_EDGE_ROW_86_2_Left_518 VGND VGND VPWR VPWR sky130_fd_sc_hd__decap_3
XFILLER_49_1256 VPWR VGND VPWR VGND sky130_ef_sc_hd__decap_12
XFILLER_164_65 VPWR VGND VPWR VGND sky130_ef_sc_hd__decap_12
XFILLER_27_1510 VPWR VGND VPWR VGND sky130_ef_sc_hd__decap_12
XTAP_TAPCELL_ROW_55_2_3335 VGND VPWR sky130_fd_sc_hd__tapvpwrvgnd_1
XFILLER_62_1412 VGND VGND VPWR VPWR sky130_fd_sc_hd__fill_1
XFILLER_216_1261 VPWR VGND VPWR VGND sky130_ef_sc_hd__decap_12
XPHY_EDGE_ROW_214_Left_433 VGND VGND VPWR VPWR sky130_fd_sc_hd__decap_3
XFILLER_27_1554 VPWR VGND VPWR VGND sky130_ef_sc_hd__decap_12
XFILLER_212_1147 VGND VGND VPWR VPWR sky130_fd_sc_hd__fill_1
XFILLER_114_1524 VGND VGND VPWR VPWR sky130_fd_sc_hd__fill_1
XANTENNA_input33_A func_wdata[29] VGND VGND VPWR VPWR sky130_fd_sc_hd__diode_2
XFILLER_209_839 VGND VGND VPWR VPWR sky130_fd_sc_hd__fill_1
XFILLER_180_53 VPWR VGND VPWR VGND sky130_ef_sc_hd__decap_12
XFILLER_180_97 VPWR VGND VPWR VGND sky130_ef_sc_hd__decap_12
XFILLER_169_1057 VGND VGND VPWR VPWR sky130_fd_sc_hd__decap_6
XFILLER_112_1270 VPWR VGND VPWR VGND sky130_ef_sc_hd__decap_12
XTAP_TAPCELL_ROW_4_892 VGND VPWR sky130_fd_sc_hd__tapvpwrvgnd_1
XFILLER_1_1225 VGND VGND VPWR VPWR sky130_fd_sc_hd__decap_6
XFILLER_95_1232 VPWR VGND VPWR VGND sky130_ef_sc_hd__decap_12
XFILLER_204_533 VPWR VGND VPWR VGND sky130_ef_sc_hd__decap_12
XFILLER_186_1371 VGND VGND VPWR VPWR sky130_fd_sc_hd__fill_1
XFILLER_147_1322 VGND VGND VPWR VPWR sky130_fd_sc_hd__decap_6
XFILLER_73_51 VGND VGND VPWR VPWR sky130_fd_sc_hd__decap_4
XFILLER_1_1269 VPWR VGND VPWR VGND sky130_ef_sc_hd__decap_12
XFILLER_188_245 VGND VGND VPWR VPWR sky130_fd_sc_hd__decap_6
XFILLER_189_51 VGND VGND VPWR VPWR sky130_fd_sc_hd__decap_4
XFILLER_147_1366 VPWR VGND VPWR VGND sky130_ef_sc_hd__decap_12
XFILLER_95_1298 VPWR VGND VPWR VGND sky130_ef_sc_hd__decap_12
XFILLER_188_289 VPWR VGND VPWR VGND sky130_ef_sc_hd__decap_12
XFILLER_148_109 VPWR VGND VPWR VGND sky130_ef_sc_hd__decap_12
XFILLER_73_1552 VGND VGND VPWR VPWR sky130_fd_sc_hd__fill_1
XPHY_EDGE_ROW_105_1_Right_691 VGND VGND VPWR VPWR sky130_fd_sc_hd__decap_3
XFILLER_176_1017 VPWR VGND VPWR VGND sky130_ef_sc_hd__decap_12
XFILLER_172_613 VPWR VGND VPWR VGND sky130_ef_sc_hd__decap_12
XFILLER_32_1282 VPWR VGND VPWR VGND sky130_ef_sc_hd__decap_12
XFILLER_172_657 VPWR VGND VPWR VGND sky130_ef_sc_hd__decap_12
XFILLER_171_167 VGND VGND VPWR VPWR sky130_fd_sc_hd__fill_1
XFILLER_158_1462 VGND VGND VPWR VPWR sky130_fd_sc_hd__decap_6
XTAP_TAPCELL_ROW_152_2_3963 VGND VPWR sky130_fd_sc_hd__tapvpwrvgnd_1
XFILLER_10_1580 VGND VGND VPWR VPWR sky130_fd_sc_hd__fill_1
XFILLER_154_1326 VPWR VGND VPWR VGND sky130_ef_sc_hd__decap_12
XFILLER_67_1378 VGND VGND VPWR VPWR sky130_fd_sc_hd__decap_6
XFILLER_132_1602 VGND VGND VPWR VPWR sky130_fd_sc_hd__decap_3
XTAP_TAPCELL_ROW_25_1_1067 VGND VPWR sky130_fd_sc_hd__tapvpwrvgnd_1
XFILLER_187_1113 VGND VGND VPWR VPWR sky130_fd_sc_hd__decap_6
XTAP_TAPCELL_ROW_99_2_3622 VGND VPWR sky130_fd_sc_hd__tapvpwrvgnd_1
XFILLER_6_1147 VGND VGND VPWR VPWR sky130_fd_sc_hd__fill_1
XFILLER_215_809 VPWR VGND VPWR VGND sky130_ef_sc_hd__decap_12
XFILLER_208_861 VGND VGND VPWR VPWR sky130_fd_sc_hd__decap_6
XFILLER_187_1157 VPWR VGND VPWR VGND sky130_ef_sc_hd__decap_12
XFILLER_130_1370 VPWR VGND VPWR VGND sky130_ef_sc_hd__decap_12
XFILLER_207_393 VPWR VGND VPWR VGND sky130_ef_sc_hd__decap_12
XFILLER_179_223 VGND VGND VPWR VPWR sky130_fd_sc_hd__fill_1
XFILLER_165_1455 VGND VGND VPWR VPWR sky130_fd_sc_hd__fill_1
XFILLER_126_1406 VGND VGND VPWR VPWR sky130_fd_sc_hd__decap_6
XFILLER_74_1338 VPWR VGND VPWR VGND sky130_ef_sc_hd__decap_12
XANTENNA__625__CLK clknet_3_1_0_clk VGND VGND VPWR VPWR sky130_fd_sc_hd__diode_2
XPHY_EDGE_ROW_52_1_Left_271 VGND VGND VPWR VPWR sky130_fd_sc_hd__decap_3
XFILLER_210_525 VGND VGND VPWR VPWR sky130_fd_sc_hd__decap_6
XFILLER_206_1441 VPWR VGND VPWR VGND sky130_ef_sc_hd__decap_12
XFILLER_195_727 VGND VGND VPWR VPWR sky130_fd_sc_hd__fill_1
XFILLER_167_429 VPWR VGND VPWR VGND sky130_ef_sc_hd__decap_12
XFILLER_210_569 VPWR VGND VPWR VGND sky130_ef_sc_hd__decap_12
XFILLER_206_1485 VPWR VGND VPWR VGND sky130_ef_sc_hd__decap_12
XFILLER_198_1253 VGND VGND VPWR VPWR sky130_fd_sc_hd__decap_6
XFILLER_191_933 VPWR VGND VPWR VGND sky130_ef_sc_hd__decap_12
XFILLER_190_421 VPWR VGND VPWR VGND sky130_ef_sc_hd__decap_12
XFILLER_175_473 VPWR VGND VPWR VGND sky130_ef_sc_hd__decap_12
XFILLER_163_613 VGND VGND VPWR VPWR sky130_fd_sc_hd__decap_3
XTAP_TAPCELL_ROW_80_1_1177 VGND VPWR sky130_fd_sc_hd__tapvpwrvgnd_1
XFILLER_11_1322 VGND VGND VPWR VPWR sky130_fd_sc_hd__decap_6
XFILLER_50_1382 VPWR VGND VPWR VGND sky130_ef_sc_hd__decap_12
XFILLER_200_1073 VPWR VGND VPWR VGND sky130_ef_sc_hd__decap_12
XFILLER_198_1297 VPWR VGND VPWR VGND sky130_ef_sc_hd__decap_12
XFILLER_194_1117 VPWR VGND VPWR VGND sky130_ef_sc_hd__decap_12
XFILLER_191_977 VPWR VGND VPWR VGND sky130_ef_sc_hd__decap_12
XFILLER_163_657 VPWR VGND VPWR VGND sky130_ef_sc_hd__decap_12
XFILLER_102_1450 VPWR VGND VPWR VGND sky130_ef_sc_hd__decap_12
XFILLER_11_1366 VPWR VGND VPWR VGND sky130_ef_sc_hd__decap_12
XFILLER_102_1494 VPWR VGND VPWR VGND sky130_ef_sc_hd__decap_12
XFILLER_85_1434 VGND VGND VPWR VPWR sky130_fd_sc_hd__decap_6
XFILLER_78_29 VPWR VGND VPWR VGND sky130_ef_sc_hd__decap_12
XTAP_TAPCELL_ROW_41_2_3243 VGND VPWR sky130_fd_sc_hd__tapvpwrvgnd_1
XFILLER_176_1595 VGND VGND VPWR VPWR sky130_fd_sc_hd__fill_1
XFILLER_137_1546 VGND VGND VPWR VPWR sky130_fd_sc_hd__decap_6
XFILLER_85_1478 VPWR VGND VPWR VGND sky130_ef_sc_hd__decap_12
XFILLER_1_339 VPWR VGND VPWR VGND sky130_ef_sc_hd__decap_12
XFILLER_217_1581 VPWR VGND VPWR VGND sky130_ef_sc_hd__decap_12
XFILLER_213_1401 VPWR VGND VPWR VGND sky130_ef_sc_hd__decap_12
XFILLER_170_1161 VPWR VGND VPWR VGND sky130_ef_sc_hd__decap_12
XFILLER_218_625 VPWR VGND VPWR VGND sky130_ef_sc_hd__decap_12
XFILLER_217_113 VPWR VGND VPWR VGND sky130_ef_sc_hd__decap_12
XANTENNA_clkbuf_3_1_0_clk_A clknet_0_clk VGND VGND VPWR VPWR sky130_fd_sc_hd__diode_2
XFILLER_218_669 VPWR VGND VPWR VGND sky130_ef_sc_hd__decap_12
XFILLER_22_1462 VGND VGND VPWR VPWR sky130_fd_sc_hd__decap_6
XFILLER_113_1590 VPWR VGND VPWR VGND sky130_ef_sc_hd__decap_12
XFILLER_183_1511 VGND VGND VPWR VPWR sky130_fd_sc_hd__fill_1
XFILLER_96_1574 VGND VGND VPWR VPWR sky130_fd_sc_hd__decap_6
X_460_ net146 net118 VGND VGND VPWR VPWR _192_ sky130_fd_sc_hd__xor2_1
XFILLER_2_1589 VGND VGND VPWR VPWR sky130_fd_sc_hd__decap_6
XFILLER_201_503 VGND VGND VPWR VPWR sky130_fd_sc_hd__fill_1
XFILLER_144_1506 VPWR VGND VPWR VGND sky130_ef_sc_hd__decap_12
XFILLER_92_1438 VPWR VGND VPWR VGND sky130_ef_sc_hd__decap_12
X_391_ b_addr\[0\] _120_ _121_ VGND VGND VPWR VPWR _129_ sky130_fd_sc_hd__a21oi_2
XFILLER_213_385 VGND VGND VPWR VPWR sky130_fd_sc_hd__decap_6
XFILLER_198_587 VGND VGND VPWR VPWR sky130_fd_sc_hd__fill_1
XFILLER_186_749 VGND VGND VPWR VPWR sky130_fd_sc_hd__decap_6
XFILLER_185_237 VPWR VGND VPWR VGND sky130_ef_sc_hd__decap_12
XFILLER_16_1244 VGND VGND VPWR VPWR sky130_fd_sc_hd__fill_1
XFILLER_194_793 VPWR VGND VPWR VGND sky130_ef_sc_hd__decap_12
XFILLER_193_281 VPWR VGND VPWR VGND sky130_ef_sc_hd__decap_12
XFILLER_5_601 VGND VGND VPWR VPWR sky130_fd_sc_hd__fill_1
XFILLER_177_1337 VGND VGND VPWR VPWR sky130_fd_sc_hd__decap_6
XFILLER_120_1550 VPWR VGND VPWR VGND sky130_ef_sc_hd__decap_12
XFILLER_155_1602 VGND VGND VPWR VPWR sky130_fd_sc_hd__decap_3
XFILLER_120_1594 VGND VGND VPWR VPWR sky130_fd_sc_hd__decap_8
XFILLER_4_15 VPWR VGND VPWR VGND sky130_ef_sc_hd__decap_12
XFILLER_64_1518 VGND VGND VPWR VPWR sky130_fd_sc_hd__decap_6
XFILLER_4_188 VGND VGND VPWR VPWR sky130_fd_sc_hd__decap_8
XTAP_TAPCELL_ROW_117_2_3741 VGND VPWR sky130_fd_sc_hd__tapvpwrvgnd_1
XFILLER_7_1401 VPWR VGND VPWR VGND sky130_ef_sc_hd__decap_12
XFILLER_62_1220 VPWR VGND VPWR VGND sky130_ef_sc_hd__decap_12
XFILLER_1_895 VGND VGND VPWR VPWR sky130_fd_sc_hd__fill_1
XFILLER_0_361 VGND VGND VPWR VPWR sky130_fd_sc_hd__decap_3
XFILLER_216_1091 VGND VGND VPWR VPWR sky130_fd_sc_hd__fill_1
XTAP_TAPCELL_ROW_85_2_3530 VGND VPWR sky130_fd_sc_hd__tapvpwrvgnd_1
XFILLER_27_1384 VGND VGND VPWR VPWR sky130_fd_sc_hd__fill_1
XFILLER_188_1477 VGND VGND VPWR VPWR sky130_fd_sc_hd__decap_6
XFILLER_90_121 VGND VGND VPWR VPWR sky130_fd_sc_hd__decap_6
XFILLER_84_83 VGND VGND VPWR VPWR sky130_fd_sc_hd__fill_1
XFILLER_1_1033 VPWR VGND VPWR VGND sky130_ef_sc_hd__decap_12
XFILLER_40_1562 VPWR VGND VPWR VGND sky130_ef_sc_hd__decap_12
XFILLER_210_15 VPWR VGND VPWR VGND sky130_ef_sc_hd__decap_12
XFILLER_205_853 VPWR VGND VPWR VGND sky130_ef_sc_hd__decap_12
XFILLER_1_1077 VPWR VGND VPWR VGND sky130_ef_sc_hd__decap_12
X_589_ clknet_3_0_0_clk _023_ VGND VGND VPWR VPWR b_addr\[5\] sky130_fd_sc_hd__dfxtp_2
XFILLER_205_897 VPWR VGND VPWR VGND sky130_ef_sc_hd__decap_12
XFILLER_204_363 VGND VGND VPWR VPWR sky130_fd_sc_hd__fill_1
XFILLER_177_727 VGND VGND VPWR VPWR sky130_fd_sc_hd__fill_1
XFILLER_34_1300 VGND VGND VPWR VPWR sky130_fd_sc_hd__fill_1
XFILLER_76_3 VPWR VGND VPWR VGND sky130_ef_sc_hd__decap_12
XFILLER_219_57 VPWR VGND VPWR VGND sky130_ef_sc_hd__decap_12
XFILLER_173_933 VPWR VGND VPWR VGND sky130_ef_sc_hd__decap_12
XFILLER_172_421 VPWR VGND VPWR VGND sky130_ef_sc_hd__decap_12
XPHY_EDGE_ROW_106_1_Right_692 VGND VGND VPWR VPWR sky130_fd_sc_hd__decap_3
XFILLER_195_1437 VPWR VGND VPWR VGND sky130_ef_sc_hd__decap_12
XFILLER_173_977 VPWR VGND VPWR VGND sky130_ef_sc_hd__decap_12
XANTENNA__442__X _174_ VGND VGND VPWR VPWR sky130_fd_sc_hd__diode_2
XTAP_TAPCELL_ROW_26_2_3145 VGND VPWR sky130_fd_sc_hd__tapvpwrvgnd_1
XFILLER_201_1393 VGND VGND VPWR VPWR sky130_fd_sc_hd__decap_6
XFILLER_158_1270 VPWR VGND VPWR VGND sky130_ef_sc_hd__decap_12
XFILLER_119_1232 VPWR VGND VPWR VGND sky130_ef_sc_hd__decap_12
XANTENNA__330__A0 b_addr\[5\] VGND VGND VPWR VPWR sky130_fd_sc_hd__diode_2
XFILLER_119_1298 VPWR VGND VPWR VGND sky130_ef_sc_hd__decap_12
XFILLER_45_1440 VGND VGND VPWR VPWR sky130_fd_sc_hd__fill_1
XFILLER_171_1481 VPWR VGND VPWR VGND sky130_ef_sc_hd__decap_12
XFILLER_104_27 VGND VGND VPWR VPWR sky130_fd_sc_hd__fill_1
XFILLER_215_617 VPWR VGND VPWR VGND sky130_ef_sc_hd__decap_12
XFILLER_199_329 VGND VGND VPWR VPWR sky130_fd_sc_hd__decap_6
XFILLER_120_15 VPWR VGND VPWR VGND sky130_ef_sc_hd__decap_12
XFILLER_78_1282 VPWR VGND VPWR VGND sky130_ef_sc_hd__decap_12
XFILLER_39_1244 VPWR VGND VPWR VGND sky130_ef_sc_hd__decap_12
XFILLER_210_333 VPWR VGND VPWR VGND sky130_ef_sc_hd__decap_12
XFILLER_168_749 VGND VGND VPWR VPWR sky130_fd_sc_hd__decap_6
XFILLER_167_237 VPWR VGND VPWR VGND sky130_ef_sc_hd__decap_12
XFILLER_126_1258 VPWR VGND VPWR VGND sky130_ef_sc_hd__decap_12
XFILLER_56_1580 VGND VGND VPWR VPWR sky130_fd_sc_hd__fill_1
XFILLER_211_889 VGND VGND VPWR VPWR sky130_fd_sc_hd__decap_6
XFILLER_210_377 VPWR VGND VPWR VGND sky130_ef_sc_hd__decap_12
XFILLER_13_57 VPWR VGND VPWR VGND sky130_ef_sc_hd__decap_12
XTAP_TAPCELL_ROW_192_2198 VGND VPWR sky130_fd_sc_hd__tapvpwrvgnd_1
XFILLER_176_793 VPWR VGND VPWR VGND sky130_ef_sc_hd__decap_12
XFILLER_129_57 VPWR VGND VPWR VGND sky130_ef_sc_hd__decap_12
XFILLER_198_1061 VPWR VGND VPWR VGND sky130_ef_sc_hd__decap_12
XFILLER_191_741 VPWR VGND VPWR VGND sky130_ef_sc_hd__decap_12
XFILLER_175_281 VPWR VGND VPWR VGND sky130_ef_sc_hd__decap_12
XFILLER_163_421 VPWR VGND VPWR VGND sky130_ef_sc_hd__decap_12
XFILLER_89_39 VPWR VGND VPWR VGND sky130_ef_sc_hd__decap_12
XFILLER_191_785 VPWR VGND VPWR VGND sky130_ef_sc_hd__decap_12
XFILLER_190_251 VGND VGND VPWR VPWR sky130_fd_sc_hd__fill_1
XFILLER_85_1220 VPWR VGND VPWR VGND sky130_ef_sc_hd__decap_12
XFILLER_137_1310 VPWR VGND VPWR VGND sky130_ef_sc_hd__decap_12
XFILLER_1_125 VGND VGND VPWR VPWR sky130_fd_sc_hd__decap_4
XFILLER_137_1354 VPWR VGND VPWR VGND sky130_ef_sc_hd__decap_12
XFILLER_85_1286 VPWR VGND VPWR VGND sky130_ef_sc_hd__decap_12
XFILLER_137_1398 VPWR VGND VPWR VGND sky130_ef_sc_hd__decap_12
XTAP_TAPCELL_ROW_103_1_1223 VGND VPWR sky130_fd_sc_hd__tapvpwrvgnd_1
XTAP_TAPCELL_ROW_6_954 VGND VPWR sky130_fd_sc_hd__tapvpwrvgnd_1
XFILLER_213_1231 VGND VGND VPWR VPWR sky130_fd_sc_hd__fill_1
XTAP_TAPCELL_ROW_6_965 VGND VPWR sky130_fd_sc_hd__tapvpwrvgnd_1
XTAP_TAPCELL_ROW_6_976 VGND VPWR sky130_fd_sc_hd__tapvpwrvgnd_1
XFILLER_24_1524 VGND VGND VPWR VPWR sky130_fd_sc_hd__fill_1
XFILLER_218_433 VPWR VGND VPWR VGND sky130_ef_sc_hd__decap_12
XFILLER_180_3 VPWR VGND VPWR VGND sky130_ef_sc_hd__decap_12
XFILLER_161_55 VGND VGND VPWR VPWR sky130_fd_sc_hd__fill_1
XFILLER_38_65 VPWR VGND VPWR VGND sky130_ef_sc_hd__decap_12
XFILLER_218_477 VPWR VGND VPWR VGND sky130_ef_sc_hd__decap_12
XFILLER_205_105 VGND VGND VPWR VPWR sky130_fd_sc_hd__decap_6
XFILLER_166_1005 VPWR VGND VPWR VGND sky130_ef_sc_hd__decap_12
XFILLER_72_121 VGND VGND VPWR VPWR sky130_fd_sc_hd__decap_6
XFILLER_22_1270 VPWR VGND VPWR VGND sky130_ef_sc_hd__decap_12
XTAP_TAPCELL_ROW_181_1891 VGND VPWR sky130_fd_sc_hd__tapvpwrvgnd_1
XFILLER_2_1353 VPWR VGND VPWR VGND sky130_ef_sc_hd__decap_12
X_512_ net62 net123 VGND VGND VPWR VPWR _230_ sky130_fd_sc_hd__or2_1
XFILLER_54_20 VGND VGND VPWR VPWR sky130_fd_sc_hd__decap_8
XFILLER_205_149 VPWR VGND VPWR VGND sky130_ef_sc_hd__decap_12
XFILLER_199_841 VPWR VGND VPWR VGND sky130_ef_sc_hd__decap_12
XFILLER_166_1049 VPWR VGND VPWR VGND sky130_ef_sc_hd__decap_12
XFILLER_148_1450 VPWR VGND VPWR VGND sky130_ef_sc_hd__decap_12
XFILLER_96_1382 VPWR VGND VPWR VGND sky130_ef_sc_hd__decap_12
X_443_ net147 net100 VGND VGND VPWR VPWR _175_ sky130_fd_sc_hd__xor2_1
XFILLER_2_1397 VPWR VGND VPWR VGND sky130_ef_sc_hd__decap_12
XANTENNA__388__B1 net156 VGND VGND VPWR VPWR sky130_fd_sc_hd__diode_2
XFILLER_54_53 VPWR VGND VPWR VGND sky130_ef_sc_hd__decap_12
XFILLER_57_1322 VGND VGND VPWR VPWR sky130_fd_sc_hd__decap_6
XFILLER_186_513 VPWR VGND VPWR VGND sky130_ef_sc_hd__decap_12
XFILLER_148_1494 VPWR VGND VPWR VGND sky130_ef_sc_hd__decap_12
XFILLER_144_1314 VPWR VGND VPWR VGND sky130_ef_sc_hd__decap_12
XFILLER_109_1434 VGND VGND VPWR VPWR sky130_fd_sc_hd__decap_6
XFILLER_92_1246 VPWR VGND VPWR VGND sky130_ef_sc_hd__decap_12
XFILLER_57_1366 VPWR VGND VPWR VGND sky130_ef_sc_hd__decap_12
XFILLER_213_193 VPWR VGND VPWR VGND sky130_ef_sc_hd__decap_12
XFILLER_207_1057 VGND VGND VPWR VPWR sky130_fd_sc_hd__decap_6
XFILLER_202_867 VGND VGND VPWR VPWR sky130_fd_sc_hd__fill_1
XFILLER_144_1358 VPWR VGND VPWR VGND sky130_ef_sc_hd__decap_12
XFILLER_109_1478 VPWR VGND VPWR VGND sky130_ef_sc_hd__decap_12
X_374_ _103_ _110_ _114_ _109_ u_ctrl.elem_idx\[2\] VGND VGND VPWR VPWR _115_ sky130_fd_sc_hd__a32o_1
XTAP_TAPCELL_ROW_32_2_3188 VGND VPWR sky130_fd_sc_hd__tapvpwrvgnd_1
XFILLER_186_557 VPWR VGND VPWR VGND sky130_ef_sc_hd__decap_12
XFILLER_70_41 VPWR VGND VPWR VGND sky130_ef_sc_hd__decap_12
XTAP_TAPCELL_ROW_8_2_3029 VGND VPWR sky130_fd_sc_hd__tapvpwrvgnd_1
XFILLER_186_41 VPWR VGND VPWR VGND sky130_ef_sc_hd__decap_12
XFILLER_70_85 VPWR VGND VPWR VGND sky130_ef_sc_hd__decap_12
XTAP_TAPCELL_ROW_12_2_3053 VGND VPWR sky130_fd_sc_hd__tapvpwrvgnd_1
XFILLER_186_85 VPWR VGND VPWR VGND sky130_ef_sc_hd__decap_12
XFILLER_177_1101 VPWR VGND VPWR VGND sky130_ef_sc_hd__decap_12
XFILLER_177_1145 VPWR VGND VPWR VGND sky130_ef_sc_hd__decap_12
XFILLER_170_925 VPWR VGND VPWR VGND sky130_ef_sc_hd__decap_12
XFILLER_55_8 VPWR VGND VPWR VGND sky130_ef_sc_hd__decap_12
XFILLER_181_273 VGND VGND VPWR VPWR sky130_fd_sc_hd__decap_6
XFILLER_177_1189 VPWR VGND VPWR VGND sky130_ef_sc_hd__decap_12
XFILLER_173_1009 VPWR VGND VPWR VGND sky130_ef_sc_hd__decap_12
XFILLER_159_1590 VPWR VGND VPWR VGND sky130_ef_sc_hd__decap_12
XFILLER_155_1410 VPWR VGND VPWR VGND sky130_ef_sc_hd__decap_12
XFILLER_68_1462 VGND VGND VPWR VPWR sky130_fd_sc_hd__decap_6
XPHY_EDGE_ROW_165_Left_384 VGND VGND VPWR VPWR sky130_fd_sc_hd__decap_3
XFILLER_155_1454 VPWR VGND VPWR VGND sky130_ef_sc_hd__decap_12
XFILLER_64_1326 VPWR VGND VPWR VGND sky130_ef_sc_hd__decap_12
XFILLER_218_1197 VGND VGND VPWR VPWR sky130_fd_sc_hd__decap_6
XFILLER_214_1017 VPWR VGND VPWR VGND sky130_ef_sc_hd__decap_12
XFILLER_205_15 VPWR VGND VPWR VGND sky130_ef_sc_hd__decap_12
XFILLER_155_1498 VPWR VGND VPWR VGND sky130_ef_sc_hd__decap_12
XFILLER_116_1438 VPWR VGND VPWR VGND sky130_ef_sc_hd__decap_12
XFILLER_42_1602 VGND VGND VPWR VPWR sky130_fd_sc_hd__decap_3
XTAP_TAPCELL_ROW_162_2_4031 VGND VPWR sky130_fd_sc_hd__tapvpwrvgnd_1
XFILLER_1_692 VPWR VGND VPWR VGND sky130_ef_sc_hd__decap_12
XFILLER_95_93 VPWR VGND VPWR VGND sky130_ef_sc_hd__decap_12
XFILLER_188_1241 VPWR VGND VPWR VGND sky130_ef_sc_hd__decap_12
XFILLER_188_1285 VPWR VGND VPWR VGND sky130_ef_sc_hd__decap_12
XFILLER_184_1105 VPWR VGND VPWR VGND sky130_ef_sc_hd__decap_12
XFILLER_40_1370 VPWR VGND VPWR VGND sky130_ef_sc_hd__decap_12
XFILLER_184_1149 VPWR VGND VPWR VGND sky130_ef_sc_hd__decap_12
XPHY_EDGE_ROW_174_Left_393 VGND VGND VPWR VPWR sky130_fd_sc_hd__decap_3
XFILLER_75_1422 VPWR VGND VPWR VGND sky130_ef_sc_hd__decap_12
XANTENNA__437__X _169_ VGND VGND VPWR VPWR sky130_fd_sc_hd__diode_2
XFILLER_162_1414 VPWR VGND VPWR VGND sky130_ef_sc_hd__decap_12
XFILLER_127_1534 VPWR VGND VPWR VGND sky130_ef_sc_hd__decap_12
XFILLER_75_1466 VPWR VGND VPWR VGND sky130_ef_sc_hd__decap_12
XFILLER_36_1406 VGND VGND VPWR VPWR sky130_fd_sc_hd__decap_6
XFILLER_189_373 VPWR VGND VPWR VGND sky130_ef_sc_hd__decap_12
XFILLER_127_1578 VPWR VGND VPWR VGND sky130_ef_sc_hd__decap_12
XTAP_TAPCELL_ROW_96_2_3599 VGND VPWR sky130_fd_sc_hd__tapvpwrvgnd_1
XFILLER_203_1455 VGND VGND VPWR VPWR sky130_fd_sc_hd__fill_1
XFILLER_199_1381 VPWR VGND VPWR VGND sky130_ef_sc_hd__decap_12
XFILLER_195_1201 VPWR VGND VPWR VGND sky130_ef_sc_hd__decap_12
XFILLER_173_741 VPWR VGND VPWR VGND sky130_ef_sc_hd__decap_12
XTAP_TAPCELL_ROW_76_2_3475 VGND VPWR sky130_fd_sc_hd__tapvpwrvgnd_1
XFILLER_195_1245 VPWR VGND VPWR VGND sky130_ef_sc_hd__decap_12
XFILLER_173_785 VPWR VGND VPWR VGND sky130_ef_sc_hd__decap_12
XFILLER_172_251 VGND VGND VPWR VPWR sky130_fd_sc_hd__fill_1
XPHY_EDGE_ROW_107_1_Right_693 VGND VGND VPWR VPWR sky130_fd_sc_hd__decap_3
XFILLER_12_1450 VPWR VGND VPWR VGND sky130_ef_sc_hd__decap_12
XTAP_TAPCELL_ROW_212_2780 VGND VPWR sky130_fd_sc_hd__tapvpwrvgnd_1
XFILLER_195_1289 VPWR VGND VPWR VGND sky130_ef_sc_hd__decap_12
XFILLER_86_1562 VPWR VGND VPWR VGND sky130_ef_sc_hd__decap_12
XFILLER_12_1494 VPWR VGND VPWR VGND sky130_ef_sc_hd__decap_12
XPHY_EDGE_ROW_30_2_Right_87 VGND VGND VPWR VPWR sky130_fd_sc_hd__decap_3
XTAP_TAPCELL_ROW_212_2791 VGND VPWR sky130_fd_sc_hd__tapvpwrvgnd_1
XFILLER_82_1426 VPWR VGND VPWR VGND sky130_ef_sc_hd__decap_12
XFILLER_47_1546 VGND VGND VPWR VPWR sky130_fd_sc_hd__decap_6
XTAP_TAPCELL_ROW_56_2_3340 VGND VPWR sky130_fd_sc_hd__tapvpwrvgnd_1
XFILLER_134_1538 VPWR VGND VPWR VGND sky130_ef_sc_hd__decap_12
XFILLER_115_15 VPWR VGND VPWR VGND sky130_ef_sc_hd__decap_12
XFILLER_214_1595 VGND VGND VPWR VPWR sky130_fd_sc_hd__fill_1
XFILLER_216_937 VPWR VGND VPWR VGND sky130_ef_sc_hd__decap_12
XFILLER_54_110 VPWR VGND VPWR VGND sky130_ef_sc_hd__decap_12
XFILLER_215_447 VGND VGND VPWR VPWR sky130_fd_sc_hd__fill_1
XFILLER_167_1325 VPWR VGND VPWR VGND sky130_ef_sc_hd__decap_12
XFILLER_23_1590 VPWR VGND VPWR VGND sky130_ef_sc_hd__decap_12
XFILLER_203_609 VGND VGND VPWR VPWR sky130_fd_sc_hd__decap_6
XFILLER_199_137 VPWR VGND VPWR VGND sky130_ef_sc_hd__decap_12
XFILLER_167_1369 VPWR VGND VPWR VGND sky130_ef_sc_hd__decap_12
XFILLER_131_69 VPWR VGND VPWR VGND sky130_ef_sc_hd__decap_12
XFILLER_110_1582 VPWR VGND VPWR VGND sky130_ef_sc_hd__decap_12
XFILLER_93_1522 VPWR VGND VPWR VGND sky130_ef_sc_hd__decap_12
XTAP_TAPCELL_ROW_198_2396 VGND VPWR sky130_fd_sc_hd__tapvpwrvgnd_1
XTAP_TAPCELL_ROW_198_2385 VGND VPWR sky130_fd_sc_hd__tapvpwrvgnd_1
XTAP_TAPCELL_ROW_198_2374 VGND VPWR sky130_fd_sc_hd__tapvpwrvgnd_1
XFILLER_196_811 VGND VGND VPWR VPWR sky130_fd_sc_hd__fill_1
XFILLER_93_1566 VPWR VGND VPWR VGND sky130_ef_sc_hd__decap_12
XFILLER_24_23 VGND VGND VPWR VPWR sky130_fd_sc_hd__decap_4
XFILLER_54_1506 VPWR VGND VPWR VGND sky130_ef_sc_hd__decap_12
XFILLER_211_653 VPWR VGND VPWR VGND sky130_ef_sc_hd__decap_12
XFILLER_168_513 VPWR VGND VPWR VGND sky130_ef_sc_hd__decap_12
XPHY_EDGE_ROW_95_2_Left_527 VGND VGND VPWR VPWR sky130_fd_sc_hd__decap_3
XTAP_TAPCELL_ROW_219_2978 VGND VPWR sky130_fd_sc_hd__tapvpwrvgnd_1
XFILLER_210_141 VPWR VGND VPWR VGND sky130_ef_sc_hd__decap_12
XFILLER_183_505 VPWR VGND VPWR VGND sky130_ef_sc_hd__decap_12
XFILLER_168_557 VPWR VGND VPWR VGND sky130_ef_sc_hd__decap_12
XTAP_TAPCELL_ROW_219_2989 VGND VPWR sky130_fd_sc_hd__tapvpwrvgnd_1
XFILLER_211_697 VPWR VGND VPWR VGND sky130_ef_sc_hd__decap_12
XFILLER_7_729 VPWR VGND VPWR VGND sky130_ef_sc_hd__decap_12
XPHY_EDGE_ROW_15_1_Left_234 VGND VGND VPWR VPWR sky130_fd_sc_hd__decap_3
XFILLER_178_1421 VGND VGND VPWR VPWR sky130_fd_sc_hd__decap_6
XFILLER_178_1465 VPWR VGND VPWR VGND sky130_ef_sc_hd__decap_12
XFILLER_3_913 VGND VGND VPWR VPWR sky130_fd_sc_hd__decap_8
XFILLER_30_1550 VPWR VGND VPWR VGND sky130_ef_sc_hd__decap_12
XFILLER_40_77 VGND VGND VPWR VPWR sky130_fd_sc_hd__decap_6
XFILLER_174_1329 VPWR VGND VPWR VGND sky130_ef_sc_hd__decap_12
XFILLER_156_77 VGND VGND VPWR VPWR sky130_fd_sc_hd__decap_6
XFILLER_65_1602 VGND VGND VPWR VPWR sky130_fd_sc_hd__decap_3
XFILLER_3_946 VGND VGND VPWR VPWR sky130_fd_sc_hd__decap_6
XFILLER_30_1594 VGND VGND VPWR VPWR sky130_fd_sc_hd__decap_8
XTAP_TAPCELL_ROW_170_1592 VGND VPWR sky130_fd_sc_hd__tapvpwrvgnd_1
XTAP_TAPCELL_ROW_170_1581 VGND VPWR sky130_fd_sc_hd__tapvpwrvgnd_1
XFILLER_6_3 VPWR VGND VPWR VGND sky130_ef_sc_hd__decap_12
XFILLER_49_20 VPWR VGND VPWR VGND sky130_ef_sc_hd__decap_12
XFILLER_215_1337 VGND VGND VPWR VPWR sky130_fd_sc_hd__decap_6
XFILLER_172_65 VPWR VGND VPWR VGND sky130_ef_sc_hd__decap_12
XFILLER_8_1562 VPWR VGND VPWR VGND sky130_ef_sc_hd__decap_12
XFILLER_219_753 VGND VGND VPWR VPWR sky130_fd_sc_hd__decap_3
XTAP_TAPCELL_ROW_183_1942 VGND VPWR sky130_fd_sc_hd__tapvpwrvgnd_1
XFILLER_1_27 VPWR VGND VPWR VGND sky130_ef_sc_hd__decap_12
XFILLER_189_1561 VGND VGND VPWR VPWR sky130_fd_sc_hd__decap_6
XTAP_TAPCELL_ROW_183_1964 VGND VPWR sky130_fd_sc_hd__tapvpwrvgnd_1
XTAP_TAPCELL_ROW_183_1953 VGND VPWR sky130_fd_sc_hd__tapvpwrvgnd_1
XFILLER_105_81 VPWR VGND VPWR VGND sky130_ef_sc_hd__decap_12
XFILLER_219_797 VPWR VGND VPWR VGND sky130_ef_sc_hd__decap_12
XFILLER_185_1425 VPWR VGND VPWR VGND sky130_ef_sc_hd__decap_12
XFILLER_209_1119 VGND VGND VPWR VPWR sky130_fd_sc_hd__fill_1
XFILLER_206_469 VGND VGND VPWR VPWR sky130_fd_sc_hd__decap_6
XFILLER_185_1469 VPWR VGND VPWR VGND sky130_ef_sc_hd__decap_12
XFILLER_2_1161 VPWR VGND VPWR VGND sky130_ef_sc_hd__decap_12
XFILLER_199_671 VGND VGND VPWR VPWR sky130_fd_sc_hd__fill_1
XFILLER_109_1220 VPWR VGND VPWR VGND sky130_ef_sc_hd__decap_12
XFILLER_187_833 VGND VGND VPWR VPWR sky130_fd_sc_hd__decap_6
XFILLER_186_321 VPWR VGND VPWR VGND sky130_ef_sc_hd__decap_12
XFILLER_81_51 VGND VGND VPWR VPWR sky130_fd_sc_hd__decap_4
X_426_ _140_ _149_ _155_ _159_ VGND VGND VPWR VPWR _160_ sky130_fd_sc_hd__o31a_1
XFILLER_197_51 VGND VGND VPWR VPWR sky130_fd_sc_hd__decap_4
XFILLER_187_877 VPWR VGND VPWR VGND sky130_ef_sc_hd__decap_12
XFILLER_109_1286 VPWR VGND VPWR VGND sky130_ef_sc_hd__decap_12
X_357_ u_ctrl.op_idx _099_ _100_ _075_ VGND VGND VPWR VPWR _101_ sky130_fd_sc_hd__a22o_1
XFILLER_186_365 VPWR VGND VPWR VGND sky130_ef_sc_hd__decap_12
XTAP_TAPCELL_ROW_177_1779 VGND VPWR sky130_fd_sc_hd__tapvpwrvgnd_1
XTAP_TAPCELL_ROW_62_2_3383 VGND VPWR sky130_fd_sc_hd__tapvpwrvgnd_1
XFILLER_196_1521 VPWR VGND VPWR VGND sky130_ef_sc_hd__decap_12
X_288_ net1 net46 VGND VGND VPWR VPWR _083_ sky130_fd_sc_hd__nor2_2
XFILLER_196_1565 VPWR VGND VPWR VGND sky130_ef_sc_hd__decap_12
XFILLER_192_1429 VPWR VGND VPWR VGND sky130_ef_sc_hd__decap_12
XPHY_EDGE_ROW_143_2_Right_200 VGND VGND VPWR VPWR sky130_fd_sc_hd__decap_3
XFILLER_5_261 VGND VGND VPWR VPWR sky130_fd_sc_hd__decap_4
XFILLER_170_755 VGND VGND VPWR VPWR sky130_fd_sc_hd__fill_1
XFILLER_68_1270 VPWR VGND VPWR VGND sky130_ef_sc_hd__decap_12
XFILLER_29_1232 VPWR VGND VPWR VGND sky130_ef_sc_hd__decap_12
XFILLER_39_3 VPWR VGND VPWR VGND sky130_ef_sc_hd__decap_12
XFILLER_116_1246 VPWR VGND VPWR VGND sky130_ef_sc_hd__decap_12
XFILLER_29_1298 VPWR VGND VPWR VGND sky130_ef_sc_hd__decap_12
XPHY_EDGE_ROW_61_1_Left_280 VGND VGND VPWR VPWR sky130_fd_sc_hd__decap_3
XFILLER_190_1197 VGND VGND VPWR VPWR sky130_fd_sc_hd__decap_6
Xinput4 func_addr[1] VGND VGND VPWR VPWR net4 sky130_fd_sc_hd__clkbuf_1
XPHY_EDGE_ROW_182_Left_401 VGND VGND VPWR VPWR sky130_fd_sc_hd__decap_3
XFILLER_188_1093 VPWR VGND VPWR VGND sky130_ef_sc_hd__decap_12
XFILLER_164_1509 VPWR VGND VPWR VGND sky130_ef_sc_hd__decap_12
XFILLER_206_981 VPWR VGND VPWR VGND sky130_ef_sc_hd__decap_12
XFILLER_178_811 VGND VGND VPWR VPWR sky130_fd_sc_hd__fill_1
XFILLER_101_39 VPWR VGND VPWR VGND sky130_ef_sc_hd__decap_12
XFILLER_51_113 VPWR VGND VPWR VGND sky130_ef_sc_hd__decap_12
XTAP_TAPCELL_ROW_201_2481 VGND VPWR sky130_fd_sc_hd__tapvpwrvgnd_1
XTAP_TAPCELL_ROW_201_2470 VGND VPWR sky130_fd_sc_hd__tapvpwrvgnd_1
XFILLER_189_181 VPWR VGND VPWR VGND sky130_ef_sc_hd__decap_12
XFILLER_127_1342 VPWR VGND VPWR VGND sky130_ef_sc_hd__decap_12
XFILLER_75_1274 VPWR VGND VPWR VGND sky130_ef_sc_hd__decap_12
XFILLER_162_1244 VGND VGND VPWR VPWR sky130_fd_sc_hd__fill_1
XFILLER_127_1386 VPWR VGND VPWR VGND sky130_ef_sc_hd__decap_12
XFILLER_36_1258 VPWR VGND VPWR VGND sky130_ef_sc_hd__decap_12
XFILLER_165_505 VPWR VGND VPWR VGND sky130_ef_sc_hd__decap_12
XTAP_TAPCELL_ROW_127_1_1271 VGND VPWR sky130_fd_sc_hd__tapvpwrvgnd_1
XANTENNA_fanout133_A _087_ VGND VGND VPWR VPWR sky130_fd_sc_hd__diode_2
XTAP_TAPCELL_ROW_214_2831 VGND VPWR sky130_fd_sc_hd__tapvpwrvgnd_1
XPHY_EDGE_ROW_191_Left_410 VGND VGND VPWR VPWR sky130_fd_sc_hd__decap_3
XFILLER_88_1602 VGND VGND VPWR VPWR sky130_fd_sc_hd__decap_3
XTAP_TAPCELL_ROW_214_2853 VGND VPWR sky130_fd_sc_hd__tapvpwrvgnd_1
XTAP_TAPCELL_ROW_214_2842 VGND VPWR sky130_fd_sc_hd__tapvpwrvgnd_1
XFILLER_192_357 VGND VGND VPWR VPWR sky130_fd_sc_hd__decap_6
XFILLER_3_209 VPWR VGND VPWR VGND sky130_ef_sc_hd__decap_12
XTAP_TAPCELL_ROW_32_1_1082 VGND VPWR sky130_fd_sc_hd__tapvpwrvgnd_1
XTAP_TAPCELL_ROW_210_2739 VGND VPWR sky130_fd_sc_hd__tapvpwrvgnd_1
XTAP_TAPCELL_ROW_210_2728 VGND VPWR sky130_fd_sc_hd__tapvpwrvgnd_1
XTAP_TAPCELL_ROW_210_2717 VGND VPWR sky130_fd_sc_hd__tapvpwrvgnd_1
XPHY_EDGE_ROW_108_1_Right_694 VGND VGND VPWR VPWR sky130_fd_sc_hd__decap_3
XTAP_TAPCELL_ROW_151_2_3959 VGND VPWR sky130_fd_sc_hd__tapvpwrvgnd_1
XFILLER_86_1370 VPWR VGND VPWR VGND sky130_ef_sc_hd__decap_12
XFILLER_47_1310 VPWR VGND VPWR VGND sky130_ef_sc_hd__decap_12
XTAP_TAPCELL_ROW_187_2075 VGND VPWR sky130_fd_sc_hd__tapvpwrvgnd_1
XTAP_TAPCELL_ROW_187_2064 VGND VPWR sky130_fd_sc_hd__tapvpwrvgnd_1
XFILLER_138_1482 VPWR VGND VPWR VGND sky130_ef_sc_hd__decap_12
XFILLER_134_1302 VPWR VGND VPWR VGND sky130_ef_sc_hd__decap_12
XFILLER_86_29 VPWR VGND VPWR VGND sky130_ef_sc_hd__decap_12
XFILLER_47_1354 VPWR VGND VPWR VGND sky130_ef_sc_hd__decap_12
XTAP_TAPCELL_ROW_120_1_1258 VGND VPWR sky130_fd_sc_hd__tapvpwrvgnd_1
XFILLER_0_949 VGND VGND VPWR VPWR sky130_fd_sc_hd__decap_3
XFILLER_47_1398 VPWR VGND VPWR VGND sky130_ef_sc_hd__decap_12
XTAP_TAPCELL_ROW_208_2657 VGND VPWR sky130_fd_sc_hd__tapvpwrvgnd_1
XFILLER_216_701 VPWR VGND VPWR VGND sky130_ef_sc_hd__decap_12
XTAP_TAPCELL_ROW_208_2679 VGND VPWR sky130_fd_sc_hd__tapvpwrvgnd_1
XTAP_TAPCELL_ROW_208_2668 VGND VPWR sky130_fd_sc_hd__tapvpwrvgnd_1
XTAP_TAPCELL_ROW_98_2_3618 VGND VPWR sky130_fd_sc_hd__tapvpwrvgnd_1
XFILLER_167_1133 VPWR VGND VPWR VGND sky130_ef_sc_hd__decap_12
XTAP_TAPCELL_ROW_111_2_3700 VGND VPWR sky130_fd_sc_hd__tapvpwrvgnd_1
XFILLER_3_1481 VPWR VGND VPWR VGND sky130_ef_sc_hd__decap_12
XFILLER_203_417 VPWR VGND VPWR VGND sky130_ef_sc_hd__decap_12
XFILLER_167_1177 VPWR VGND VPWR VGND sky130_ef_sc_hd__decap_12
XFILLER_163_1019 VPWR VGND VPWR VGND sky130_ef_sc_hd__decap_12
XFILLER_93_1330 VPWR VGND VPWR VGND sky130_ef_sc_hd__decap_12
XFILLER_35_55 VGND VGND VPWR VPWR sky130_fd_sc_hd__fill_1
XFILLER_58_1450 VPWR VGND VPWR VGND sky130_ef_sc_hd__decap_12
XFILLER_208_1141 VGND VGND VPWR VPWR sky130_fd_sc_hd__decap_6
XFILLER_169_833 VGND VGND VPWR VPWR sky130_fd_sc_hd__decap_6
XFILLER_168_321 VPWR VGND VPWR VGND sky130_ef_sc_hd__decap_12
XFILLER_145_1442 VPWR VGND VPWR VGND sky130_ef_sc_hd__decap_12
XFILLER_19_1434 VGND VGND VPWR VPWR sky130_fd_sc_hd__decap_6
XFILLER_54_1314 VPWR VGND VPWR VGND sky130_ef_sc_hd__decap_12
XFILLER_58_1494 VPWR VGND VPWR VGND sky130_ef_sc_hd__decap_12
XFILLER_212_973 VGND VGND VPWR VPWR sky130_fd_sc_hd__decap_6
XFILLER_211_461 VPWR VGND VPWR VGND sky130_ef_sc_hd__decap_12
XFILLER_208_1185 VPWR VGND VPWR VGND sky130_ef_sc_hd__decap_12
XFILLER_204_1005 VPWR VGND VPWR VGND sky130_ef_sc_hd__decap_12
XFILLER_169_877 VPWR VGND VPWR VGND sky130_ef_sc_hd__decap_12
XFILLER_143_3 VPWR VGND VPWR VGND sky130_ef_sc_hd__decap_12
XFILLER_106_1426 VPWR VGND VPWR VGND sky130_ef_sc_hd__decap_12
XFILLER_19_1478 VPWR VGND VPWR VGND sky130_ef_sc_hd__decap_12
XFILLER_54_1358 VPWR VGND VPWR VGND sky130_ef_sc_hd__decap_12
XFILLER_204_1049 VPWR VGND VPWR VGND sky130_ef_sc_hd__decap_12
XFILLER_184_825 VPWR VGND VPWR VGND sky130_ef_sc_hd__decap_12
XFILLER_168_365 VPWR VGND VPWR VGND sky130_ef_sc_hd__decap_12
XFILLER_141_1328 VGND VGND VPWR VPWR sky130_fd_sc_hd__fill_1
XTAP_TAPCELL_ROW_47_2_3285 VGND VPWR sky130_fd_sc_hd__tapvpwrvgnd_1
XFILLER_184_869 VPWR VGND VPWR VGND sky130_ef_sc_hd__decap_12
XFILLER_183_335 VGND VGND VPWR VPWR sky130_fd_sc_hd__fill_1
XTAP_TAPCELL_ROW_172_1654 VGND VPWR sky130_fd_sc_hd__tapvpwrvgnd_1
XTAP_TAPCELL_ROW_172_1643 VGND VPWR sky130_fd_sc_hd__tapvpwrvgnd_1
XTAP_TAPCELL_ROW_172_1632 VGND VPWR sky130_fd_sc_hd__tapvpwrvgnd_1
XFILLER_178_1273 VPWR VGND VPWR VGND sky130_ef_sc_hd__decap_12
XFILLER_139_1268 VGND VGND VPWR VPWR sky130_fd_sc_hd__decap_4
XFILLER_69_1590 VPWR VGND VPWR VGND sky130_ef_sc_hd__decap_12
XFILLER_65_1410 VPWR VGND VPWR VGND sky130_ef_sc_hd__decap_12
XTAP_TAPCELL_ROW_40_2_3239 VGND VPWR sky130_fd_sc_hd__tapvpwrvgnd_1
XFILLER_215_1101 VPWR VGND VPWR VGND sky130_ef_sc_hd__decap_12
XFILLER_117_1522 VPWR VGND VPWR VGND sky130_ef_sc_hd__decap_12
XFILLER_65_1454 VPWR VGND VPWR VGND sky130_ef_sc_hd__decap_12
XFILLER_2_253 VGND VGND VPWR VPWR sky130_fd_sc_hd__fill_1
XFILLER_215_1145 VPWR VGND VPWR VGND sky130_ef_sc_hd__decap_12
XFILLER_156_1582 VPWR VGND VPWR VGND sky130_ef_sc_hd__decap_12
XFILLER_117_1566 VPWR VGND VPWR VGND sky130_ef_sc_hd__decap_12
XFILLER_65_1498 VPWR VGND VPWR VGND sky130_ef_sc_hd__decap_12
XFILLER_26_1438 VPWR VGND VPWR VGND sky130_ef_sc_hd__decap_12
XFILLER_215_1189 VPWR VGND VPWR VGND sky130_ef_sc_hd__decap_12
XFILLER_211_1009 VPWR VGND VPWR VGND sky130_ef_sc_hd__decap_12
XFILLER_152_1468 VGND VGND VPWR VPWR sky130_fd_sc_hd__fill_1
XFILLER_8_1370 VPWR VGND VPWR VGND sky130_ef_sc_hd__decap_12
XFILLER_219_561 VPWR VGND VPWR VGND sky130_ef_sc_hd__decap_12
XTAP_TAPCELL_ROW_166_1469 VGND VPWR sky130_fd_sc_hd__tapvpwrvgnd_1
XTAP_TAPCELL_ROW_166_1458 VGND VPWR sky130_fd_sc_hd__tapvpwrvgnd_1
XFILLER_206_233 VPWR VGND VPWR VGND sky130_ef_sc_hd__decap_12
XFILLER_202_27 VGND VGND VPWR VPWR sky130_fd_sc_hd__fill_1
XFILLER_185_1233 VPWR VGND VPWR VGND sky130_ef_sc_hd__decap_12
XFILLER_206_277 VPWR VGND VPWR VGND sky130_ef_sc_hd__decap_12
XFILLER_76_1550 VPWR VGND VPWR VGND sky130_ef_sc_hd__decap_12
XFILLER_33_113 VGND VGND VPWR VPWR sky130_fd_sc_hd__fill_1
XFILLER_203_951 VGND VGND VPWR VPWR sky130_fd_sc_hd__fill_1
XFILLER_181_1119 VGND VGND VPWR VPWR sky130_fd_sc_hd__fill_1
XFILLER_92_83 VGND VGND VPWR VPWR sky130_fd_sc_hd__fill_1
XFILLER_76_1594 VGND VGND VPWR VPWR sky130_fd_sc_hd__decap_8
XFILLER_72_1414 VPWR VGND VPWR VGND sky130_ef_sc_hd__decap_12
XFILLER_37_1534 VPWR VGND VPWR VGND sky130_ef_sc_hd__decap_12
XFILLER_187_641 VPWR VGND VPWR VGND sky130_ef_sc_hd__decap_12
XFILLER_163_1553 VPWR VGND VPWR VGND sky130_ef_sc_hd__decap_12
XFILLER_124_1526 VPWR VGND VPWR VGND sky130_ef_sc_hd__decap_12
X_409_ _141_ _143_ VGND VGND VPWR VPWR _145_ sky130_fd_sc_hd__and2b_1
XFILLER_37_1578 VPWR VGND VPWR VGND sky130_ef_sc_hd__decap_12
XFILLER_187_685 VPWR VGND VPWR VGND sky130_ef_sc_hd__decap_12
XFILLER_163_1597 VGND VGND VPWR VPWR sky130_fd_sc_hd__decap_8
XFILLER_186_195 VGND VGND VPWR VPWR sky130_fd_sc_hd__fill_1
XFILLER_174_357 VGND VGND VPWR VPWR sky130_fd_sc_hd__decap_6
XFILLER_196_1373 VPWR VGND VPWR VGND sky130_ef_sc_hd__decap_12
XFILLER_122_1294 VGND VGND VPWR VPWR sky130_fd_sc_hd__decap_6
XPHY_EDGE_ROW_144_2_Right_201 VGND VGND VPWR VPWR sky130_fd_sc_hd__decap_3
XFILLER_83_1510 VPWR VGND VPWR VGND sky130_ef_sc_hd__decap_12
XFILLER_192_1259 VGND VGND VPWR VPWR sky130_fd_sc_hd__fill_1
XFILLER_83_1554 VPWR VGND VPWR VGND sky130_ef_sc_hd__decap_12
XFILLER_44_1538 VPWR VGND VPWR VGND sky130_ef_sc_hd__decap_12
XFILLER_5_1009 VPWR VGND VPWR VGND sky130_ef_sc_hd__decap_12
XTAP_TAPCELL_ROW_84_2_3526 VGND VPWR sky130_fd_sc_hd__tapvpwrvgnd_1
XTAP_TAPCELL_ROW_203_2532 VGND VPWR sky130_fd_sc_hd__tapvpwrvgnd_1
XTAP_TAPCELL_ROW_203_2521 VGND VPWR sky130_fd_sc_hd__tapvpwrvgnd_1
XFILLER_168_1453 VPWR VGND VPWR VGND sky130_ef_sc_hd__decap_12
XFILLER_112_27 VGND VGND VPWR VPWR sky130_fd_sc_hd__fill_1
XFILLER_198_917 VGND VGND VPWR VPWR sky130_fd_sc_hd__decap_6
XFILLER_197_405 VPWR VGND VPWR VGND sky130_ef_sc_hd__decap_12
XTAP_TAPCELL_ROW_195_2300 VGND VPWR sky130_fd_sc_hd__tapvpwrvgnd_1
XFILLER_164_1317 VPWR VGND VPWR VGND sky130_ef_sc_hd__decap_12
XTAP_TAPCELL_ROW_0_779 VGND VPWR sky130_fd_sc_hd__tapvpwrvgnd_1
XTAP_TAPCELL_ROW_0_757 VGND VPWR sky130_fd_sc_hd__tapvpwrvgnd_1
XTAP_TAPCELL_ROW_0_768 VGND VPWR sky130_fd_sc_hd__tapvpwrvgnd_1
XFILLER_20_1582 VPWR VGND VPWR VGND sky130_ef_sc_hd__decap_12
XTAP_TAPCELL_ROW_195_2311 VGND VPWR sky130_fd_sc_hd__tapvpwrvgnd_1
XFILLER_168_1497 VPWR VGND VPWR VGND sky130_ef_sc_hd__decap_12
XFILLER_205_1325 VPWR VGND VPWR VGND sky130_ef_sc_hd__decap_12
XFILLER_197_449 VPWR VGND VPWR VGND sky130_ef_sc_hd__decap_12
XTAP_TAPCELL_ROW_33_2_3193 VGND VPWR sky130_fd_sc_hd__tapvpwrvgnd_1
XTAP_TAPCELL_ROW_216_2904 VGND VPWR sky130_fd_sc_hd__tapvpwrvgnd_1
XFILLER_205_1369 VPWR VGND VPWR VGND sky130_ef_sc_hd__decap_12
XFILLER_166_825 VPWR VGND VPWR VGND sky130_ef_sc_hd__decap_12
XANTENNA_fanout136_X net136 VGND VGND VPWR VPWR sky130_fd_sc_hd__diode_2
XTAP_TAPCELL_ROW_9_2_3034 VGND VPWR sky130_fd_sc_hd__tapvpwrvgnd_1
XFILLER_192_121 VPWR VGND VPWR VGND sky130_ef_sc_hd__decap_12
XFILLER_166_869 VPWR VGND VPWR VGND sky130_ef_sc_hd__decap_12
XFILLER_165_335 VGND VGND VPWR VPWR sky130_fd_sc_hd__fill_1
XFILLER_192_165 VPWR VGND VPWR VGND sky130_ef_sc_hd__decap_12
XFILLER_140_1350 VGND VGND VPWR VPWR sky130_fd_sc_hd__decap_6
XTAP_TAPCELL_ROW_63_1_1143 VGND VPWR sky130_fd_sc_hd__tapvpwrvgnd_1
XFILLER_4_507 VGND VGND VPWR VPWR sky130_fd_sc_hd__decap_3
XTAP_TAPCELL_ROW_189_2126 VGND VPWR sky130_fd_sc_hd__tapvpwrvgnd_1
XTAP_TAPCELL_ROW_189_2115 VGND VPWR sky130_fd_sc_hd__tapvpwrvgnd_1
XFILLER_181_839 VGND VGND VPWR VPWR sky130_fd_sc_hd__fill_1
XFILLER_175_1413 VPWR VGND VPWR VGND sky130_ef_sc_hd__decap_12
XFILLER_140_1394 VPWR VGND VPWR VGND sky130_ef_sc_hd__decap_12
XFILLER_21_57 VGND VGND VPWR VPWR sky130_fd_sc_hd__decap_8
XTAP_TAPCELL_ROW_189_2137 VGND VPWR sky130_fd_sc_hd__tapvpwrvgnd_1
XFILLER_179_1593 VPWR VGND VPWR VGND sky130_ef_sc_hd__decap_12
XFILLER_175_1457 VPWR VGND VPWR VGND sky130_ef_sc_hd__decap_12
XFILLER_137_57 VPWR VGND VPWR VGND sky130_ef_sc_hd__decap_12
XFILLER_101_1378 VGND VGND VPWR VPWR sky130_fd_sc_hd__decap_6
XFILLER_216_1421 VGND VGND VPWR VPWR sky130_fd_sc_hd__decap_6
XPHY_EDGE_ROW_208_Right_53 VGND VGND VPWR VPWR sky130_fd_sc_hd__decap_3
XPHY_EDGE_ROW_109_1_Right_695 VGND VGND VPWR VPWR sky130_fd_sc_hd__decap_3
XFILLER_97_39 VPWR VGND VPWR VGND sky130_ef_sc_hd__decap_12
XFILLER_216_1465 VPWR VGND VPWR VGND sky130_ef_sc_hd__decap_12
XTAP_TAPCELL_ROW_151_1_1319 VGND VPWR sky130_fd_sc_hd__tapvpwrvgnd_1
XFILLER_0_724 VGND VGND VPWR VPWR sky130_fd_sc_hd__decap_4
XFILLER_212_1329 VPWR VGND VPWR VGND sky130_ef_sc_hd__decap_12
XFILLER_151_1490 VGND VGND VPWR VPWR sky130_fd_sc_hd__decap_6
XFILLER_216_531 VGND VGND VPWR VPWR sky130_fd_sc_hd__fill_1
XPHY_EDGE_ROW_39_2_Left_471 VGND VGND VPWR VPWR sky130_fd_sc_hd__decap_3
XFILLER_46_65 VPWR VGND VPWR VGND sky130_ef_sc_hd__decap_12
XPHY_EDGE_ROW_217_Right_62 VGND VGND VPWR VPWR sky130_fd_sc_hd__decap_3
XFILLER_204_737 VPWR VGND VPWR VGND sky130_ef_sc_hd__decap_12
XFILLER_186_1553 VPWR VGND VPWR VGND sky130_ef_sc_hd__decap_12
XFILLER_15_113 VPWR VGND VPWR VGND sky130_ef_sc_hd__decap_12
XFILLER_203_225 VPWR VGND VPWR VGND sky130_ef_sc_hd__decap_12
XFILLER_186_1597 VGND VGND VPWR VPWR sky130_fd_sc_hd__decap_8
XFILLER_19_1220 VPWR VGND VPWR VGND sky130_ef_sc_hd__decap_12
XFILLER_180_1141 VGND VGND VPWR VPWR sky130_fd_sc_hd__decap_6
XFILLER_169_641 VPWR VGND VPWR VGND sky130_ef_sc_hd__decap_12
XFILLER_30_116 VGND VGND VPWR VPWR sky130_fd_sc_hd__decap_8
XFILLER_62_53 VPWR VGND VPWR VGND sky130_ef_sc_hd__decap_12
XFILLER_212_781 VPWR VGND VPWR VGND sky130_ef_sc_hd__decap_12
XFILLER_178_53 VPWR VGND VPWR VGND sky130_ef_sc_hd__decap_12
XTAP_TAPCELL_ROW_174_1705 VGND VPWR sky130_fd_sc_hd__tapvpwrvgnd_1
XFILLER_169_685 VPWR VGND VPWR VGND sky130_ef_sc_hd__decap_12
XFILLER_145_1272 VGND VGND VPWR VPWR sky130_fd_sc_hd__fill_1
XFILLER_19_1286 VPWR VGND VPWR VGND sky130_ef_sc_hd__decap_12
XFILLER_62_97 VPWR VGND VPWR VGND sky130_ef_sc_hd__decap_12
XFILLER_180_1185 VPWR VGND VPWR VGND sky130_ef_sc_hd__decap_12
XFILLER_178_97 VPWR VGND VPWR VGND sky130_ef_sc_hd__decap_12
XFILLER_168_195 VGND VGND VPWR VPWR sky130_fd_sc_hd__fill_1
XFILLER_7_15 VPWR VGND VPWR VGND sky130_ef_sc_hd__decap_12
XFILLER_171_305 VPWR VGND VPWR VGND sky130_ef_sc_hd__decap_12
XTAP_TAPCELL_ROW_122_2_3769 VGND VPWR sky130_fd_sc_hd__tapvpwrvgnd_1
XTAP_TAPCELL_ROW_77_2_3480 VGND VPWR sky130_fd_sc_hd__tapvpwrvgnd_1
XFILLER_194_41 VPWR VGND VPWR VGND sky130_ef_sc_hd__decap_12
XFILLER_193_1513 VPWR VGND VPWR VGND sky130_ef_sc_hd__decap_12
XFILLER_184_699 VGND VGND VPWR VPWR sky130_fd_sc_hd__fill_1
XFILLER_194_85 VPWR VGND VPWR VGND sky130_ef_sc_hd__decap_12
XFILLER_180_861 VGND VGND VPWR VPWR sky130_fd_sc_hd__decap_6
XFILLER_171_349 VPWR VGND VPWR VGND sky130_ef_sc_hd__decap_12
XANTENNA__503__A3 net129 VGND VGND VPWR VPWR sky130_fd_sc_hd__diode_2
XFILLER_97_105 VGND VGND VPWR VPWR sky130_fd_sc_hd__decap_6
XFILLER_117_1330 VPWR VGND VPWR VGND sky130_ef_sc_hd__decap_12
XFILLER_191_1281 VGND VGND VPWR VPWR sky130_fd_sc_hd__decap_6
XFILLER_152_1232 VPWR VGND VPWR VGND sky130_ef_sc_hd__decap_12
XTAP_TAPCELL_ROW_70_2_3434 VGND VPWR sky130_fd_sc_hd__tapvpwrvgnd_1
XTAP_TAPCELL_ROW_69_2_3428 VGND VPWR sky130_fd_sc_hd__tapvpwrvgnd_1
XFILLER_6_1329 VPWR VGND VPWR VGND sky130_ef_sc_hd__decap_12
XFILLER_26_1246 VPWR VGND VPWR VGND sky130_ef_sc_hd__decap_12
XFILLER_213_15 VPWR VGND VPWR VGND sky130_ef_sc_hd__decap_12
XFILLER_207_553 VGND VGND VPWR VPWR sky130_fd_sc_hd__decap_6
XFILLER_130_1574 VGND VGND VPWR VPWR sky130_fd_sc_hd__decap_6
XFILLER_179_405 VPWR VGND VPWR VGND sky130_ef_sc_hd__decap_12
XFILLER_207_597 VPWR VGND VPWR VGND sky130_ef_sc_hd__decap_12
XFILLER_185_1063 VGND VGND VPWR VPWR sky130_fd_sc_hd__fill_1
XTAP_TAPCELL_ROW_18_2_3095 VGND VPWR sky130_fd_sc_hd__tapvpwrvgnd_1
XFILLER_195_909 VPWR VGND VPWR VGND sky130_ef_sc_hd__decap_12
XFILLER_188_961 VPWR VGND VPWR VGND sky130_ef_sc_hd__decap_12
XFILLER_179_449 VPWR VGND VPWR VGND sky130_ef_sc_hd__decap_12
XFILLER_128_1470 VPWR VGND VPWR VGND sky130_ef_sc_hd__decap_12
XFILLER_37_1342 VPWR VGND VPWR VGND sky130_ef_sc_hd__decap_12
XFILLER_194_419 VGND VGND VPWR VPWR sky130_fd_sc_hd__fill_1
XFILLER_72_1244 VGND VGND VPWR VPWR sky130_fd_sc_hd__fill_1
XFILLER_37_1386 VPWR VGND VPWR VGND sky130_ef_sc_hd__decap_12
XFILLER_202_1509 VPWR VGND VPWR VGND sky130_ef_sc_hd__decap_12
XFILLER_174_121 VPWR VGND VPWR VGND sky130_ef_sc_hd__decap_12
XFILLER_124_1356 VGND VGND VPWR VPWR sky130_fd_sc_hd__fill_1
Xinput40 func_wdata[6] VGND VGND VPWR VPWR net40 sky130_fd_sc_hd__clkbuf_1
XFILLER_190_625 VPWR VGND VPWR VGND sky130_ef_sc_hd__decap_12
XFILLER_174_165 VPWR VGND VPWR VGND sky130_ef_sc_hd__decap_12
XTAP_TAPCELL_ROW_11_2_3049 VGND VPWR sky130_fd_sc_hd__tapvpwrvgnd_1
XFILLER_190_669 VPWR VGND VPWR VGND sky130_ef_sc_hd__decap_12
XFILLER_107_27 VPWR VGND VPWR VGND sky130_ef_sc_hd__decap_12
XPHY_EDGE_ROW_145_2_Right_202 VGND VGND VPWR VPWR sky130_fd_sc_hd__decap_3
XFILLER_44_1302 VPWR VGND VPWR VGND sky130_ef_sc_hd__decap_12
XFILLER_48_1482 VPWR VGND VPWR VGND sky130_ef_sc_hd__decap_12
XFILLER_83_1384 VGND VGND VPWR VPWR sky130_fd_sc_hd__fill_1
XFILLER_170_1365 VGND VGND VPWR VPWR sky130_fd_sc_hd__decap_6
XTAP_TAPCELL_ROW_161_2_4027 VGND VPWR sky130_fd_sc_hd__tapvpwrvgnd_1
XFILLER_135_1496 VGND VGND VPWR VPWR sky130_fd_sc_hd__fill_1
XFILLER_123_15 VPWR VGND VPWR VGND sky130_ef_sc_hd__decap_12
XFILLER_217_317 VPWR VGND VPWR VGND sky130_ef_sc_hd__decap_12
XPHY_EDGE_ROW_24_1_Left_243 VGND VGND VPWR VPWR sky130_fd_sc_hd__decap_3
XFILLER_203_81 VPWR VGND VPWR VGND sky130_ef_sc_hd__decap_12
XFILLER_168_1261 VPWR VGND VPWR VGND sky130_ef_sc_hd__decap_12
XFILLER_198_725 VPWR VGND VPWR VGND sky130_ef_sc_hd__decap_12
XFILLER_129_1256 VPWR VGND VPWR VGND sky130_ef_sc_hd__decap_12
XFILLER_16_46 VGND VGND VPWR VPWR sky130_fd_sc_hd__decap_4
XFILLER_198_769 VPWR VGND VPWR VGND sky130_ef_sc_hd__decap_12
XFILLER_164_1147 VGND VGND VPWR VPWR sky130_fd_sc_hd__fill_1
XFILLER_107_1510 VPWR VGND VPWR VGND sky130_ef_sc_hd__decap_12
XFILLER_90_1300 VGND VGND VPWR VPWR sky130_fd_sc_hd__fill_1
XFILLER_12_105 VPWR VGND VPWR VGND sky130_ef_sc_hd__decap_12
XFILLER_55_1442 VPWR VGND VPWR VGND sky130_ef_sc_hd__decap_12
XFILLER_205_1133 VPWR VGND VPWR VGND sky130_ef_sc_hd__decap_12
XFILLER_201_729 VPWR VGND VPWR VGND sky130_ef_sc_hd__decap_12
XFILLER_197_279 VGND VGND VPWR VPWR sky130_fd_sc_hd__fill_1
XFILLER_142_1412 VGND VGND VPWR VPWR sky130_fd_sc_hd__fill_1
XFILLER_16_1426 VPWR VGND VPWR VGND sky130_ef_sc_hd__decap_12
XFILLER_205_1177 VPWR VGND VPWR VGND sky130_ef_sc_hd__decap_12
XFILLER_107_1554 VPWR VGND VPWR VGND sky130_ef_sc_hd__decap_12
XFILLER_51_1328 VGND VGND VPWR VPWR sky130_fd_sc_hd__fill_1
XFILLER_193_441 VGND VGND VPWR VPWR sky130_fd_sc_hd__decap_6
XFILLER_193_485 VPWR VGND VPWR VGND sky130_ef_sc_hd__decap_12
XFILLER_166_699 VGND VGND VPWR VPWR sky130_fd_sc_hd__fill_1
XFILLER_5_827 VPWR VGND VPWR VGND sky130_ef_sc_hd__decap_12
XFILLER_106_3 VPWR VGND VPWR VGND sky130_ef_sc_hd__decap_12
XFILLER_79_105 VGND VGND VPWR VPWR sky130_fd_sc_hd__decap_6
XFILLER_49_1268 VGND VGND VPWR VPWR sky130_fd_sc_hd__decap_4
XFILLER_175_1287 VGND VGND VPWR VPWR sky130_fd_sc_hd__fill_1
XFILLER_164_77 VGND VGND VPWR VPWR sky130_fd_sc_hd__decap_6
XFILLER_27_1522 VPWR VGND VPWR VGND sky130_ef_sc_hd__decap_12
XTAP_TAPCELL_ROW_55_2_3336 VGND VPWR sky130_fd_sc_hd__tapvpwrvgnd_1
XFILLER_216_1273 VPWR VGND VPWR VGND sky130_ef_sc_hd__decap_12
XFILLER_153_1552 VGND VGND VPWR VPWR sky130_fd_sc_hd__fill_1
XFILLER_66_1582 VPWR VGND VPWR VGND sky130_ef_sc_hd__decap_12
XFILLER_27_1566 VPWR VGND VPWR VGND sky130_ef_sc_hd__decap_12
XFILLER_57_20 VPWR VGND VPWR VGND sky130_ef_sc_hd__decap_12
XFILLER_62_1468 VGND VGND VPWR VPWR sky130_fd_sc_hd__fill_1
XANTENNA_input26_A func_wdata[22] VGND VGND VPWR VPWR sky130_fd_sc_hd__diode_2
XFILLER_180_65 VPWR VGND VPWR VGND sky130_ef_sc_hd__decap_12
XTAP_TAPCELL_ROW_4_893 VGND VPWR sky130_fd_sc_hd__tapvpwrvgnd_1
XFILLER_217_895 VGND VGND VPWR VPWR sky130_fd_sc_hd__fill_1
XFILLER_204_501 VPWR VGND VPWR VGND sky130_ef_sc_hd__decap_12
XFILLER_113_81 VPWR VGND VPWR VGND sky130_ef_sc_hd__decap_12
XFILLER_112_1282 VPWR VGND VPWR VGND sky130_ef_sc_hd__decap_12
XFILLER_95_1244 VPWR VGND VPWR VGND sky130_ef_sc_hd__decap_12
XFILLER_204_545 VPWR VGND VPWR VGND sky130_ef_sc_hd__decap_12
XFILLER_182_1203 VGND VGND VPWR VPWR sky130_fd_sc_hd__fill_1
XFILLER_177_909 VPWR VGND VPWR VGND sky130_ef_sc_hd__decap_12
XFILLER_147_1378 VGND VGND VPWR VPWR sky130_fd_sc_hd__decap_6
XFILLER_204_589 VPWR VGND VPWR VGND sky130_ef_sc_hd__decap_12
XFILLER_176_419 VGND VGND VPWR VPWR sky130_fd_sc_hd__fill_1
XFILLER_34_1526 VPWR VGND VPWR VGND sky130_ef_sc_hd__decap_12
XFILLER_185_953 VPWR VGND VPWR VGND sky130_ef_sc_hd__decap_12
XFILLER_156_121 VGND VGND VPWR VPWR sky130_fd_sc_hd__decap_6
XFILLER_208_15 VPWR VGND VPWR VGND sky130_ef_sc_hd__decap_12
XFILLER_172_625 VPWR VGND VPWR VGND sky130_ef_sc_hd__decap_12
XFILLER_171_113 VPWR VGND VPWR VGND sky130_ef_sc_hd__decap_12
XANTENNA__577__CLK clknet_3_2_0_clk VGND VGND VPWR VPWR sky130_fd_sc_hd__diode_2
XFILLER_176_1029 VGND VGND VPWR VPWR sky130_fd_sc_hd__decap_6
XFILLER_172_669 VPWR VGND VPWR VGND sky130_ef_sc_hd__decap_12
XFILLER_32_1294 VGND VGND VPWR VPWR sky130_fd_sc_hd__decap_6
XFILLER_193_1343 VGND VGND VPWR VPWR sky130_fd_sc_hd__fill_1
XTAP_TAPCELL_ROW_152_2_3964 VGND VPWR sky130_fd_sc_hd__tapvpwrvgnd_1
XFILLER_154_1338 VPWR VGND VPWR VGND sky130_ef_sc_hd__decap_12
XFILLER_80_1524 VGND VGND VPWR VPWR sky130_fd_sc_hd__fill_1
XFILLER_21_3 VPWR VGND VPWR VGND sky130_ef_sc_hd__decap_12
XTAP_TAPCELL_ROW_25_1_1068 VGND VPWR sky130_fd_sc_hd__tapvpwrvgnd_1
XTAP_TAPCELL_ROW_99_2_3623 VGND VPWR sky130_fd_sc_hd__tapvpwrvgnd_1
XFILLER_214_309 VPWR VGND VPWR VGND sky130_ef_sc_hd__decap_12
XFILLER_207_361 VPWR VGND VPWR VGND sky130_ef_sc_hd__decap_12
XFILLER_187_1169 VGND VGND VPWR VPWR sky130_fd_sc_hd__decap_6
XFILLER_165_1401 VPWR VGND VPWR VGND sky130_ef_sc_hd__decap_12
XFILLER_130_1382 VPWR VGND VPWR VGND sky130_ef_sc_hd__decap_12
XTAP_TAPCELL_ROW_87_1_1191 VGND VPWR sky130_fd_sc_hd__tapvpwrvgnd_1
XFILLER_169_1581 VPWR VGND VPWR VGND sky130_ef_sc_hd__decap_12
XFILLER_179_279 VGND VGND VPWR VPWR sky130_fd_sc_hd__fill_1
XTAP_TAPCELL_ROW_48_2_3290 VGND VPWR sky130_fd_sc_hd__tapvpwrvgnd_1
XFILLER_206_1453 VPWR VGND VPWR VGND sky130_ef_sc_hd__decap_12
XFILLER_202_1317 VPWR VGND VPWR VGND sky130_ef_sc_hd__decap_12
XFILLER_206_1497 VPWR VGND VPWR VGND sky130_ef_sc_hd__decap_12
XFILLER_175_441 VGND VGND VPWR VPWR sky130_fd_sc_hd__decap_6
XFILLER_191_945 VGND VGND VPWR VPWR sky130_fd_sc_hd__decap_6
XFILLER_175_485 VPWR VGND VPWR VGND sky130_ef_sc_hd__decap_12
XFILLER_118_15 VPWR VGND VPWR VGND sky130_ef_sc_hd__decap_12
XTAP_TAPCELL_ROW_80_1_1178 VGND VPWR sky130_fd_sc_hd__tapvpwrvgnd_1
XFILLER_8_80 VGND VGND VPWR VPWR sky130_fd_sc_hd__decap_4
XFILLER_50_1350 VGND VGND VPWR VPWR sky130_fd_sc_hd__decap_6
XFILLER_194_1129 VPWR VGND VPWR VGND sky130_ef_sc_hd__decap_12
XFILLER_190_433 VPWR VGND VPWR VGND sky130_ef_sc_hd__decap_12
XFILLER_163_669 VGND VGND VPWR VPWR sky130_fd_sc_hd__decap_3
XFILLER_102_1462 VGND VGND VPWR VPWR sky130_fd_sc_hd__decap_6
XFILLER_50_1394 VPWR VGND VPWR VGND sky130_ef_sc_hd__decap_12
XFILLER_200_1085 VGND VGND VPWR VPWR sky130_fd_sc_hd__decap_6
XFILLER_191_989 VPWR VGND VPWR VGND sky130_ef_sc_hd__decap_12
XFILLER_190_477 VPWR VGND VPWR VGND sky130_ef_sc_hd__decap_12
XFILLER_176_1541 VPWR VGND VPWR VGND sky130_ef_sc_hd__decap_12
XANTENNA__351__A net157 VGND VGND VPWR VPWR sky130_fd_sc_hd__diode_2
XFILLER_11_1378 VGND VGND VPWR VPWR sky130_fd_sc_hd__decap_6
XTAP_TAPCELL_ROW_41_2_3244 VGND VPWR sky130_fd_sc_hd__tapvpwrvgnd_1
XFILLER_172_1427 VGND VGND VPWR VPWR sky130_fd_sc_hd__fill_1
XPHY_EDGE_ROW_146_2_Right_203 VGND VGND VPWR VPWR sky130_fd_sc_hd__decap_3
XFILLER_217_1593 VPWR VGND VPWR VGND sky130_ef_sc_hd__decap_12
XFILLER_213_1413 VPWR VGND VPWR VGND sky130_ef_sc_hd__decap_12
XFILLER_218_637 VGND VGND VPWR VPWR sky130_fd_sc_hd__decap_6
XFILLER_213_1457 VPWR VGND VPWR VGND sky130_ef_sc_hd__decap_12
XFILLER_170_1173 VPWR VGND VPWR VGND sky130_ef_sc_hd__decap_12
XFILLER_94_29 VPWR VGND VPWR VGND sky130_ef_sc_hd__decap_12
XFILLER_217_125 VPWR VGND VPWR VGND sky130_ef_sc_hd__decap_12
XFILLER_61_1490 VGND VGND VPWR VPWR sky130_fd_sc_hd__decap_6
XFILLER_217_169 VPWR VGND VPWR VGND sky130_ef_sc_hd__decap_12
XTAP_TAPCELL_ROW_1_830 VGND VPWR sky130_fd_sc_hd__tapvpwrvgnd_1
XFILLER_92_1406 VGND VGND VPWR VPWR sky130_fd_sc_hd__decap_6
XFILLER_198_533 VPWR VGND VPWR VGND sky130_ef_sc_hd__decap_12
XFILLER_183_1567 VGND VGND VPWR VPWR sky130_fd_sc_hd__fill_1
XFILLER_168_1091 VGND VGND VPWR VPWR sky130_fd_sc_hd__fill_1
XFILLER_144_1518 VGND VGND VPWR VPWR sky130_fd_sc_hd__decap_6
X_390_ b_addr\[2\] _104_ VGND VGND VPWR VPWR _128_ sky130_fd_sc_hd__xnor2_1
XFILLER_185_205 VPWR VGND VPWR VGND sky130_ef_sc_hd__decap_12
XFILLER_43_55 VGND VGND VPWR VPWR sky130_fd_sc_hd__fill_1
XFILLER_201_559 VGND VGND VPWR VPWR sky130_fd_sc_hd__fill_1
XFILLER_199_1007 VGND VGND VPWR VPWR sky130_fd_sc_hd__fill_1
XFILLER_159_55 VGND VGND VPWR VPWR sky130_fd_sc_hd__fill_1
XFILLER_142_1220 VPWR VGND VPWR VGND sky130_ef_sc_hd__decap_12
XFILLER_55_1272 VGND VGND VPWR VPWR sky130_fd_sc_hd__fill_1
XFILLER_185_249 VPWR VGND VPWR VGND sky130_ef_sc_hd__decap_12
XFILLER_167_953 VPWR VGND VPWR VGND sky130_ef_sc_hd__decap_12
XFILLER_138_121 VGND VGND VPWR VPWR sky130_fd_sc_hd__decap_6
XFILLER_107_1384 VGND VGND VPWR VPWR sky130_fd_sc_hd__fill_1
XFILLER_182_923 VGND VGND VPWR VPWR sky130_fd_sc_hd__fill_1
XFILLER_193_293 VPWR VGND VPWR VGND sky130_ef_sc_hd__decap_12
XFILLER_153_113 VPWR VGND VPWR VGND sky130_ef_sc_hd__decap_12
XTAP_TAPCELL_ROW_137_2_3866 VGND VPWR sky130_fd_sc_hd__tapvpwrvgnd_1
XFILLER_120_1562 VPWR VGND VPWR VGND sky130_ef_sc_hd__decap_12
XFILLER_5_679 VGND VGND VPWR VPWR sky130_fd_sc_hd__decap_4
XFILLER_5_668 VGND VGND VPWR VPWR sky130_fd_sc_hd__decap_4
XFILLER_4_27 VGND VGND VPWR VPWR sky130_fd_sc_hd__fill_1
XFILLER_68_41 VPWR VGND VPWR VGND sky130_ef_sc_hd__decap_12
XFILLER_27_1330 VPWR VGND VPWR VGND sky130_ef_sc_hd__decap_12
XFILLER_114_1300 VGND VGND VPWR VPWR sky130_fd_sc_hd__fill_1
XFILLER_68_85 VPWR VGND VPWR VGND sky130_ef_sc_hd__decap_12
XFILLER_7_1413 VPWR VGND VPWR VGND sky130_ef_sc_hd__decap_12
XFILLER_62_1232 VPWR VGND VPWR VGND sky130_ef_sc_hd__decap_12
XFILLER_209_615 VGND VGND VPWR VPWR sky130_fd_sc_hd__fill_1
XTAP_TAPCELL_ROW_85_2_3531 VGND VPWR sky130_fd_sc_hd__tapvpwrvgnd_1
XFILLER_7_1457 VPWR VGND VPWR VGND sky130_ef_sc_hd__decap_12
XFILLER_97_1328 VGND VGND VPWR VPWR sky130_fd_sc_hd__fill_1
XFILLER_184_1309 VGND VGND VPWR VPWR sky130_fd_sc_hd__decap_6
XFILLER_1_1001 VGND VGND VPWR VPWR sky130_fd_sc_hd__decap_6
XFILLER_40_1574 VGND VGND VPWR VPWR sky130_fd_sc_hd__decap_6
XFILLER_205_821 VPWR VGND VPWR VGND sky130_ef_sc_hd__decap_12
XFILLER_1_1045 VPWR VGND VPWR VGND sky130_ef_sc_hd__decap_12
XFILLER_210_27 VGND VGND VPWR VPWR sky130_fd_sc_hd__fill_1
XFILLER_205_865 VPWR VGND VPWR VGND sky130_ef_sc_hd__decap_12
XFILLER_1_1089 VPWR VGND VPWR VGND sky130_ef_sc_hd__decap_12
X_588_ clknet_3_2_0_clk _022_ VGND VGND VPWR VPWR b_addr\[4\] sky130_fd_sc_hd__dfxtp_2
XFILLER_125_1440 VGND VGND VPWR VPWR sky130_fd_sc_hd__fill_1
XFILLER_38_1470 VPWR VGND VPWR VGND sky130_ef_sc_hd__decap_12
XFILLER_34_1356 VGND VGND VPWR VPWR sky130_fd_sc_hd__fill_1
XFILLER_200_581 VGND VGND VPWR VPWR sky130_fd_sc_hd__decap_6
XFILLER_185_783 VGND VGND VPWR VPWR sky130_fd_sc_hd__fill_1
XFILLER_219_69 VPWR VGND VPWR VGND sky130_ef_sc_hd__decap_12
XFILLER_195_1449 VGND VGND VPWR VPWR sky130_fd_sc_hd__decap_6
XFILLER_173_945 VGND VGND VPWR VPWR sky130_fd_sc_hd__decap_6
XFILLER_172_433 VPWR VGND VPWR VGND sky130_ef_sc_hd__decap_12
XFILLER_69_3 VPWR VGND VPWR VGND sky130_ef_sc_hd__decap_12
XFILLER_173_989 VPWR VGND VPWR VGND sky130_ef_sc_hd__decap_12
XFILLER_172_477 VPWR VGND VPWR VGND sky130_ef_sc_hd__decap_12
XTAP_TAPCELL_ROW_26_2_3146 VGND VPWR sky130_fd_sc_hd__tapvpwrvgnd_1
XFILLER_158_1282 VPWR VGND VPWR VGND sky130_ef_sc_hd__decap_12
XFILLER_119_1244 VPWR VGND VPWR VGND sky130_ef_sc_hd__decap_12
XFILLER_136_1580 VGND VGND VPWR VPWR sky130_fd_sc_hd__fill_1
XFILLER_171_1493 VPWR VGND VPWR VGND sky130_ef_sc_hd__decap_12
XFILLER_45_1496 VGND VGND VPWR VPWR sky130_fd_sc_hd__fill_1
XTAP_TAPCELL_ROW_56_1_1129 VGND VPWR sky130_fd_sc_hd__tapvpwrvgnd_1
XFILLER_215_629 VPWR VGND VPWR VGND sky130_ef_sc_hd__decap_12
XFILLER_81_111 VGND VGND VPWR VPWR sky130_fd_sc_hd__fill_1
XFILLER_214_139 VGND VGND VPWR VPWR sky130_fd_sc_hd__fill_1
XFILLER_208_681 VPWR VGND VPWR VGND sky130_ef_sc_hd__decap_12
XFILLER_165_1231 VGND VGND VPWR VPWR sky130_fd_sc_hd__fill_1
XFILLER_120_27 VGND VGND VPWR VPWR sky130_fd_sc_hd__fill_1
XFILLER_78_1294 VGND VGND VPWR VPWR sky130_fd_sc_hd__decap_6
XFILLER_210_301 VGND VGND VPWR VPWR sky130_fd_sc_hd__decap_6
XFILLER_195_503 VGND VGND VPWR VPWR sky130_fd_sc_hd__fill_1
XFILLER_167_205 VPWR VGND VPWR VGND sky130_ef_sc_hd__decap_12
XFILLER_17_1510 VPWR VGND VPWR VGND sky130_ef_sc_hd__decap_12
XFILLER_39_1256 VPWR VGND VPWR VGND sky130_ef_sc_hd__decap_12
XFILLER_210_345 VPWR VGND VPWR VGND sky130_ef_sc_hd__decap_12
XFILLER_52_1412 VGND VGND VPWR VPWR sky130_fd_sc_hd__fill_1
XFILLER_206_1261 VPWR VGND VPWR VGND sky130_ef_sc_hd__decap_12
XFILLER_183_709 VPWR VGND VPWR VGND sky130_ef_sc_hd__decap_12
XFILLER_167_249 VPWR VGND VPWR VGND sky130_ef_sc_hd__decap_12
XFILLER_104_1524 VGND VGND VPWR VPWR sky130_fd_sc_hd__fill_1
XFILLER_17_1554 VPWR VGND VPWR VGND sky130_ef_sc_hd__decap_12
XFILLER_210_389 VPWR VGND VPWR VGND sky130_ef_sc_hd__decap_12
XFILLER_202_1147 VGND VGND VPWR VPWR sky130_fd_sc_hd__fill_1
XTAP_TAPCELL_ROW_192_2199 VGND VPWR sky130_fd_sc_hd__tapvpwrvgnd_1
XFILLER_164_923 VGND VGND VPWR VPWR sky130_fd_sc_hd__fill_1
XFILLER_13_69 VPWR VGND VPWR VGND sky130_ef_sc_hd__decap_12
XFILLER_198_1073 VPWR VGND VPWR VGND sky130_ef_sc_hd__decap_12
XFILLER_191_753 VPWR VGND VPWR VGND sky130_ef_sc_hd__decap_12
XFILLER_175_293 VPWR VGND VPWR VGND sky130_ef_sc_hd__decap_12
XFILLER_163_433 VPWR VGND VPWR VGND sky130_ef_sc_hd__decap_12
XFILLER_135_113 VPWR VGND VPWR VGND sky130_ef_sc_hd__decap_12
XFILLER_129_69 VPWR VGND VPWR VGND sky130_ef_sc_hd__decap_12
XFILLER_163_477 VPWR VGND VPWR VGND sky130_ef_sc_hd__decap_12
XFILLER_102_1270 VPWR VGND VPWR VGND sky130_ef_sc_hd__decap_12
XFILLER_191_797 VPWR VGND VPWR VGND sky130_ef_sc_hd__decap_12
XFILLER_176_1371 VGND VGND VPWR VPWR sky130_fd_sc_hd__fill_1
XFILLER_137_1322 VGND VGND VPWR VPWR sky130_fd_sc_hd__decap_6
XTAP_TAPCELL_ROW_103_2_3650 VGND VPWR sky130_fd_sc_hd__tapvpwrvgnd_1
XFILLER_85_1232 VPWR VGND VPWR VGND sky130_ef_sc_hd__decap_12
XPHY_EDGE_ROW_48_2_Left_480 VGND VGND VPWR VPWR sky130_fd_sc_hd__decap_3
XFILLER_145_57 VPWR VGND VPWR VGND sky130_ef_sc_hd__decap_12
XFILLER_137_1366 VPWR VGND VPWR VGND sky130_ef_sc_hd__decap_12
XFILLER_85_1298 VPWR VGND VPWR VGND sky130_ef_sc_hd__decap_12
XFILLER_1_137 VGND VGND VPWR VPWR sky130_fd_sc_hd__decap_8
XTAP_TAPCELL_ROW_103_1_1224 VGND VPWR sky130_fd_sc_hd__tapvpwrvgnd_1
XFILLER_63_1552 VGND VGND VPWR VPWR sky130_fd_sc_hd__fill_1
XTAP_TAPCELL_ROW_6_955 VGND VPWR sky130_fd_sc_hd__tapvpwrvgnd_1
XFILLER_49_108 VGND VGND VPWR VPWR sky130_fd_sc_hd__decap_4
XFILLER_218_401 VPWR VGND VPWR VGND sky130_ef_sc_hd__decap_12
XPHY_EDGE_ROW_147_2_Right_204 VGND VGND VPWR VPWR sky130_fd_sc_hd__decap_3
XTAP_TAPCELL_ROW_6_966 VGND VPWR sky130_fd_sc_hd__tapvpwrvgnd_1
XTAP_TAPCELL_ROW_6_977 VGND VPWR sky130_fd_sc_hd__tapvpwrvgnd_1
XFILLER_218_445 VPWR VGND VPWR VGND sky130_ef_sc_hd__decap_12
XFILLER_213_1287 VGND VGND VPWR VPWR sky130_fd_sc_hd__fill_1
XFILLER_38_77 VGND VGND VPWR VPWR sky130_fd_sc_hd__decap_6
XFILLER_173_3 VPWR VGND VPWR VGND sky130_ef_sc_hd__decap_12
XFILLER_218_489 VPWR VGND VPWR VGND sky130_ef_sc_hd__decap_12
XTAP_TAPCELL_ROW_181_1892 VGND VPWR sky130_fd_sc_hd__tapvpwrvgnd_1
XFILLER_166_1017 VPWR VGND VPWR VGND sky130_ef_sc_hd__decap_12
XFILLER_96_1350 VGND VGND VPWR VPWR sky130_fd_sc_hd__decap_6
XFILLER_2_1365 VGND VGND VPWR VPWR sky130_fd_sc_hd__decap_6
X_511_ net149 _173_ net127 net139 _229_ VGND VGND VPWR VPWR _039_ sky130_fd_sc_hd__o311a_1
XFILLER_22_1282 VPWR VGND VPWR VGND sky130_ef_sc_hd__decap_12
XFILLER_199_853 VPWR VGND VPWR VGND sky130_ef_sc_hd__decap_12
XFILLER_148_1462 VGND VGND VPWR VPWR sky130_fd_sc_hd__decap_6
XFILLER_96_1394 VPWR VGND VPWR VGND sky130_ef_sc_hd__decap_12
X_442_ net145 net109 VGND VGND VPWR VPWR _174_ sky130_fd_sc_hd__xor2_2
XFILLER_54_65 VPWR VGND VPWR VGND sky130_ef_sc_hd__decap_12
XFILLER_213_161 VGND VGND VPWR VPWR sky130_fd_sc_hd__decap_6
XFILLER_202_813 VPWR VGND VPWR VGND sky130_ef_sc_hd__decap_12
XFILLER_198_363 VGND VGND VPWR VPWR sky130_fd_sc_hd__fill_1
XFILLER_144_1326 VPWR VGND VPWR VGND sky130_ef_sc_hd__decap_12
XFILLER_92_1258 VPWR VGND VPWR VGND sky130_ef_sc_hd__decap_12
XFILLER_54_98 VPWR VGND VPWR VGND sky130_ef_sc_hd__decap_12
XFILLER_57_1378 VGND VGND VPWR VPWR sky130_fd_sc_hd__decap_6
XFILLER_199_897 VPWR VGND VPWR VGND sky130_ef_sc_hd__decap_12
XFILLER_186_525 VGND VGND VPWR VPWR sky130_fd_sc_hd__decap_6
X_373_ _069_ _070_ _071_ VGND VGND VPWR VPWR _114_ sky130_fd_sc_hd__or3_1
XTAP_TAPCELL_ROW_32_2_3189 VGND VPWR sky130_fd_sc_hd__tapvpwrvgnd_1
XFILLER_186_569 VPWR VGND VPWR VGND sky130_ef_sc_hd__decap_12
XFILLER_122_1602 VGND VGND VPWR VPWR sky130_fd_sc_hd__decap_3
XFILLER_70_53 VPWR VGND VPWR VGND sky130_ef_sc_hd__decap_12
XFILLER_186_53 VPWR VGND VPWR VGND sky130_ef_sc_hd__decap_12
XFILLER_167_783 VGND VGND VPWR VPWR sky130_fd_sc_hd__fill_1
XFILLER_177_1113 VGND VGND VPWR VPWR sky130_fd_sc_hd__decap_6
XPHY_EDGE_ROW_167_Right_12 VGND VGND VPWR VPWR sky130_fd_sc_hd__decap_3
XFILLER_70_97 VPWR VGND VPWR VGND sky130_ef_sc_hd__decap_12
XTAP_TAPCELL_ROW_12_2_3054 VGND VPWR sky130_fd_sc_hd__tapvpwrvgnd_1
XFILLER_186_97 VPWR VGND VPWR VGND sky130_ef_sc_hd__decap_12
XFILLER_177_1157 VPWR VGND VPWR VGND sky130_ef_sc_hd__decap_12
XFILLER_120_1370 VPWR VGND VPWR VGND sky130_ef_sc_hd__decap_12
XFILLER_170_937 VPWR VGND VPWR VGND sky130_ef_sc_hd__decap_12
XFILLER_155_1422 VPWR VGND VPWR VGND sky130_ef_sc_hd__decap_12
XFILLER_141_105 VGND VGND VPWR VPWR sky130_fd_sc_hd__decap_6
XPHY_EDGE_ROW_101_1_Left_320 VGND VGND VPWR VPWR sky130_fd_sc_hd__decap_3
XFILLER_79_51 VGND VGND VPWR VPWR sky130_fd_sc_hd__decap_4
XFILLER_116_1406 VGND VGND VPWR VPWR sky130_fd_sc_hd__decap_6
XFILLER_64_1338 VPWR VGND VPWR VGND sky130_ef_sc_hd__decap_12
XFILLER_214_1029 VGND VGND VPWR VPWR sky130_fd_sc_hd__decap_6
XFILLER_205_27 VPWR VGND VPWR VGND sky130_ef_sc_hd__decap_12
XFILLER_155_1466 VPWR VGND VPWR VGND sky130_ef_sc_hd__decap_12
XANTENNA__615__CLK clknet_3_6_0_clk VGND VGND VPWR VPWR sky130_fd_sc_hd__diode_2
XTAP_TAPCELL_ROW_162_2_4032 VGND VPWR sky130_fd_sc_hd__tapvpwrvgnd_1
XPHY_EDGE_ROW_176_Right_21 VGND VGND VPWR VPWR sky130_fd_sc_hd__decap_3
XFILLER_188_1253 VGND VGND VPWR VPWR sky130_fd_sc_hd__decap_6
XFILLER_63_111 VGND VGND VPWR VPWR sky130_fd_sc_hd__fill_1
XFILLER_188_1297 VPWR VGND VPWR VGND sky130_ef_sc_hd__decap_12
XFILLER_184_1117 VPWR VGND VPWR VGND sky130_ef_sc_hd__decap_12
XFILLER_40_1382 VPWR VGND VPWR VGND sky130_ef_sc_hd__decap_12
XFILLER_75_1434 VGND VGND VPWR VPWR sky130_fd_sc_hd__decap_6
XFILLER_205_673 VPWR VGND VPWR VGND sky130_ef_sc_hd__decap_12
XFILLER_177_503 VGND VGND VPWR VPWR sky130_fd_sc_hd__fill_1
XFILLER_189_385 VGND VGND VPWR VPWR sky130_fd_sc_hd__decap_6
XFILLER_166_1595 VGND VGND VPWR VPWR sky130_fd_sc_hd__fill_1
XFILLER_162_1426 VPWR VGND VPWR VGND sky130_ef_sc_hd__decap_12
XFILLER_127_1546 VGND VGND VPWR VPWR sky130_fd_sc_hd__decap_6
XFILLER_75_1478 VPWR VGND VPWR VGND sky130_ef_sc_hd__decap_12
XFILLER_207_1581 VPWR VGND VPWR VGND sky130_ef_sc_hd__decap_12
XFILLER_203_1401 VPWR VGND VPWR VGND sky130_ef_sc_hd__decap_12
XPHY_EDGE_ROW_185_Right_30 VGND VGND VPWR VPWR sky130_fd_sc_hd__decap_3
XFILLER_165_709 VPWR VGND VPWR VGND sky130_ef_sc_hd__decap_12
XFILLER_195_1213 VPWR VGND VPWR VGND sky130_ef_sc_hd__decap_12
XFILLER_173_753 VPWR VGND VPWR VGND sky130_ef_sc_hd__decap_12
XFILLER_117_113 VPWR VGND VPWR VGND sky130_ef_sc_hd__decap_12
XFILLER_199_1393 VGND VGND VPWR VPWR sky130_fd_sc_hd__decap_6
XFILLER_195_1257 VPWR VGND VPWR VGND sky130_ef_sc_hd__decap_12
XFILLER_103_1590 VPWR VGND VPWR VGND sky130_ef_sc_hd__decap_12
XFILLER_12_1462 VGND VGND VPWR VPWR sky130_fd_sc_hd__decap_6
XPHY_EDGE_ROW_33_1_Left_252 VGND VGND VPWR VPWR sky130_fd_sc_hd__decap_3
XTAP_TAPCELL_ROW_212_2781 VGND VPWR sky130_fd_sc_hd__tapvpwrvgnd_1
XTAP_TAPCELL_ROW_212_2770 VGND VPWR sky130_fd_sc_hd__tapvpwrvgnd_1
XFILLER_173_1511 VGND VGND VPWR VPWR sky130_fd_sc_hd__fill_1
XFILLER_173_797 VPWR VGND VPWR VGND sky130_ef_sc_hd__decap_12
XTAP_TAPCELL_ROW_212_2792 VGND VPWR sky130_fd_sc_hd__tapvpwrvgnd_1
XFILLER_86_1574 VGND VGND VPWR VPWR sky130_fd_sc_hd__decap_6
XFILLER_82_1438 VPWR VGND VPWR VGND sky130_ef_sc_hd__decap_12
XTAP_TAPCELL_ROW_56_2_3341 VGND VPWR sky130_fd_sc_hd__tapvpwrvgnd_1
XFILLER_134_1506 VPWR VGND VPWR VGND sky130_ef_sc_hd__decap_12
XFILLER_115_27 VPWR VGND VPWR VGND sky130_ef_sc_hd__decap_12
XFILLER_219_209 VPWR VGND VPWR VGND sky130_ef_sc_hd__decap_12
XFILLER_214_1541 VPWR VGND VPWR VGND sky130_ef_sc_hd__decap_12
XFILLER_210_1427 VGND VGND VPWR VPWR sky130_fd_sc_hd__fill_1
XFILLER_216_905 VPWR VGND VPWR VGND sky130_ef_sc_hd__decap_12
XFILLER_131_15 VPWR VGND VPWR VGND sky130_ef_sc_hd__decap_12
XFILLER_216_949 VPWR VGND VPWR VGND sky130_ef_sc_hd__decap_12
XFILLER_199_105 VGND VGND VPWR VPWR sky130_fd_sc_hd__decap_6
XFILLER_167_1337 VGND VGND VPWR VPWR sky130_fd_sc_hd__decap_6
XFILLER_110_1550 VPWR VGND VPWR VGND sky130_ef_sc_hd__decap_12
XFILLER_54_122 VGND VGND VPWR VPWR sky130_fd_sc_hd__decap_4
XFILLER_199_149 VPWR VGND VPWR VGND sky130_ef_sc_hd__decap_12
XFILLER_110_1594 VGND VGND VPWR VPWR sky130_fd_sc_hd__decap_8
XFILLER_211_81 VPWR VGND VPWR VGND sky130_ef_sc_hd__decap_12
XFILLER_202_109 VPWR VGND VPWR VGND sky130_ef_sc_hd__decap_12
XTAP_TAPCELL_ROW_198_2386 VGND VPWR sky130_fd_sc_hd__tapvpwrvgnd_1
XTAP_TAPCELL_ROW_198_2375 VGND VPWR sky130_fd_sc_hd__tapvpwrvgnd_1
XFILLER_145_1602 VGND VGND VPWR VPWR sky130_fd_sc_hd__decap_3
XFILLER_93_1534 VPWR VGND VPWR VGND sky130_ef_sc_hd__decap_12
XFILLER_54_1518 VGND VGND VPWR VPWR sky130_fd_sc_hd__decap_6
XTAP_TAPCELL_ROW_198_2397 VGND VPWR sky130_fd_sc_hd__tapvpwrvgnd_1
XFILLER_168_525 VGND VGND VPWR VPWR sky130_fd_sc_hd__decap_6
XFILLER_93_1578 VPWR VGND VPWR VGND sky130_ef_sc_hd__decap_12
XFILLER_24_35 VPWR VGND VPWR VGND sky130_ef_sc_hd__decap_12
XTAP_TAPCELL_ROW_219_2968 VGND VPWR sky130_fd_sc_hd__tapvpwrvgnd_1
XFILLER_211_665 VGND VGND VPWR VPWR sky130_fd_sc_hd__decap_6
XFILLER_210_153 VPWR VGND VPWR VGND sky130_ef_sc_hd__decap_12
XFILLER_196_867 VGND VGND VPWR VPWR sky130_fd_sc_hd__fill_1
XFILLER_168_569 VPWR VGND VPWR VGND sky130_ef_sc_hd__decap_12
XFILLER_52_1220 VPWR VGND VPWR VGND sky130_ef_sc_hd__decap_12
XTAP_TAPCELL_ROW_219_2979 VGND VPWR sky130_fd_sc_hd__tapvpwrvgnd_1
XFILLER_210_197 VPWR VGND VPWR VGND sky130_ef_sc_hd__decap_12
XFILLER_206_1091 VGND VGND VPWR VPWR sky130_fd_sc_hd__fill_1
XFILLER_183_517 VPWR VGND VPWR VGND sky130_ef_sc_hd__decap_12
XFILLER_17_1384 VGND VGND VPWR VPWR sky130_fd_sc_hd__fill_1
XFILLER_191_561 VPWR VGND VPWR VGND sky130_ef_sc_hd__decap_12
XFILLER_30_1562 VPWR VGND VPWR VGND sky130_ef_sc_hd__decap_12
XFILLER_219_1441 VPWR VGND VPWR VGND sky130_ef_sc_hd__decap_12
XFILLER_178_1477 VGND VGND VPWR VPWR sky130_fd_sc_hd__decap_6
XTAP_TAPCELL_ROW_170_1571 VGND VPWR sky130_fd_sc_hd__tapvpwrvgnd_1
XFILLER_123_105 VGND VGND VPWR VPWR sky130_fd_sc_hd__decap_6
XTAP_TAPCELL_ROW_170_1593 VGND VPWR sky130_fd_sc_hd__tapvpwrvgnd_1
XTAP_TAPCELL_ROW_170_1582 VGND VPWR sky130_fd_sc_hd__tapvpwrvgnd_1
XFILLER_219_1485 VPWR VGND VPWR VGND sky130_ef_sc_hd__decap_12
XFILLER_49_32 VPWR VGND VPWR VGND sky130_ef_sc_hd__decap_12
XFILLER_24_1300 VGND VGND VPWR VPWR sky130_fd_sc_hd__fill_1
XTAP_TAPCELL_ROW_183_1943 VGND VPWR sky130_fd_sc_hd__tapvpwrvgnd_1
XFILLER_172_77 VGND VGND VPWR VPWR sky130_fd_sc_hd__decap_6
XPHY_EDGE_ROW_148_2_Right_205 VGND VGND VPWR VPWR sky130_fd_sc_hd__decap_3
XFILLER_98_1412 VGND VGND VPWR VPWR sky130_fd_sc_hd__fill_1
XFILLER_4_1427 VGND VGND VPWR VPWR sky130_fd_sc_hd__fill_1
XFILLER_8_1574 VGND VGND VPWR VPWR sky130_fd_sc_hd__decap_6
XFILLER_218_253 VPWR VGND VPWR VGND sky130_ef_sc_hd__decap_12
XTAP_TAPCELL_ROW_183_1965 VGND VPWR sky130_fd_sc_hd__tapvpwrvgnd_1
XTAP_TAPCELL_ROW_183_1954 VGND VPWR sky130_fd_sc_hd__tapvpwrvgnd_1
XFILLER_105_93 VPWR VGND VPWR VGND sky130_ef_sc_hd__decap_12
XFILLER_1_39 VPWR VGND VPWR VGND sky130_ef_sc_hd__decap_12
XFILLER_185_1437 VPWR VGND VPWR VGND sky130_ef_sc_hd__decap_12
XFILLER_2_1173 VPWR VGND VPWR VGND sky130_ef_sc_hd__decap_12
XFILLER_148_1270 VPWR VGND VPWR VGND sky130_ef_sc_hd__decap_12
XFILLER_202_643 VGND VGND VPWR VPWR sky130_fd_sc_hd__fill_1
XFILLER_121_81 VPWR VGND VPWR VGND sky130_ef_sc_hd__decap_12
XFILLER_109_1232 VPWR VGND VPWR VGND sky130_ef_sc_hd__decap_12
X_425_ _157_ _158_ VGND VGND VPWR VPWR _159_ sky130_fd_sc_hd__nor2_1
XFILLER_186_333 VPWR VGND VPWR VGND sky130_ef_sc_hd__decap_12
X_356_ net152 _080_ _088_ VGND VGND VPWR VPWR _100_ sky130_fd_sc_hd__and3_1
XFILLER_35_1440 VGND VGND VPWR VPWR sky130_fd_sc_hd__fill_1
XFILLER_187_889 VGND VGND VPWR VPWR sky130_fd_sc_hd__decap_6
XFILLER_186_377 VPWR VGND VPWR VGND sky130_ef_sc_hd__decap_12
XFILLER_109_1298 VPWR VGND VPWR VGND sky130_ef_sc_hd__decap_12
XTAP_TAPCELL_ROW_62_2_3384 VGND VPWR sky130_fd_sc_hd__tapvpwrvgnd_1
X_287_ net152 u_ctrl.state\[1\] VGND VGND VPWR VPWR net46 sky130_fd_sc_hd__or2_1
XFILLER_196_1533 VGND VGND VPWR VPWR sky130_fd_sc_hd__decap_6
XFILLER_170_701 VPWR VGND VPWR VGND sky130_ef_sc_hd__decap_12
XFILLER_196_1577 VPWR VGND VPWR VGND sky130_ef_sc_hd__decap_12
XFILLER_216_15 VPWR VGND VPWR VGND sky130_ef_sc_hd__decap_12
XFILLER_68_1282 VPWR VGND VPWR VGND sky130_ef_sc_hd__decap_12
XFILLER_29_1244 VPWR VGND VPWR VGND sky130_ef_sc_hd__decap_12
XFILLER_155_1274 VPWR VGND VPWR VGND sky130_ef_sc_hd__decap_12
XFILLER_116_1258 VPWR VGND VPWR VGND sky130_ef_sc_hd__decap_12
XFILLER_46_1580 VGND VGND VPWR VPWR sky130_fd_sc_hd__fill_1
Xinput5 func_addr[2] VGND VGND VPWR VPWR net5 sky130_fd_sc_hd__clkbuf_1
XFILLER_188_1061 VPWR VGND VPWR VGND sky130_ef_sc_hd__decap_12
XANTENNA__448__X _180_ VGND VGND VPWR VPWR sky130_fd_sc_hd__diode_2
XFILLER_206_993 VPWR VGND VPWR VGND sky130_ef_sc_hd__decap_12
XTAP_TAPCELL_ROW_201_2460 VGND VPWR sky130_fd_sc_hd__tapvpwrvgnd_1
XFILLER_197_609 VGND VGND VPWR VPWR sky130_fd_sc_hd__decap_6
XFILLER_127_1310 VPWR VGND VPWR VGND sky130_ef_sc_hd__decap_12
XFILLER_75_1220 VPWR VGND VPWR VGND sky130_ef_sc_hd__decap_12
XFILLER_51_125 VGND VGND VPWR VPWR sky130_fd_sc_hd__fill_2
XTAP_TAPCELL_ROW_201_2482 VGND VPWR sky130_fd_sc_hd__tapvpwrvgnd_1
XTAP_TAPCELL_ROW_201_2471 VGND VPWR sky130_fd_sc_hd__tapvpwrvgnd_1
XPHY_EDGE_ROW_110_2_Right_167 VGND VGND VPWR VPWR sky130_fd_sc_hd__decap_3
XFILLER_75_1286 VPWR VGND VPWR VGND sky130_ef_sc_hd__decap_12
XTAP_TAPCELL_ROW_193_2250 VGND VPWR sky130_fd_sc_hd__tapvpwrvgnd_1
XFILLER_189_193 VPWR VGND VPWR VGND sky130_ef_sc_hd__decap_12
XFILLER_178_867 VGND VGND VPWR VPWR sky130_fd_sc_hd__fill_1
XFILLER_127_1354 VPWR VGND VPWR VGND sky130_ef_sc_hd__decap_12
XFILLER_203_1231 VGND VGND VPWR VPWR sky130_fd_sc_hd__fill_1
XFILLER_165_517 VPWR VGND VPWR VGND sky130_ef_sc_hd__decap_12
XFILLER_127_1398 VPWR VGND VPWR VGND sky130_ef_sc_hd__decap_12
XFILLER_14_1524 VGND VGND VPWR VPWR sky130_fd_sc_hd__fill_1
XTAP_TAPCELL_ROW_214_2832 VGND VPWR sky130_fd_sc_hd__tapvpwrvgnd_1
XTAP_TAPCELL_ROW_127_1_1272 VGND VPWR sky130_fd_sc_hd__tapvpwrvgnd_1
XTAP_TAPCELL_ROW_214_2843 VGND VPWR sky130_fd_sc_hd__tapvpwrvgnd_1
XFILLER_195_1021 VPWR VGND VPWR VGND sky130_ef_sc_hd__decap_12
XFILLER_173_561 VPWR VGND VPWR VGND sky130_ef_sc_hd__decap_12
XTAP_TAPCELL_ROW_210_2729 VGND VPWR sky130_fd_sc_hd__tapvpwrvgnd_1
XTAP_TAPCELL_ROW_210_2718 VGND VPWR sky130_fd_sc_hd__tapvpwrvgnd_1
XFILLER_195_1065 VPWR VGND VPWR VGND sky130_ef_sc_hd__decap_12
XFILLER_105_105 VGND VGND VPWR VPWR sky130_fd_sc_hd__decap_6
XFILLER_10_15 VPWR VGND VPWR VGND sky130_ef_sc_hd__decap_12
XFILLER_12_1270 VPWR VGND VPWR VGND sky130_ef_sc_hd__decap_12
XFILLER_126_15 VPWR VGND VPWR VGND sky130_ef_sc_hd__decap_12
XFILLER_47_1322 VGND VGND VPWR VPWR sky130_fd_sc_hd__decap_6
XTAP_TAPCELL_ROW_187_2076 VGND VPWR sky130_fd_sc_hd__tapvpwrvgnd_1
XTAP_TAPCELL_ROW_187_2065 VGND VPWR sky130_fd_sc_hd__tapvpwrvgnd_1
XFILLER_138_1450 VPWR VGND VPWR VGND sky130_ef_sc_hd__decap_12
XFILLER_134_1314 VPWR VGND VPWR VGND sky130_ef_sc_hd__decap_12
XFILLER_86_1382 VPWR VGND VPWR VGND sky130_ef_sc_hd__decap_12
XFILLER_82_1246 VPWR VGND VPWR VGND sky130_ef_sc_hd__decap_12
XFILLER_47_1366 VPWR VGND VPWR VGND sky130_ef_sc_hd__decap_12
XFILLER_138_1494 VPWR VGND VPWR VGND sky130_ef_sc_hd__decap_12
XFILLER_214_1371 VGND VGND VPWR VPWR sky130_fd_sc_hd__fill_1
XFILLER_134_1358 VPWR VGND VPWR VGND sky130_ef_sc_hd__decap_12
XTAP_TAPCELL_ROW_208_2669 VGND VPWR sky130_fd_sc_hd__tapvpwrvgnd_1
XTAP_TAPCELL_ROW_208_2658 VGND VPWR sky130_fd_sc_hd__tapvpwrvgnd_1
XFILLER_19_57 VPWR VGND VPWR VGND sky130_ef_sc_hd__decap_12
XFILLER_216_713 VPWR VGND VPWR VGND sky130_ef_sc_hd__decap_12
XFILLER_167_1101 VPWR VGND VPWR VGND sky130_ef_sc_hd__decap_12
XFILLER_216_757 VPWR VGND VPWR VGND sky130_ef_sc_hd__decap_12
XFILLER_215_223 VGND VGND VPWR VPWR sky130_fd_sc_hd__fill_1
XFILLER_167_1145 VPWR VGND VPWR VGND sky130_ef_sc_hd__decap_12
XTAP_TAPCELL_ROW_111_2_3701 VGND VPWR sky130_fd_sc_hd__tapvpwrvgnd_1
XFILLER_203_429 VPWR VGND VPWR VGND sky130_ef_sc_hd__decap_12
XFILLER_163_1009 VGND VGND VPWR VPWR sky130_fd_sc_hd__decap_6
XFILLER_93_1342 VPWR VGND VPWR VGND sky130_ef_sc_hd__decap_12
XFILLER_3_1493 VPWR VGND VPWR VGND sky130_ef_sc_hd__decap_12
XFILLER_167_1189 VPWR VGND VPWR VGND sky130_ef_sc_hd__decap_12
XFILLER_149_1590 VPWR VGND VPWR VGND sky130_ef_sc_hd__decap_12
XFILLER_145_1410 VPWR VGND VPWR VGND sky130_ef_sc_hd__decap_12
XFILLER_54_1326 VPWR VGND VPWR VGND sky130_ef_sc_hd__decap_12
XFILLER_58_1462 VGND VGND VPWR VPWR sky130_fd_sc_hd__decap_6
XFILLER_204_1017 VPWR VGND VPWR VGND sky130_ef_sc_hd__decap_12
XFILLER_168_333 VPWR VGND VPWR VGND sky130_ef_sc_hd__decap_12
XFILLER_145_1454 VPWR VGND VPWR VGND sky130_ef_sc_hd__decap_12
XFILLER_93_1386 VPWR VGND VPWR VGND sky130_ef_sc_hd__decap_12
XFILLER_211_473 VPWR VGND VPWR VGND sky130_ef_sc_hd__decap_12
XFILLER_208_1197 VGND VGND VPWR VPWR sky130_fd_sc_hd__decap_6
XFILLER_184_837 VPWR VGND VPWR VGND sky130_ef_sc_hd__decap_12
XFILLER_169_889 VGND VGND VPWR VPWR sky130_fd_sc_hd__decap_6
XFILLER_168_377 VPWR VGND VPWR VGND sky130_ef_sc_hd__decap_12
XFILLER_145_1498 VPWR VGND VPWR VGND sky130_ef_sc_hd__decap_12
XFILLER_136_3 VPWR VGND VPWR VGND sky130_ef_sc_hd__decap_12
XFILLER_106_1438 VPWR VGND VPWR VGND sky130_ef_sc_hd__decap_12
XFILLER_7_505 VGND VGND VPWR VPWR sky130_fd_sc_hd__decap_6
XFILLER_32_1602 VGND VGND VPWR VPWR sky130_fd_sc_hd__decap_3
XTAP_TAPCELL_ROW_47_2_3286 VGND VPWR sky130_fd_sc_hd__tapvpwrvgnd_1
XFILLER_167_55 VGND VGND VPWR VPWR sky130_fd_sc_hd__fill_1
XFILLER_51_55 VGND VGND VPWR VPWR sky130_fd_sc_hd__fill_1
XFILLER_178_1241 VPWR VGND VPWR VGND sky130_ef_sc_hd__decap_12
XTAP_TAPCELL_ROW_172_1655 VGND VPWR sky130_fd_sc_hd__tapvpwrvgnd_1
XTAP_TAPCELL_ROW_172_1644 VGND VPWR sky130_fd_sc_hd__tapvpwrvgnd_1
XTAP_TAPCELL_ROW_172_1633 VGND VPWR sky130_fd_sc_hd__tapvpwrvgnd_1
XTAP_TAPCELL_ROW_27_2_3151 VGND VPWR sky130_fd_sc_hd__tapvpwrvgnd_1
XFILLER_192_881 VPWR VGND VPWR VGND sky130_ef_sc_hd__decap_12
XFILLER_174_1105 VPWR VGND VPWR VGND sky130_ef_sc_hd__decap_12
XFILLER_30_1370 VPWR VGND VPWR VGND sky130_ef_sc_hd__decap_12
XFILLER_191_391 VGND VGND VPWR VPWR sky130_fd_sc_hd__fill_1
XFILLER_178_1285 VPWR VGND VPWR VGND sky130_ef_sc_hd__decap_12
XFILLER_174_1149 VPWR VGND VPWR VGND sky130_ef_sc_hd__decap_12
XFILLER_65_1422 VPWR VGND VPWR VGND sky130_ef_sc_hd__decap_12
XFILLER_215_1113 VGND VGND VPWR VPWR sky130_fd_sc_hd__decap_6
XFILLER_156_1550 VPWR VGND VPWR VGND sky130_ef_sc_hd__decap_12
XFILLER_26_1406 VGND VGND VPWR VPWR sky130_fd_sc_hd__decap_6
XFILLER_215_1157 VPWR VGND VPWR VGND sky130_ef_sc_hd__decap_12
XFILLER_156_1594 VGND VGND VPWR VPWR sky130_fd_sc_hd__decap_8
XFILLER_152_1414 VPWR VGND VPWR VGND sky130_ef_sc_hd__decap_12
XFILLER_117_1534 VPWR VGND VPWR VGND sky130_ef_sc_hd__decap_12
XFILLER_65_1466 VPWR VGND VPWR VGND sky130_ef_sc_hd__decap_12
XFILLER_117_1578 VPWR VGND VPWR VGND sky130_ef_sc_hd__decap_12
XFILLER_76_41 VPWR VGND VPWR VGND sky130_ef_sc_hd__decap_12
XTAP_TAPCELL_ROW_20_2_3105 VGND VPWR sky130_fd_sc_hd__tapvpwrvgnd_1
XTAP_TAPCELL_ROW_166_1459 VGND VPWR sky130_fd_sc_hd__tapvpwrvgnd_1
XPHY_EDGE_ROW_149_2_Right_206 VGND VGND VPWR VPWR sky130_fd_sc_hd__decap_3
XFILLER_98_1220 VPWR VGND VPWR VGND sky130_ef_sc_hd__decap_12
XFILLER_76_85 VPWR VGND VPWR VGND sky130_ef_sc_hd__decap_12
XFILLER_8_1382 VPWR VGND VPWR VGND sky130_ef_sc_hd__decap_12
XFILLER_219_573 VPWR VGND VPWR VGND sky130_ef_sc_hd__decap_12
XFILLER_185_1201 VPWR VGND VPWR VGND sky130_ef_sc_hd__decap_12
XFILLER_206_245 VGND VGND VPWR VPWR sky130_fd_sc_hd__decap_6
XFILLER_189_1381 VPWR VGND VPWR VGND sky130_ef_sc_hd__decap_12
XFILLER_185_1245 VPWR VGND VPWR VGND sky130_ef_sc_hd__decap_12
XFILLER_179_609 VGND VGND VPWR VPWR sky130_fd_sc_hd__decap_6
XFILLER_206_289 VPWR VGND VPWR VGND sky130_ef_sc_hd__decap_12
XFILLER_185_1289 VPWR VGND VPWR VGND sky130_ef_sc_hd__decap_12
XFILLER_76_1562 VPWR VGND VPWR VGND sky130_ef_sc_hd__decap_12
XFILLER_187_653 VPWR VGND VPWR VGND sky130_ef_sc_hd__decap_12
XFILLER_163_1565 VGND VGND VPWR VPWR sky130_fd_sc_hd__decap_3
XFILLER_72_1426 VPWR VGND VPWR VGND sky130_ef_sc_hd__decap_12
X_408_ _143_ _141_ VGND VGND VPWR VPWR _144_ sky130_fd_sc_hd__and2b_1
XFILLER_37_1546 VGND VGND VPWR VPWR sky130_fd_sc_hd__decap_6
XFILLER_186_141 VPWR VGND VPWR VGND sky130_ef_sc_hd__decap_12
XFILLER_124_1538 VPWR VGND VPWR VGND sky130_ef_sc_hd__decap_12
XFILLER_187_697 VPWR VGND VPWR VGND sky130_ef_sc_hd__decap_12
X_339_ net157 _090_ VGND VGND VPWR VPWR _006_ sky130_fd_sc_hd__and2_1
XPHY_EDGE_ROW_30_1_Right_616 VGND VGND VPWR VPWR sky130_fd_sc_hd__decap_3
XFILLER_204_1595 VGND VGND VPWR VPWR sky130_fd_sc_hd__fill_1
XFILLER_196_1341 VPWR VGND VPWR VGND sky130_ef_sc_hd__decap_12
XFILLER_192_1205 VPWR VGND VPWR VGND sky130_ef_sc_hd__decap_12
XFILLER_13_1590 VPWR VGND VPWR VGND sky130_ef_sc_hd__decap_12
XFILLER_196_1385 VPWR VGND VPWR VGND sky130_ef_sc_hd__decap_12
XFILLER_170_531 VGND VGND VPWR VPWR sky130_fd_sc_hd__fill_1
XFILLER_51_3 VPWR VGND VPWR VGND sky130_ef_sc_hd__decap_12
XFILLER_100_1582 VPWR VGND VPWR VGND sky130_ef_sc_hd__decap_12
XFILLER_83_1522 VPWR VGND VPWR VGND sky130_ef_sc_hd__decap_12
XFILLER_83_1566 VPWR VGND VPWR VGND sky130_ef_sc_hd__decap_12
XFILLER_44_1506 VPWR VGND VPWR VGND sky130_ef_sc_hd__decap_12
XFILLER_211_1511 VGND VGND VPWR VPWR sky130_fd_sc_hd__fill_1
XTAP_TAPCELL_ROW_84_2_3527 VGND VPWR sky130_fd_sc_hd__tapvpwrvgnd_1
XPHY_EDGE_ROW_11_2_Right_68 VGND VGND VPWR VPWR sky130_fd_sc_hd__decap_3
XTAP_TAPCELL_ROW_203_2533 VGND VPWR sky130_fd_sc_hd__tapvpwrvgnd_1
XTAP_TAPCELL_ROW_203_2522 VGND VPWR sky130_fd_sc_hd__tapvpwrvgnd_1
XFILLER_168_1421 VGND VGND VPWR VPWR sky130_fd_sc_hd__decap_6
XFILLER_20_1550 VPWR VGND VPWR VGND sky130_ef_sc_hd__decap_12
XFILLER_213_727 VGND VGND VPWR VPWR sky130_fd_sc_hd__fill_1
XTAP_TAPCELL_ROW_195_2301 VGND VPWR sky130_fd_sc_hd__tapvpwrvgnd_1
XFILLER_168_1465 VPWR VGND VPWR VGND sky130_ef_sc_hd__decap_12
XTAP_TAPCELL_ROW_0_758 VGND VPWR sky130_fd_sc_hd__tapvpwrvgnd_1
XTAP_TAPCELL_ROW_0_769 VGND VPWR sky130_fd_sc_hd__tapvpwrvgnd_1
XFILLER_24_103 VPWR VGND VPWR VGND sky130_ef_sc_hd__decap_12
XFILLER_197_417 VPWR VGND VPWR VGND sky130_ef_sc_hd__decap_12
XFILLER_164_1329 VPWR VGND VPWR VGND sky130_ef_sc_hd__decap_12
XFILLER_20_1594 VGND VGND VPWR VPWR sky130_fd_sc_hd__decap_8
XFILLER_55_1602 VGND VGND VPWR VPWR sky130_fd_sc_hd__decap_3
XFILLER_90_1526 VPWR VGND VPWR VGND sky130_ef_sc_hd__decap_12
XTAP_TAPCELL_ROW_33_2_3194 VGND VPWR sky130_fd_sc_hd__tapvpwrvgnd_1
XTAP_TAPCELL_ROW_216_2905 VGND VPWR sky130_fd_sc_hd__tapvpwrvgnd_1
XFILLER_205_1337 VGND VGND VPWR VPWR sky130_fd_sc_hd__decap_6
XPHY_EDGE_ROW_111_2_Right_168 VGND VGND VPWR VPWR sky130_fd_sc_hd__decap_3
XTAP_TAPCELL_ROW_9_2_3035 VGND VPWR sky130_fd_sc_hd__tapvpwrvgnd_1
XFILLER_166_837 VPWR VGND VPWR VGND sky130_ef_sc_hd__decap_12
XTAP_TAPCELL_ROW_158_1_1333 VGND VPWR sky130_fd_sc_hd__tapvpwrvgnd_1
XFILLER_192_133 VGND VGND VPWR VPWR sky130_fd_sc_hd__decap_6
XTAP_TAPCELL_ROW_63_1_1144 VGND VPWR sky130_fd_sc_hd__tapvpwrvgnd_1
XANTENNA_fanout129_X net129 VGND VGND VPWR VPWR sky130_fd_sc_hd__diode_2
XFILLER_192_177 VPWR VGND VPWR VGND sky130_ef_sc_hd__decap_12
XTAP_TAPCELL_ROW_189_2127 VGND VPWR sky130_fd_sc_hd__tapvpwrvgnd_1
XTAP_TAPCELL_ROW_189_2116 VGND VPWR sky130_fd_sc_hd__tapvpwrvgnd_1
XFILLER_179_1561 VGND VGND VPWR VPWR sky130_fd_sc_hd__decap_6
XFILLER_174_881 VPWR VGND VPWR VGND sky130_ef_sc_hd__decap_12
XFILLER_4_519 VPWR VGND VPWR VGND sky130_ef_sc_hd__decap_12
XTAP_TAPCELL_ROW_189_2138 VGND VPWR sky130_fd_sc_hd__tapvpwrvgnd_1
XFILLER_175_1425 VPWR VGND VPWR VGND sky130_ef_sc_hd__decap_12
XFILLER_173_391 VGND VGND VPWR VPWR sky130_fd_sc_hd__fill_1
XFILLER_137_69 VPWR VGND VPWR VGND sky130_ef_sc_hd__decap_12
XPHY_EDGE_ROW_76_2_Left_508 VGND VGND VPWR VPWR sky130_fd_sc_hd__decap_3
XFILLER_175_1469 VPWR VGND VPWR VGND sky130_ef_sc_hd__decap_12
XFILLER_216_1477 VGND VGND VPWR VPWR sky130_fd_sc_hd__decap_6
XFILLER_153_57 VPWR VGND VPWR VGND sky130_ef_sc_hd__decap_12
XFILLER_5_1511 VGND VGND VPWR VPWR sky130_fd_sc_hd__fill_1
XFILLER_186_1521 VPWR VGND VPWR VGND sky130_ef_sc_hd__decap_12
XFILLER_46_77 VGND VGND VPWR VPWR sky130_fd_sc_hd__decap_6
XFILLER_216_587 VGND VGND VPWR VPWR sky130_fd_sc_hd__fill_1
XFILLER_186_1565 VPWR VGND VPWR VGND sky130_ef_sc_hd__decap_12
XPHY_EDGE_ROW_73_2_Right_130 VGND VGND VPWR VPWR sky130_fd_sc_hd__decap_3
XFILLER_15_125 VGND VGND VPWR VPWR sky130_fd_sc_hd__fill_2
XFILLER_204_749 VGND VGND VPWR VPWR sky130_fd_sc_hd__decap_6
XFILLER_203_237 VPWR VGND VPWR VGND sky130_ef_sc_hd__decap_12
XFILLER_182_1429 VPWR VGND VPWR VGND sky130_ef_sc_hd__decap_12
XFILLER_58_1270 VPWR VGND VPWR VGND sky130_ef_sc_hd__decap_12
XFILLER_197_951 VGND VGND VPWR VPWR sky130_fd_sc_hd__fill_1
XTAP_TAPCELL_ROW_178_1820 VGND VPWR sky130_fd_sc_hd__tapvpwrvgnd_1
XFILLER_169_653 VPWR VGND VPWR VGND sky130_ef_sc_hd__decap_12
XFILLER_102_83 VGND VGND VPWR VPWR sky130_fd_sc_hd__fill_1
XFILLER_19_1232 VPWR VGND VPWR VGND sky130_ef_sc_hd__decap_12
XFILLER_212_793 VPWR VGND VPWR VGND sky130_ef_sc_hd__decap_12
XFILLER_184_601 VPWR VGND VPWR VGND sky130_ef_sc_hd__decap_12
XTAP_TAPCELL_ROW_174_1706 VGND VPWR sky130_fd_sc_hd__tapvpwrvgnd_1
XFILLER_168_141 VPWR VGND VPWR VGND sky130_ef_sc_hd__decap_12
XFILLER_62_65 VPWR VGND VPWR VGND sky130_ef_sc_hd__decap_12
XFILLER_211_281 VPWR VGND VPWR VGND sky130_ef_sc_hd__decap_12
XFILLER_184_645 VPWR VGND VPWR VGND sky130_ef_sc_hd__decap_12
XFILLER_183_111 VGND VGND VPWR VPWR sky130_fd_sc_hd__fill_1
XFILLER_180_1197 VGND VGND VPWR VPWR sky130_fd_sc_hd__decap_6
XFILLER_178_65 VPWR VGND VPWR VGND sky130_ef_sc_hd__decap_12
XFILLER_169_697 VPWR VGND VPWR VGND sky130_ef_sc_hd__decap_12
XFILLER_106_1246 VPWR VGND VPWR VGND sky130_ef_sc_hd__decap_12
XFILLER_7_27 VGND VGND VPWR VPWR sky130_fd_sc_hd__fill_1
XFILLER_19_1298 VPWR VGND VPWR VGND sky130_ef_sc_hd__decap_12
XTAP_TAPCELL_ROW_77_2_3481 VGND VPWR sky130_fd_sc_hd__tapvpwrvgnd_1
XFILLER_171_317 VPWR VGND VPWR VGND sky130_ef_sc_hd__decap_12
XFILLER_194_53 VPWR VGND VPWR VGND sky130_ef_sc_hd__decap_12
XFILLER_193_1525 VPWR VGND VPWR VGND sky130_ef_sc_hd__decap_12
XFILLER_194_97 VPWR VGND VPWR VGND sky130_ef_sc_hd__decap_12
XFILLER_193_1569 VPWR VGND VPWR VGND sky130_ef_sc_hd__decap_12
XFILLER_178_1093 VPWR VGND VPWR VGND sky130_ef_sc_hd__decap_12
XFILLER_87_51 VGND VGND VPWR VPWR sky130_fd_sc_hd__decap_4
XFILLER_152_1244 VGND VGND VPWR VPWR sky130_fd_sc_hd__fill_1
XFILLER_117_1342 VPWR VGND VPWR VGND sky130_ef_sc_hd__decap_12
XTAP_TAPCELL_ROW_70_2_3435 VGND VPWR sky130_fd_sc_hd__tapvpwrvgnd_1
XTAP_TAPCELL_ROW_69_2_3429 VGND VPWR sky130_fd_sc_hd__tapvpwrvgnd_1
XFILLER_65_1274 VPWR VGND VPWR VGND sky130_ef_sc_hd__decap_12
XFILLER_26_1258 VPWR VGND VPWR VGND sky130_ef_sc_hd__decap_12
XFILLER_117_1386 VPWR VGND VPWR VGND sky130_ef_sc_hd__decap_12
XFILLER_213_27 VPWR VGND VPWR VGND sky130_ef_sc_hd__decap_12
XFILLER_78_1602 VGND VGND VPWR VPWR sky130_fd_sc_hd__decap_3
XANTENNA__439__A net148 VGND VGND VPWR VPWR sky130_fd_sc_hd__diode_2
XTAP_TAPCELL_ROW_50_2_3300 VGND VPWR sky130_fd_sc_hd__tapvpwrvgnd_1
XFILLER_179_417 VPWR VGND VPWR VGND sky130_ef_sc_hd__decap_12
XTAP_TAPCELL_ROW_18_2_3096 VGND VPWR sky130_fd_sc_hd__tapvpwrvgnd_1
XFILLER_37_1310 VPWR VGND VPWR VGND sky130_ef_sc_hd__decap_12
XPHY_EDGE_ROW_42_1_Left_261 VGND VGND VPWR VPWR sky130_fd_sc_hd__decap_3
XFILLER_99_3 VPWR VGND VPWR VGND sky130_ef_sc_hd__decap_12
XFILLER_76_1370 VPWR VGND VPWR VGND sky130_ef_sc_hd__decap_12
XFILLER_21_106 VGND VGND VPWR VPWR sky130_fd_sc_hd__decap_6
XFILLER_188_973 VGND VGND VPWR VPWR sky130_fd_sc_hd__decap_6
XFILLER_187_461 VPWR VGND VPWR VGND sky130_ef_sc_hd__decap_12
XFILLER_163_1373 VPWR VGND VPWR VGND sky130_ef_sc_hd__decap_12
XFILLER_128_1482 VPWR VGND VPWR VGND sky130_ef_sc_hd__decap_12
XFILLER_124_1302 VPWR VGND VPWR VGND sky130_ef_sc_hd__decap_12
XFILLER_37_1354 VPWR VGND VPWR VGND sky130_ef_sc_hd__decap_12
XFILLER_37_1398 VPWR VGND VPWR VGND sky130_ef_sc_hd__decap_12
XFILLER_174_133 VGND VGND VPWR VPWR sky130_fd_sc_hd__decap_6
Xinput30 func_wdata[26] VGND VGND VPWR VPWR net30 sky130_fd_sc_hd__clkbuf_1
XPHY_EDGE_ROW_31_1_Right_617 VGND VGND VPWR VPWR sky130_fd_sc_hd__decap_3
XFILLER_190_637 VGND VGND VPWR VPWR sky130_fd_sc_hd__decap_6
XFILLER_174_177 VPWR VGND VPWR VGND sky130_ef_sc_hd__decap_12
Xinput41 func_wdata[7] VGND VGND VPWR VPWR net41 sky130_fd_sc_hd__clkbuf_1
XFILLER_192_1035 VGND VGND VPWR VPWR sky130_fd_sc_hd__fill_1
XFILLER_107_39 VPWR VGND VPWR VGND sky130_ef_sc_hd__decap_12
XFILLER_171_895 VGND VGND VPWR VPWR sky130_fd_sc_hd__fill_1
XFILLER_83_1330 VPWR VGND VPWR VGND sky130_ef_sc_hd__decap_12
XFILLER_44_1314 VPWR VGND VPWR VGND sky130_ef_sc_hd__decap_12
XFILLER_48_1450 VPWR VGND VPWR VGND sky130_ef_sc_hd__decap_12
XFILLER_135_1442 VPWR VGND VPWR VGND sky130_ef_sc_hd__decap_12
XFILLER_48_1494 VPWR VGND VPWR VGND sky130_ef_sc_hd__decap_12
XFILLER_131_1328 VGND VGND VPWR VPWR sky130_fd_sc_hd__fill_1
XFILLER_44_1358 VPWR VGND VPWR VGND sky130_ef_sc_hd__decap_12
XFILLER_217_329 VGND VGND VPWR VPWR sky130_fd_sc_hd__decap_6
XFILLER_123_27 VPWR VGND VPWR VGND sky130_ef_sc_hd__decap_12
XANTENNA__349__A net156 VGND VGND VPWR VPWR sky130_fd_sc_hd__diode_2
XFILLER_203_93 VPWR VGND VPWR VGND sky130_ef_sc_hd__decap_12
XFILLER_198_737 VPWR VGND VPWR VGND sky130_ef_sc_hd__decap_12
XFILLER_168_1273 VPWR VGND VPWR VGND sky130_ef_sc_hd__decap_12
XFILLER_0_1441 VPWR VGND VPWR VGND sky130_ef_sc_hd__decap_12
XFILLER_16_58 VGND VGND VPWR VPWR sky130_fd_sc_hd__fill_1
XFILLER_16_69 VGND VGND VPWR VPWR sky130_fd_sc_hd__fill_1
XFILLER_205_1101 VPWR VGND VPWR VGND sky130_ef_sc_hd__decap_12
XFILLER_197_225 VPWR VGND VPWR VGND sky130_ef_sc_hd__decap_12
XFILLER_179_951 VGND VGND VPWR VPWR sky130_fd_sc_hd__fill_1
XFILLER_129_1268 VGND VGND VPWR VPWR sky130_fd_sc_hd__decap_4
XFILLER_94_1470 VPWR VGND VPWR VGND sky130_ef_sc_hd__decap_12
XFILLER_0_1485 VPWR VGND VPWR VGND sky130_ef_sc_hd__decap_12
XFILLER_12_117 VGND VGND VPWR VPWR sky130_fd_sc_hd__decap_8
XFILLER_55_1410 VPWR VGND VPWR VGND sky130_ef_sc_hd__decap_12
XFILLER_59_1590 VPWR VGND VPWR VGND sky130_ef_sc_hd__decap_12
XFILLER_209_1281 VGND VGND VPWR VPWR sky130_fd_sc_hd__decap_6
XFILLER_166_601 VPWR VGND VPWR VGND sky130_ef_sc_hd__decap_12
XFILLER_146_1582 VPWR VGND VPWR VGND sky130_ef_sc_hd__decap_12
XFILLER_107_1522 VPWR VGND VPWR VGND sky130_ef_sc_hd__decap_12
XFILLER_90_1356 VGND VGND VPWR VPWR sky130_fd_sc_hd__fill_1
XFILLER_55_1454 VPWR VGND VPWR VGND sky130_ef_sc_hd__decap_12
XFILLER_205_1145 VPWR VGND VPWR VGND sky130_ef_sc_hd__decap_12
XFILLER_201_1009 VPWR VGND VPWR VGND sky130_ef_sc_hd__decap_12
XFILLER_165_111 VGND VGND VPWR VPWR sky130_fd_sc_hd__fill_1
XPHY_EDGE_ROW_112_2_Right_169 VGND VGND VPWR VPWR sky130_fd_sc_hd__decap_3
XFILLER_107_1566 VPWR VGND VPWR VGND sky130_ef_sc_hd__decap_12
XFILLER_16_1438 VPWR VGND VPWR VGND sky130_ef_sc_hd__decap_12
XFILLER_55_1498 VPWR VGND VPWR VGND sky130_ef_sc_hd__decap_12
XFILLER_205_1189 VPWR VGND VPWR VGND sky130_ef_sc_hd__decap_12
XFILLER_166_645 VPWR VGND VPWR VGND sky130_ef_sc_hd__decap_12
XFILLER_142_1468 VGND VGND VPWR VPWR sky130_fd_sc_hd__fill_1
XTAP_TAPCELL_ROW_94_1_1205 VGND VPWR sky130_fd_sc_hd__tapvpwrvgnd_1
XFILLER_193_497 VGND VGND VPWR VPWR sky130_fd_sc_hd__decap_6
XFILLER_181_615 VGND VGND VPWR VPWR sky130_fd_sc_hd__fill_1
XFILLER_5_839 VGND VGND VPWR VPWR sky130_fd_sc_hd__fill_1
XFILLER_218_1539 VGND VGND VPWR VPWR sky130_fd_sc_hd__fill_1
XFILLER_175_1233 VPWR VGND VPWR VGND sky130_ef_sc_hd__decap_12
XFILLER_171_1119 VGND VGND VPWR VPWR sky130_fd_sc_hd__fill_1
XFILLER_66_1550 VPWR VGND VPWR VGND sky130_ef_sc_hd__decap_12
XFILLER_0_522 VGND VGND VPWR VPWR sky130_fd_sc_hd__fill_1
XTAP_TAPCELL_ROW_55_2_3337 VGND VPWR sky130_fd_sc_hd__tapvpwrvgnd_1
XFILLER_216_1241 VPWR VGND VPWR VGND sky130_ef_sc_hd__decap_12
XTAP_TAPCELL_ROW_167_1510 VGND VPWR sky130_fd_sc_hd__tapvpwrvgnd_1
XFILLER_66_1594 VGND VGND VPWR VPWR sky130_fd_sc_hd__decap_8
XFILLER_27_1534 VPWR VGND VPWR VGND sky130_ef_sc_hd__decap_12
XFILLER_62_1414 VPWR VGND VPWR VGND sky130_ef_sc_hd__decap_12
XFILLER_216_1285 VPWR VGND VPWR VGND sky130_ef_sc_hd__decap_12
XFILLER_212_1105 VPWR VGND VPWR VGND sky130_ef_sc_hd__decap_12
XFILLER_114_1526 VPWR VGND VPWR VGND sky130_ef_sc_hd__decap_12
XFILLER_94_109 VPWR VGND VPWR VGND sky130_ef_sc_hd__decap_12
XFILLER_0_566 VGND VGND VPWR VPWR sky130_fd_sc_hd__fill_1
XFILLER_0_577 VGND VGND VPWR VPWR sky130_fd_sc_hd__decap_4
XFILLER_27_1578 VPWR VGND VPWR VGND sky130_ef_sc_hd__decap_12
XFILLER_57_32 VPWR VGND VPWR VGND sky130_ef_sc_hd__decap_12
XFILLER_212_1149 VPWR VGND VPWR VGND sky130_ef_sc_hd__decap_12
XFILLER_208_307 VGND VGND VPWR VPWR sky130_fd_sc_hd__fill_1
XFILLER_217_841 VPWR VGND VPWR VGND sky130_ef_sc_hd__decap_12
XFILLER_180_77 VGND VGND VPWR VPWR sky130_fd_sc_hd__decap_6
XTAP_TAPCELL_ROW_4_894 VGND VPWR sky130_fd_sc_hd__tapvpwrvgnd_1
XANTENNA_input19_A func_wdata[16] VGND VGND VPWR VPWR sky130_fd_sc_hd__diode_2
XFILLER_112_1294 VGND VGND VPWR VPWR sky130_fd_sc_hd__decap_6
XFILLER_204_513 VPWR VGND VPWR VGND sky130_ef_sc_hd__decap_12
XFILLER_186_1373 VPWR VGND VPWR VGND sky130_ef_sc_hd__decap_12
XFILLER_113_93 VPWR VGND VPWR VGND sky130_ef_sc_hd__decap_12
XFILLER_95_1256 VPWR VGND VPWR VGND sky130_ef_sc_hd__decap_12
XFILLER_204_557 VPWR VGND VPWR VGND sky130_ef_sc_hd__decap_12
XFILLER_182_1259 VGND VGND VPWR VPWR sky130_fd_sc_hd__fill_1
XPHY_EDGE_ROW_74_2_Right_131 VGND VGND VPWR VPWR sky130_fd_sc_hd__decap_3
XFILLER_73_1510 VPWR VGND VPWR VGND sky130_ef_sc_hd__decap_12
XFILLER_169_461 VPWR VGND VPWR VGND sky130_ef_sc_hd__decap_12
XFILLER_73_1554 VPWR VGND VPWR VGND sky130_ef_sc_hd__decap_12
XFILLER_185_921 VPWR VGND VPWR VGND sky130_ef_sc_hd__decap_12
XFILLER_160_1524 VGND VGND VPWR VPWR sky130_fd_sc_hd__fill_1
XFILLER_34_1538 VPWR VGND VPWR VGND sky130_ef_sc_hd__decap_12
XFILLER_185_965 VPWR VGND VPWR VGND sky130_ef_sc_hd__decap_12
XTAP_TAPCELL_ROW_141_1_1300 VGND VPWR sky130_fd_sc_hd__tapvpwrvgnd_1
XFILLER_184_475 VGND VGND VPWR VPWR sky130_fd_sc_hd__fill_1
XFILLER_172_637 VGND VGND VPWR VPWR sky130_fd_sc_hd__decap_6
XFILLER_208_27 VGND VGND VPWR VPWR sky130_fd_sc_hd__fill_1
XFILLER_171_125 VPWR VGND VPWR VGND sky130_ef_sc_hd__decap_12
XFILLER_7_187 VGND VGND VPWR VPWR sky130_fd_sc_hd__decap_6
XFILLER_171_169 VPWR VGND VPWR VGND sky130_ef_sc_hd__decap_12
XTAP_TAPCELL_ROW_152_2_3965 VGND VPWR sky130_fd_sc_hd__tapvpwrvgnd_1
XFILLER_180_681 VPWR VGND VPWR VGND sky130_ef_sc_hd__decap_12
XFILLER_98_83 VGND VGND VPWR VPWR sky130_fd_sc_hd__fill_1
XFILLER_10_1582 VPWR VGND VPWR VGND sky130_ef_sc_hd__decap_12
XFILLER_193_1399 VGND VGND VPWR VPWR sky130_fd_sc_hd__fill_1
XFILLER_3_382 VGND VGND VPWR VPWR sky130_fd_sc_hd__fill_1
XFILLER_3_393 VGND VGND VPWR VPWR sky130_fd_sc_hd__decap_3
XFILLER_6_1105 VPWR VGND VPWR VGND sky130_ef_sc_hd__decap_12
XFILLER_6_1149 VPWR VGND VPWR VGND sky130_ef_sc_hd__decap_12
XFILLER_14_3 VPWR VGND VPWR VGND sky130_ef_sc_hd__decap_12
XFILLER_130_1350 VGND VGND VPWR VPWR sky130_fd_sc_hd__decap_6
XTAP_TAPCELL_ROW_99_2_3624 VGND VPWR sky130_fd_sc_hd__tapvpwrvgnd_1
XFILLER_130_1394 VPWR VGND VPWR VGND sky130_ef_sc_hd__decap_12
XTAP_TAPCELL_ROW_87_1_1192 VGND VPWR sky130_fd_sc_hd__tapvpwrvgnd_1
XFILLER_207_373 VPWR VGND VPWR VGND sky130_ef_sc_hd__decap_12
XFILLER_169_1593 VPWR VGND VPWR VGND sky130_ef_sc_hd__decap_12
XFILLER_165_1413 VPWR VGND VPWR VGND sky130_ef_sc_hd__decap_12
XFILLER_179_225 VPWR VGND VPWR VGND sky130_ef_sc_hd__decap_12
XFILLER_165_1457 VPWR VGND VPWR VGND sky130_ef_sc_hd__decap_12
XFILLER_206_1421 VGND VGND VPWR VPWR sky130_fd_sc_hd__decap_6
XFILLER_195_729 VPWR VGND VPWR VGND sky130_ef_sc_hd__decap_12
XFILLER_206_1465 VPWR VGND VPWR VGND sky130_ef_sc_hd__decap_12
XFILLER_188_781 VPWR VGND VPWR VGND sky130_ef_sc_hd__decap_12
XFILLER_147_111 VGND VGND VPWR VPWR sky130_fd_sc_hd__fill_1
XTAP_TAPCELL_ROW_48_2_3291 VGND VPWR sky130_fd_sc_hd__tapvpwrvgnd_1
XFILLER_202_1329 VPWR VGND VPWR VGND sky130_ef_sc_hd__decap_12
XFILLER_190_401 VPWR VGND VPWR VGND sky130_ef_sc_hd__decap_12
XFILLER_190_445 VPWR VGND VPWR VGND sky130_ef_sc_hd__decap_12
XFILLER_175_497 VGND VGND VPWR VPWR sky130_fd_sc_hd__decap_6
XFILLER_141_1490 VGND VGND VPWR VPWR sky130_fd_sc_hd__decap_6
XFILLER_118_27 VGND VGND VPWR VPWR sky130_fd_sc_hd__fill_1
XPHY_EDGE_ROW_32_1_Right_618 VGND VGND VPWR VPWR sky130_fd_sc_hd__decap_3
XFILLER_190_489 VPWR VGND VPWR VGND sky130_ef_sc_hd__decap_12
XFILLER_176_1553 VPWR VGND VPWR VGND sky130_ef_sc_hd__decap_12
XTAP_TAPCELL_ROW_41_2_3245 VGND VPWR sky130_fd_sc_hd__tapvpwrvgnd_1
XFILLER_176_1597 VGND VGND VPWR VPWR sky130_fd_sc_hd__decap_8
XFILLER_217_1561 VGND VGND VPWR VPWR sky130_fd_sc_hd__decap_6
XFILLER_134_15 VPWR VGND VPWR VGND sky130_ef_sc_hd__decap_12
XFILLER_213_1425 VPWR VGND VPWR VGND sky130_ef_sc_hd__decap_12
XFILLER_170_1141 VGND VGND VPWR VPWR sky130_fd_sc_hd__decap_6
XFILLER_135_1272 VGND VGND VPWR VPWR sky130_fd_sc_hd__fill_1
XFILLER_76_109 VPWR VGND VPWR VGND sky130_ef_sc_hd__decap_12
XFILLER_213_1469 VPWR VGND VPWR VGND sky130_ef_sc_hd__decap_12
XFILLER_170_1185 VPWR VGND VPWR VGND sky130_ef_sc_hd__decap_12
XFILLER_217_137 VPWR VGND VPWR VGND sky130_ef_sc_hd__decap_12
XTAP_TAPCELL_ROW_1_820 VGND VPWR sky130_fd_sc_hd__tapvpwrvgnd_1
XTAP_TAPCELL_ROW_1_831 VGND VPWR sky130_fd_sc_hd__tapvpwrvgnd_1
XFILLER_27_57 VGND VGND VPWR VPWR sky130_fd_sc_hd__decap_4
XFILLER_214_811 VGND VGND VPWR VPWR sky130_fd_sc_hd__fill_1
XFILLER_198_501 VPWR VGND VPWR VGND sky130_ef_sc_hd__decap_12
XFILLER_183_1513 VPWR VGND VPWR VGND sky130_ef_sc_hd__decap_12
XFILLER_198_545 VPWR VGND VPWR VGND sky130_ef_sc_hd__decap_12
XFILLER_201_505 VPWR VGND VPWR VGND sky130_ef_sc_hd__decap_12
XFILLER_198_589 VPWR VGND VPWR VGND sky130_ef_sc_hd__decap_12
XFILLER_185_217 VGND VGND VPWR VPWR sky130_fd_sc_hd__decap_6
XFILLER_181_1281 VGND VGND VPWR VPWR sky130_fd_sc_hd__decap_6
XFILLER_167_921 VPWR VGND VPWR VGND sky130_ef_sc_hd__decap_12
XFILLER_142_1232 VPWR VGND VPWR VGND sky130_ef_sc_hd__decap_12
XFILLER_107_1330 VPWR VGND VPWR VGND sky130_ef_sc_hd__decap_12
XFILLER_167_965 VPWR VGND VPWR VGND sky130_ef_sc_hd__decap_12
XFILLER_16_1246 VPWR VGND VPWR VGND sky130_ef_sc_hd__decap_12
XFILLER_216_3 VPWR VGND VPWR VGND sky130_ef_sc_hd__decap_12
XFILLER_193_261 VPWR VGND VPWR VGND sky130_ef_sc_hd__decap_12
XFILLER_166_475 VGND VGND VPWR VPWR sky130_fd_sc_hd__fill_1
XFILLER_153_125 VGND VGND VPWR VPWR sky130_fd_sc_hd__fill_2
XTAP_TAPCELL_ROW_137_2_3867 VGND VPWR sky130_fd_sc_hd__tapvpwrvgnd_1
XFILLER_5_625 VGND VGND VPWR VPWR sky130_fd_sc_hd__fill_1
XFILLER_5_636 VGND VGND VPWR VPWR sky130_fd_sc_hd__fill_1
XTAP_TAPCELL_ROW_31_1_1079 VGND VPWR sky130_fd_sc_hd__tapvpwrvgnd_1
XFILLER_182_979 VGND VGND VPWR VPWR sky130_fd_sc_hd__fill_1
XFILLER_175_55 VGND VGND VPWR VPWR sky130_fd_sc_hd__fill_1
XFILLER_120_1574 VGND VGND VPWR VPWR sky130_fd_sc_hd__decap_6
XFILLER_4_135 VGND VGND VPWR VPWR sky130_fd_sc_hd__decap_3
XFILLER_175_1063 VGND VGND VPWR VPWR sky130_fd_sc_hd__fill_1
XFILLER_190_1539 VGND VGND VPWR VPWR sky130_fd_sc_hd__fill_1
XFILLER_68_53 VPWR VGND VPWR VGND sky130_ef_sc_hd__decap_12
XFILLER_1_831 VGND VGND VPWR VPWR sky130_fd_sc_hd__decap_8
XFILLER_118_1470 VPWR VGND VPWR VGND sky130_ef_sc_hd__decap_12
XFILLER_0_341 VGND VGND VPWR VPWR sky130_fd_sc_hd__fill_2
XFILLER_7_1425 VGND VGND VPWR VPWR sky130_fd_sc_hd__decap_3
XFILLER_27_1342 VPWR VGND VPWR VGND sky130_ef_sc_hd__decap_12
XFILLER_62_1244 VGND VGND VPWR VPWR sky130_fd_sc_hd__fill_1
XFILLER_216_1093 VPWR VGND VPWR VGND sky130_ef_sc_hd__decap_12
XFILLER_114_1356 VGND VGND VPWR VPWR sky130_fd_sc_hd__fill_1
XTAP_TAPCELL_ROW_85_2_3532 VGND VPWR sky130_fd_sc_hd__tapvpwrvgnd_1
XFILLER_68_97 VPWR VGND VPWR VGND sky130_ef_sc_hd__decap_12
XFILLER_0_374 VGND VGND VPWR VPWR sky130_fd_sc_hd__decap_4
XFILLER_0_396 VGND VGND VPWR VPWR sky130_fd_sc_hd__fill_1
XFILLER_7_1469 VPWR VGND VPWR VGND sky130_ef_sc_hd__decap_12
XFILLER_27_1386 VPWR VGND VPWR VGND sky130_ef_sc_hd__decap_12
XFILLER_84_41 VPWR VGND VPWR VGND sky130_ef_sc_hd__decap_12
XFILLER_217_671 VGND VGND VPWR VPWR sky130_fd_sc_hd__fill_1
XFILLER_205_833 VGND VGND VPWR VPWR sky130_fd_sc_hd__decap_6
XFILLER_84_85 VPWR VGND VPWR VGND sky130_ef_sc_hd__decap_12
XFILLER_1_1057 VGND VGND VPWR VPWR sky130_fd_sc_hd__decap_6
XFILLER_205_877 VPWR VGND VPWR VGND sky130_ef_sc_hd__decap_12
XFILLER_204_321 VPWR VGND VPWR VGND sky130_ef_sc_hd__decap_12
X_587_ clknet_3_2_0_clk _021_ VGND VGND VPWR VPWR b_addr\[3\] sky130_fd_sc_hd__dfxtp_2
XFILLER_204_365 VPWR VGND VPWR VGND sky130_ef_sc_hd__decap_12
XFILLER_177_729 VPWR VGND VPWR VGND sky130_ef_sc_hd__decap_12
XPHY_EDGE_ROW_75_2_Right_132 VGND VGND VPWR VPWR sky130_fd_sc_hd__decap_3
XFILLER_34_1302 VPWR VGND VPWR VGND sky130_ef_sc_hd__decap_12
XFILLER_38_1482 VPWR VGND VPWR VGND sky130_ef_sc_hd__decap_12
XFILLER_219_15 VPWR VGND VPWR VGND sky130_ef_sc_hd__decap_12
XFILLER_129_111 VGND VGND VPWR VPWR sky130_fd_sc_hd__fill_1
XFILLER_73_1384 VGND VGND VPWR VPWR sky130_fd_sc_hd__fill_1
XFILLER_172_401 VPWR VGND VPWR VGND sky130_ef_sc_hd__decap_12
XFILLER_125_1496 VGND VGND VPWR VPWR sky130_fd_sc_hd__fill_1
XFILLER_172_445 VPWR VGND VPWR VGND sky130_ef_sc_hd__decap_12
XPHY_EDGE_ROW_20_2_Right_77 VGND VGND VPWR VPWR sky130_fd_sc_hd__decap_3
XTAP_TAPCELL_ROW_26_2_3147 VGND VPWR sky130_fd_sc_hd__tapvpwrvgnd_1
XFILLER_172_489 VPWR VGND VPWR VGND sky130_ef_sc_hd__decap_12
XFILLER_158_1294 VGND VGND VPWR VPWR sky130_fd_sc_hd__decap_6
XFILLER_119_1256 VPWR VGND VPWR VGND sky130_ef_sc_hd__decap_12
XFILLER_80_1300 VGND VGND VPWR VPWR sky130_fd_sc_hd__fill_1
XFILLER_4_691 VGND VGND VPWR VPWR sky130_fd_sc_hd__decap_6
XFILLER_132_1412 VGND VGND VPWR VPWR sky130_fd_sc_hd__fill_1
XFILLER_45_1442 VPWR VGND VPWR VGND sky130_ef_sc_hd__decap_12
XFILLER_58_109 VPWR VGND VPWR VGND sky130_ef_sc_hd__decap_12
XFILLER_41_1328 VGND VGND VPWR VPWR sky130_fd_sc_hd__fill_1
XFILLER_104_29 VPWR VGND VPWR VGND sky130_ef_sc_hd__decap_12
XFILLER_208_693 VGND VGND VPWR VPWR sky130_fd_sc_hd__decap_6
XFILLER_207_181 VPWR VGND VPWR VGND sky130_ef_sc_hd__decap_12
XPHY_EDGE_ROW_85_2_Left_517 VGND VGND VPWR VPWR sky130_fd_sc_hd__decap_3
XANTENNA_fanout156_A net157 VGND VGND VPWR VPWR sky130_fd_sc_hd__diode_2
XFILLER_39_1268 VGND VGND VPWR VPWR sky130_fd_sc_hd__decap_4
XFILLER_167_217 VGND VGND VPWR VPWR sky130_fd_sc_hd__decap_6
XFILLER_165_1287 VGND VGND VPWR VPWR sky130_fd_sc_hd__fill_1
XFILLER_91_1440 VGND VGND VPWR VPWR sky130_fd_sc_hd__fill_1
XFILLER_13_15 VPWR VGND VPWR VGND sky130_ef_sc_hd__decap_12
XFILLER_17_1522 VPWR VGND VPWR VGND sky130_ef_sc_hd__decap_12
XFILLER_56_1582 VPWR VGND VPWR VGND sky130_ef_sc_hd__decap_12
XFILLER_210_357 VGND VGND VPWR VPWR sky130_fd_sc_hd__decap_6
XFILLER_206_1273 VPWR VGND VPWR VGND sky130_ef_sc_hd__decap_12
XFILLER_200_83 VGND VGND VPWR VPWR sky130_fd_sc_hd__fill_1
XFILLER_195_559 VGND VGND VPWR VPWR sky130_fd_sc_hd__fill_1
XFILLER_143_1552 VGND VGND VPWR VPWR sky130_fd_sc_hd__fill_1
XFILLER_129_15 VPWR VGND VPWR VGND sky130_ef_sc_hd__decap_12
XFILLER_17_1566 VPWR VGND VPWR VGND sky130_ef_sc_hd__decap_12
XFILLER_182_209 VPWR VGND VPWR VGND sky130_ef_sc_hd__decap_12
XFILLER_175_261 VPWR VGND VPWR VGND sky130_ef_sc_hd__decap_12
XTAP_TAPCELL_ROW_123_2_3775 VGND VPWR sky130_fd_sc_hd__tapvpwrvgnd_1
XFILLER_52_1468 VGND VGND VPWR VPWR sky130_fd_sc_hd__fill_1
XFILLER_191_721 VGND VGND VPWR VPWR sky130_fd_sc_hd__decap_6
XFILLER_163_445 VGND VGND VPWR VPWR sky130_fd_sc_hd__decap_3
XFILLER_135_125 VGND VGND VPWR VPWR sky130_fd_sc_hd__fill_2
XANTENNA__362__A b_addr\[3\] VGND VGND VPWR VPWR sky130_fd_sc_hd__diode_2
XFILLER_209_81 VPWR VGND VPWR VGND sky130_ef_sc_hd__decap_12
XFILLER_198_1085 VGND VGND VPWR VPWR sky130_fd_sc_hd__decap_6
XFILLER_191_765 VPWR VGND VPWR VGND sky130_ef_sc_hd__decap_12
XFILLER_190_253 VPWR VGND VPWR VGND sky130_ef_sc_hd__decap_12
XFILLER_164_979 VGND VGND VPWR VPWR sky130_fd_sc_hd__fill_1
XFILLER_102_1282 VPWR VGND VPWR VGND sky130_ef_sc_hd__decap_12
XPHY_EDGE_ROW_33_1_Right_619 VGND VGND VPWR VPWR sky130_fd_sc_hd__decap_3
XFILLER_172_1203 VGND VGND VPWR VPWR sky130_fd_sc_hd__fill_1
XFILLER_163_489 VPWR VGND VPWR VGND sky130_ef_sc_hd__decap_12
XFILLER_85_1244 VPWR VGND VPWR VGND sky130_ef_sc_hd__decap_12
XFILLER_1_105 VGND VGND VPWR VPWR sky130_fd_sc_hd__decap_6
XFILLER_145_69 VPWR VGND VPWR VGND sky130_ef_sc_hd__decap_12
XFILLER_137_1378 VGND VGND VPWR VPWR sky130_fd_sc_hd__decap_6
XTAP_TAPCELL_ROW_71_2_3440 VGND VPWR sky130_fd_sc_hd__tapvpwrvgnd_1
XFILLER_219_925 VPWR VGND VPWR VGND sky130_ef_sc_hd__decap_12
XFILLER_213_1233 VPWR VGND VPWR VGND sky130_ef_sc_hd__decap_12
XTAP_TAPCELL_ROW_6_956 VGND VPWR sky130_fd_sc_hd__tapvpwrvgnd_1
XTAP_TAPCELL_ROW_6_967 VGND VPWR sky130_fd_sc_hd__tapvpwrvgnd_1
XFILLER_24_1526 VPWR VGND VPWR VGND sky130_ef_sc_hd__decap_12
XFILLER_218_413 VGND VGND VPWR VPWR sky130_fd_sc_hd__decap_6
XFILLER_218_457 VPWR VGND VPWR VGND sky130_ef_sc_hd__decap_12
XFILLER_161_57 VPWR VGND VPWR VGND sky130_ef_sc_hd__decap_12
X_510_ net61 net121 VGND VGND VPWR VPWR _229_ sky130_fd_sc_hd__or2_1
XFILLER_166_1029 VGND VGND VPWR VPWR sky130_fd_sc_hd__decap_6
XFILLER_22_1294 VGND VGND VPWR VPWR sky130_fd_sc_hd__decap_6
XFILLER_199_821 VPWR VGND VPWR VGND sky130_ef_sc_hd__decap_12
XTAP_TAPCELL_ROW_181_1893 VGND VPWR sky130_fd_sc_hd__tapvpwrvgnd_1
XFILLER_166_3 VPWR VGND VPWR VGND sky130_ef_sc_hd__decap_12
X_441_ net146 net93 VGND VGND VPWR VPWR _173_ sky130_fd_sc_hd__xor2_1
XFILLER_202_825 VPWR VGND VPWR VGND sky130_ef_sc_hd__decap_12
XFILLER_199_865 VPWR VGND VPWR VGND sky130_ef_sc_hd__decap_12
XFILLER_183_1343 VGND VGND VPWR VPWR sky130_fd_sc_hd__fill_1
X_372_ net155 _113_ VGND VGND VPWR VPWR _016_ sky130_fd_sc_hd__and2_1
XFILLER_54_77 VGND VGND VPWR VPWR sky130_fd_sc_hd__decap_6
XFILLER_202_869 VPWR VGND VPWR VGND sky130_ef_sc_hd__decap_12
XFILLER_201_335 VGND VGND VPWR VPWR sky130_fd_sc_hd__fill_1
XFILLER_144_1338 VPWR VGND VPWR VGND sky130_ef_sc_hd__decap_12
XFILLER_110_83 VGND VGND VPWR VPWR sky130_fd_sc_hd__fill_1
XFILLER_70_1524 VGND VGND VPWR VPWR sky130_fd_sc_hd__fill_1
XFILLER_70_65 VPWR VGND VPWR VGND sky130_ef_sc_hd__decap_12
XFILLER_194_581 VGND VGND VPWR VPWR sky130_fd_sc_hd__decap_6
XFILLER_186_65 VPWR VGND VPWR VGND sky130_ef_sc_hd__decap_12
XFILLER_5_400 VGND VGND VPWR VPWR sky130_fd_sc_hd__decap_8
XFILLER_6_923 VGND VGND VPWR VPWR sky130_fd_sc_hd__fill_1
XTAP_TAPCELL_ROW_12_2_3055 VGND VPWR sky130_fd_sc_hd__tapvpwrvgnd_1
XFILLER_170_905 VPWR VGND VPWR VGND sky130_ef_sc_hd__decap_12
XFILLER_119_81 VPWR VGND VPWR VGND sky130_ef_sc_hd__decap_12
XFILLER_177_1169 VGND VGND VPWR VPWR sky130_fd_sc_hd__decap_6
XFILLER_170_949 VPWR VGND VPWR VGND sky130_ef_sc_hd__decap_12
XFILLER_120_1382 VPWR VGND VPWR VGND sky130_ef_sc_hd__decap_12
XANTENNA__312__A2 net144 VGND VGND VPWR VPWR sky130_fd_sc_hd__diode_2
XFILLER_194_1483 VGND VGND VPWR VPWR sky130_fd_sc_hd__fill_1
XFILLER_155_1434 VGND VGND VPWR VPWR sky130_fd_sc_hd__decap_6
XPHY_EDGE_ROW_51_1_Left_270 VGND VGND VPWR VPWR sky130_fd_sc_hd__decap_3
XFILLER_155_1478 VPWR VGND VPWR VGND sky130_ef_sc_hd__decap_12
XFILLER_205_39 VPWR VGND VPWR VGND sky130_ef_sc_hd__decap_12
XTAP_TAPCELL_ROW_162_2_4033 VGND VPWR sky130_fd_sc_hd__tapvpwrvgnd_1
XFILLER_7_1233 VPWR VGND VPWR VGND sky130_ef_sc_hd__decap_12
XFILLER_95_51 VGND VGND VPWR VPWR sky130_fd_sc_hd__decap_4
XFILLER_3_1119 VGND VGND VPWR VPWR sky130_fd_sc_hd__fill_1
XFILLER_40_1350 VGND VGND VPWR VPWR sky130_fd_sc_hd__decap_6
XFILLER_40_1394 VPWR VGND VPWR VGND sky130_ef_sc_hd__decap_12
XFILLER_205_641 VPWR VGND VPWR VGND sky130_ef_sc_hd__decap_12
XFILLER_184_1129 VPWR VGND VPWR VGND sky130_ef_sc_hd__decap_12
XFILLER_166_1541 VPWR VGND VPWR VGND sky130_ef_sc_hd__decap_12
XANTENNA__447__A net147 VGND VGND VPWR VPWR sky130_fd_sc_hd__diode_2
XFILLER_205_685 VPWR VGND VPWR VGND sky130_ef_sc_hd__decap_12
XFILLER_204_195 VGND VGND VPWR VPWR sky130_fd_sc_hd__fill_1
XFILLER_162_1438 VPWR VGND VPWR VGND sky130_ef_sc_hd__decap_12
XFILLER_207_1593 VPWR VGND VPWR VGND sky130_ef_sc_hd__decap_12
XFILLER_203_1413 VPWR VGND VPWR VGND sky130_ef_sc_hd__decap_12
XFILLER_177_559 VGND VGND VPWR VPWR sky130_fd_sc_hd__fill_1
XFILLER_81_3 VPWR VGND VPWR VGND sky130_ef_sc_hd__decap_12
XPHY_EDGE_ROW_76_2_Right_133 VGND VGND VPWR VPWR sky130_fd_sc_hd__decap_3
XFILLER_203_1457 VPWR VGND VPWR VGND sky130_ef_sc_hd__decap_12
XFILLER_164_209 VPWR VGND VPWR VGND sky130_ef_sc_hd__decap_12
XTAP_TAPCELL_ROW_108_2_3677 VGND VPWR sky130_fd_sc_hd__tapvpwrvgnd_1
XFILLER_173_721 VGND VGND VPWR VPWR sky130_fd_sc_hd__decap_6
XFILLER_117_125 VGND VGND VPWR VPWR sky130_fd_sc_hd__fill_2
XFILLER_195_1225 VGND VGND VPWR VPWR sky130_fd_sc_hd__decap_6
XFILLER_173_765 VPWR VGND VPWR VGND sky130_ef_sc_hd__decap_12
XFILLER_172_253 VPWR VGND VPWR VGND sky130_ef_sc_hd__decap_12
XPHY_EDGE_ROW_160_1_Right_746 VGND VGND VPWR VPWR sky130_fd_sc_hd__decap_3
XFILLER_51_1490 VGND VGND VPWR VPWR sky130_fd_sc_hd__decap_6
XTAP_TAPCELL_ROW_212_2771 VGND VPWR sky130_fd_sc_hd__tapvpwrvgnd_1
XFILLER_195_1269 VPWR VGND VPWR VGND sky130_ef_sc_hd__decap_12
XTAP_TAPCELL_ROW_212_2793 VGND VPWR sky130_fd_sc_hd__tapvpwrvgnd_1
XTAP_TAPCELL_ROW_212_2782 VGND VPWR sky130_fd_sc_hd__tapvpwrvgnd_1
XFILLER_82_1406 VGND VGND VPWR VPWR sky130_fd_sc_hd__decap_6
XTAP_TAPCELL_ROW_56_2_3342 VGND VPWR sky130_fd_sc_hd__tapvpwrvgnd_1
XFILLER_173_1567 VGND VGND VPWR VPWR sky130_fd_sc_hd__fill_1
XFILLER_134_1518 VGND VGND VPWR VPWR sky130_fd_sc_hd__decap_6
XFILLER_214_1553 VPWR VGND VPWR VGND sky130_ef_sc_hd__decap_12
XFILLER_132_1220 VPWR VGND VPWR VGND sky130_ef_sc_hd__decap_12
XFILLER_115_39 VPWR VGND VPWR VGND sky130_ef_sc_hd__decap_12
XFILLER_45_1272 VGND VGND VPWR VPWR sky130_fd_sc_hd__fill_1
XFILLER_189_1007 VGND VGND VPWR VPWR sky130_fd_sc_hd__fill_1
XFILLER_216_917 VGND VGND VPWR VPWR sky130_fd_sc_hd__decap_6
XFILLER_214_1597 VGND VGND VPWR VPWR sky130_fd_sc_hd__decap_8
XFILLER_215_405 VPWR VGND VPWR VGND sky130_ef_sc_hd__decap_12
XTAP_TAPCELL_ROW_206_2597 VGND VPWR sky130_fd_sc_hd__tapvpwrvgnd_1
XFILLER_131_27 VPWR VGND VPWR VGND sky130_ef_sc_hd__decap_12
XFILLER_215_449 VPWR VGND VPWR VGND sky130_ef_sc_hd__decap_12
XFILLER_110_1562 VPWR VGND VPWR VGND sky130_ef_sc_hd__decap_12
XTAP_TAPCELL_ROW_198_2387 VGND VPWR sky130_fd_sc_hd__tapvpwrvgnd_1
XTAP_TAPCELL_ROW_198_2376 VGND VPWR sky130_fd_sc_hd__tapvpwrvgnd_1
XFILLER_93_1546 VGND VGND VPWR VPWR sky130_fd_sc_hd__decap_6
XFILLER_211_93 VPWR VGND VPWR VGND sky130_ef_sc_hd__decap_12
XFILLER_210_121 VPWR VGND VPWR VGND sky130_ef_sc_hd__decap_12
XFILLER_196_813 VPWR VGND VPWR VGND sky130_ef_sc_hd__decap_12
XFILLER_24_47 VGND VGND VPWR VPWR sky130_fd_sc_hd__decap_8
XTAP_TAPCELL_ROW_219_2969 VGND VPWR sky130_fd_sc_hd__tapvpwrvgnd_1
XFILLER_104_1300 VGND VGND VPWR VPWR sky130_fd_sc_hd__fill_1
XFILLER_17_1330 VPWR VGND VPWR VGND sky130_ef_sc_hd__decap_12
XFILLER_24_69 VGND VGND VPWR VPWR sky130_fd_sc_hd__fill_1
XFILLER_52_1232 VPWR VGND VPWR VGND sky130_ef_sc_hd__decap_12
XFILLER_210_165 VPWR VGND VPWR VGND sky130_ef_sc_hd__decap_12
XFILLER_183_529 VPWR VGND VPWR VGND sky130_ef_sc_hd__decap_12
XFILLER_176_581 VGND VGND VPWR VPWR sky130_fd_sc_hd__decap_6
XTAP_TAPCELL_ROW_46_1_1110 VGND VPWR sky130_fd_sc_hd__tapvpwrvgnd_1
XFILLER_163_253 VPWR VGND VPWR VGND sky130_ef_sc_hd__decap_12
XFILLER_87_1328 VGND VGND VPWR VPWR sky130_fd_sc_hd__fill_1
XFILLER_191_573 VPWR VGND VPWR VGND sky130_ef_sc_hd__decap_12
XFILLER_174_1309 VGND VGND VPWR VPWR sky130_fd_sc_hd__decap_6
XTAP_TAPCELL_ROW_153_2_3970 VGND VPWR sky130_fd_sc_hd__tapvpwrvgnd_1
XFILLER_30_1574 VGND VGND VPWR VPWR sky130_fd_sc_hd__decap_6
XFILLER_219_1453 VGND VGND VPWR VPWR sky130_fd_sc_hd__decap_3
XTAP_TAPCELL_ROW_170_1594 VGND VPWR sky130_fd_sc_hd__tapvpwrvgnd_1
XTAP_TAPCELL_ROW_170_1583 VGND VPWR sky130_fd_sc_hd__tapvpwrvgnd_1
XTAP_TAPCELL_ROW_170_1572 VGND VPWR sky130_fd_sc_hd__tapvpwrvgnd_1
XFILLER_219_1497 VPWR VGND VPWR VGND sky130_ef_sc_hd__decap_12
XFILLER_2_469 VGND VGND VPWR VPWR sky130_fd_sc_hd__decap_6
XFILLER_49_44 VPWR VGND VPWR VGND sky130_ef_sc_hd__decap_12
XFILLER_28_1470 VPWR VGND VPWR VGND sky130_ef_sc_hd__decap_12
XFILLER_218_221 VPWR VGND VPWR VGND sky130_ef_sc_hd__decap_12
XFILLER_213_1063 VGND VGND VPWR VPWR sky130_fd_sc_hd__fill_1
XFILLER_115_1440 VGND VGND VPWR VPWR sky130_fd_sc_hd__fill_1
XTAP_TAPCELL_ROW_183_1966 VGND VPWR sky130_fd_sc_hd__tapvpwrvgnd_1
XTAP_TAPCELL_ROW_183_1955 VGND VPWR sky130_fd_sc_hd__tapvpwrvgnd_1
XTAP_TAPCELL_ROW_183_1944 VGND VPWR sky130_fd_sc_hd__tapvpwrvgnd_1
XTAP_TAPCELL_ROW_145_2_3918 VGND VPWR sky130_fd_sc_hd__tapvpwrvgnd_1
XFILLER_24_1356 VGND VGND VPWR VPWR sky130_fd_sc_hd__fill_1
XFILLER_218_265 VPWR VGND VPWR VGND sky130_ef_sc_hd__decap_12
XFILLER_98_1468 VGND VGND VPWR VPWR sky130_fd_sc_hd__fill_1
XFILLER_2_1141 VGND VGND VPWR VPWR sky130_fd_sc_hd__decap_6
XFILLER_185_1449 VGND VGND VPWR VPWR sky130_fd_sc_hd__decap_6
XFILLER_2_1185 VPWR VGND VPWR VGND sky130_ef_sc_hd__decap_12
X_424_ b_addr\[6\] _104_ VGND VGND VPWR VPWR _158_ sky130_fd_sc_hd__nor2_1
XFILLER_199_673 VPWR VGND VPWR VGND sky130_ef_sc_hd__decap_12
XFILLER_186_301 VGND VGND VPWR VPWR sky130_fd_sc_hd__decap_6
XFILLER_148_1282 VPWR VGND VPWR VGND sky130_ef_sc_hd__decap_12
XFILLER_121_93 VPWR VGND VPWR VGND sky130_ef_sc_hd__decap_12
XFILLER_109_1244 VPWR VGND VPWR VGND sky130_ef_sc_hd__decap_12
XFILLER_186_345 VPWR VGND VPWR VGND sky130_ef_sc_hd__decap_12
X_355_ net152 _081_ _098_ _076_ VGND VGND VPWR VPWR _099_ sky130_fd_sc_hd__a22o_1
XFILLER_202_699 VGND VGND VPWR VPWR sky130_fd_sc_hd__fill_1
XFILLER_186_389 VPWR VGND VPWR VGND sky130_ef_sc_hd__decap_12
XFILLER_126_1580 VGND VGND VPWR VPWR sky130_fd_sc_hd__fill_1
X_286_ _073_ net2 net155 VGND VGND VPWR VPWR _001_ sky130_fd_sc_hd__o21ai_1
XFILLER_35_1496 VGND VGND VPWR VPWR sky130_fd_sc_hd__fill_1
XFILLER_196_1589 VGND VGND VPWR VPWR sky130_fd_sc_hd__decap_6
XFILLER_192_1409 VPWR VGND VPWR VGND sky130_ef_sc_hd__decap_12
XFILLER_170_713 VPWR VGND VPWR VGND sky130_ef_sc_hd__decap_12
XTAP_TAPCELL_ROW_42_2_3250 VGND VPWR sky130_fd_sc_hd__tapvpwrvgnd_1
XFILLER_216_27 VGND VGND VPWR VPWR sky130_fd_sc_hd__fill_1
XFILLER_170_757 VPWR VGND VPWR VGND sky130_ef_sc_hd__decap_12
XFILLER_155_1220 VPWR VGND VPWR VGND sky130_ef_sc_hd__decap_12
XFILLER_68_1294 VGND VGND VPWR VPWR sky130_fd_sc_hd__decap_6
XFILLER_9_1328 VGND VGND VPWR VPWR sky130_fd_sc_hd__fill_1
XFILLER_29_1256 VPWR VGND VPWR VGND sky130_ef_sc_hd__decap_12
XFILLER_155_1286 VPWR VGND VPWR VGND sky130_ef_sc_hd__decap_12
XFILLER_2_981 VPWR VGND VPWR VGND sky130_ef_sc_hd__decap_12
XFILLER_42_1412 VGND VGND VPWR VPWR sky130_fd_sc_hd__fill_1
XFILLER_7_1063 VGND VGND VPWR VPWR sky130_fd_sc_hd__fill_1
Xinput6 func_addr[3] VGND VGND VPWR VPWR net6 sky130_fd_sc_hd__clkbuf_1
XFILLER_213_909 VPWR VGND VPWR VGND sky130_ef_sc_hd__decap_12
XFILLER_188_1073 VPWR VGND VPWR VGND sky130_ef_sc_hd__decap_12
XFILLER_212_419 VGND VGND VPWR VPWR sky130_fd_sc_hd__fill_1
XFILLER_206_961 VPWR VGND VPWR VGND sky130_ef_sc_hd__decap_12
XFILLER_75_1232 VPWR VGND VPWR VGND sky130_ef_sc_hd__decap_12
XTAP_TAPCELL_ROW_201_2472 VGND VPWR sky130_fd_sc_hd__tapvpwrvgnd_1
XTAP_TAPCELL_ROW_201_2461 VGND VPWR sky130_fd_sc_hd__tapvpwrvgnd_1
XFILLER_196_109 VPWR VGND VPWR VGND sky130_ef_sc_hd__decap_12
XFILLER_189_161 VGND VGND VPWR VPWR sky130_fd_sc_hd__decap_6
XFILLER_178_813 VPWR VGND VPWR VGND sky130_ef_sc_hd__decap_12
XFILLER_166_1371 VGND VGND VPWR VPWR sky130_fd_sc_hd__fill_1
XFILLER_127_1322 VGND VGND VPWR VPWR sky130_fd_sc_hd__decap_6
XTAP_TAPCELL_ROW_193_2240 VGND VPWR sky130_fd_sc_hd__tapvpwrvgnd_1
XFILLER_162_1246 VPWR VGND VPWR VGND sky130_ef_sc_hd__decap_12
XFILLER_127_1366 VPWR VGND VPWR VGND sky130_ef_sc_hd__decap_12
XFILLER_75_1298 VPWR VGND VPWR VGND sky130_ef_sc_hd__decap_12
XTAP_TAPCELL_ROW_193_2251 VGND VPWR sky130_fd_sc_hd__tapvpwrvgnd_1
XFILLER_165_529 VPWR VGND VPWR VGND sky130_ef_sc_hd__decap_12
XPHY_EDGE_ROW_77_2_Right_134 VGND VGND VPWR VPWR sky130_fd_sc_hd__decap_3
XFILLER_53_1552 VGND VGND VPWR VPWR sky130_fd_sc_hd__fill_1
XTAP_TAPCELL_ROW_214_2844 VGND VPWR sky130_fd_sc_hd__tapvpwrvgnd_1
XTAP_TAPCELL_ROW_214_2833 VGND VPWR sky130_fd_sc_hd__tapvpwrvgnd_1
XFILLER_203_1287 VGND VGND VPWR VPWR sky130_fd_sc_hd__fill_1
XTAP_TAPCELL_ROW_138_2_3872 VGND VPWR sky130_fd_sc_hd__tapvpwrvgnd_1
XTAP_TAPCELL_ROW_210_2719 VGND VPWR sky130_fd_sc_hd__tapvpwrvgnd_1
XFILLER_195_1033 VPWR VGND VPWR VGND sky130_ef_sc_hd__decap_12
XFILLER_173_573 VPWR VGND VPWR VGND sky130_ef_sc_hd__decap_12
XPHY_EDGE_ROW_161_1_Right_747 VGND VGND VPWR VPWR sky130_fd_sc_hd__decap_3
XFILLER_10_27 VGND VGND VPWR VPWR sky130_fd_sc_hd__fill_1
XFILLER_12_1282 VPWR VGND VPWR VGND sky130_ef_sc_hd__decap_12
XFILLER_195_1077 VPWR VGND VPWR VGND sky130_ef_sc_hd__decap_12
XFILLER_126_27 VGND VGND VPWR VPWR sky130_fd_sc_hd__fill_1
XFILLER_86_1350 VGND VGND VPWR VPWR sky130_fd_sc_hd__decap_6
XTAP_TAPCELL_ROW_187_2066 VGND VPWR sky130_fd_sc_hd__tapvpwrvgnd_1
XFILLER_138_1462 VGND VGND VPWR VPWR sky130_fd_sc_hd__decap_6
XFILLER_120_109 VPWR VGND VPWR VGND sky130_ef_sc_hd__decap_12
XFILLER_86_1394 VPWR VGND VPWR VGND sky130_ef_sc_hd__decap_12
XFILLER_0_929 VGND VGND VPWR VPWR sky130_fd_sc_hd__fill_2
XFILLER_0_907 VGND VGND VPWR VPWR sky130_fd_sc_hd__fill_1
XTAP_TAPCELL_ROW_187_2077 VGND VPWR sky130_fd_sc_hd__tapvpwrvgnd_1
XFILLER_134_1326 VPWR VGND VPWR VGND sky130_ef_sc_hd__decap_12
XFILLER_82_1258 VPWR VGND VPWR VGND sky130_ef_sc_hd__decap_12
XFILLER_47_1378 VGND VGND VPWR VPWR sky130_fd_sc_hd__decap_6
XFILLER_142_15 VPWR VGND VPWR VGND sky130_ef_sc_hd__decap_12
XFILLER_112_1602 VGND VGND VPWR VPWR sky130_fd_sc_hd__decap_3
XFILLER_210_1203 VGND VGND VPWR VPWR sky130_fd_sc_hd__fill_1
XTAP_TAPCELL_ROW_208_2659 VGND VPWR sky130_fd_sc_hd__tapvpwrvgnd_1
XFILLER_19_69 VPWR VGND VPWR VGND sky130_ef_sc_hd__decap_12
XFILLER_216_725 VPWR VGND VPWR VGND sky130_ef_sc_hd__decap_12
XPHY_EDGE_ROW_29_2_Left_461 VGND VGND VPWR VPWR sky130_fd_sc_hd__decap_3
XFILLER_216_769 VPWR VGND VPWR VGND sky130_ef_sc_hd__decap_12
XFILLER_167_1113 VGND VGND VPWR VPWR sky130_fd_sc_hd__decap_6
XTAP_TAPCELL_ROW_111_2_3702 VGND VPWR sky130_fd_sc_hd__tapvpwrvgnd_1
XFILLER_215_279 VGND VGND VPWR VPWR sky130_fd_sc_hd__fill_1
XFILLER_167_1157 VPWR VGND VPWR VGND sky130_ef_sc_hd__decap_12
XFILLER_110_1370 VPWR VGND VPWR VGND sky130_ef_sc_hd__decap_12
XFILLER_97_1490 VGND VGND VPWR VPWR sky130_fd_sc_hd__decap_6
XFILLER_93_1310 VPWR VGND VPWR VGND sky130_ef_sc_hd__decap_12
XFILLER_35_57 VPWR VGND VPWR VGND sky130_ef_sc_hd__decap_12
XFILLER_168_301 VGND VGND VPWR VPWR sky130_fd_sc_hd__decap_6
XFILLER_145_1422 VPWR VGND VPWR VGND sky130_ef_sc_hd__decap_12
XFILLER_93_1354 VPWR VGND VPWR VGND sky130_ef_sc_hd__decap_12
XFILLER_211_441 VGND VGND VPWR VPWR sky130_fd_sc_hd__decap_6
XFILLER_196_643 VGND VGND VPWR VPWR sky130_fd_sc_hd__fill_1
XFILLER_168_345 VPWR VGND VPWR VGND sky130_ef_sc_hd__decap_12
XFILLER_145_1466 VPWR VGND VPWR VGND sky130_ef_sc_hd__decap_12
XFILLER_106_1406 VGND VGND VPWR VPWR sky130_fd_sc_hd__decap_6
XFILLER_93_1398 VPWR VGND VPWR VGND sky130_ef_sc_hd__decap_12
XANTENNA__605__CLK clknet_3_3_0_clk VGND VGND VPWR VPWR sky130_fd_sc_hd__diode_2
XFILLER_54_1338 VPWR VGND VPWR VGND sky130_ef_sc_hd__decap_12
XFILLER_211_485 VPWR VGND VPWR VGND sky130_ef_sc_hd__decap_12
XFILLER_204_1029 VGND VGND VPWR VPWR sky130_fd_sc_hd__decap_6
XFILLER_184_805 VGND VGND VPWR VPWR sky130_fd_sc_hd__decap_6
XFILLER_184_849 VPWR VGND VPWR VGND sky130_ef_sc_hd__decap_12
XFILLER_183_337 VPWR VGND VPWR VGND sky130_ef_sc_hd__decap_12
XTAP_TAPCELL_ROW_176_1770 VGND VPWR sky130_fd_sc_hd__tapvpwrvgnd_1
XFILLER_168_389 VPWR VGND VPWR VGND sky130_ef_sc_hd__decap_12
XFILLER_129_3 VPWR VGND VPWR VGND sky130_ef_sc_hd__decap_12
XTAP_TAPCELL_ROW_172_1656 VGND VPWR sky130_fd_sc_hd__tapvpwrvgnd_1
XTAP_TAPCELL_ROW_172_1645 VGND VPWR sky130_fd_sc_hd__tapvpwrvgnd_1
XTAP_TAPCELL_ROW_172_1634 VGND VPWR sky130_fd_sc_hd__tapvpwrvgnd_1
XFILLER_192_893 VPWR VGND VPWR VGND sky130_ef_sc_hd__decap_12
XFILLER_178_1253 VGND VGND VPWR VPWR sky130_fd_sc_hd__decap_6
XTAP_TAPCELL_ROW_27_2_3152 VGND VPWR sky130_fd_sc_hd__tapvpwrvgnd_1
XFILLER_178_1297 VPWR VGND VPWR VGND sky130_ef_sc_hd__decap_12
XFILLER_174_1117 VPWR VGND VPWR VGND sky130_ef_sc_hd__decap_12
XFILLER_30_1382 VPWR VGND VPWR VGND sky130_ef_sc_hd__decap_12
XFILLER_219_1261 VPWR VGND VPWR VGND sky130_ef_sc_hd__decap_12
XFILLER_183_55 VGND VGND VPWR VPWR sky130_fd_sc_hd__fill_1
XFILLER_156_1562 VPWR VGND VPWR VGND sky130_ef_sc_hd__decap_12
XFILLER_65_1434 VGND VGND VPWR VPWR sky130_fd_sc_hd__decap_6
XFILLER_152_1426 VPWR VGND VPWR VGND sky130_ef_sc_hd__decap_12
XFILLER_117_1546 VGND VGND VPWR VPWR sky130_fd_sc_hd__decap_6
XFILLER_65_1478 VPWR VGND VPWR VGND sky130_ef_sc_hd__decap_12
XFILLER_215_1169 VGND VGND VPWR VPWR sky130_fd_sc_hd__decap_6
XFILLER_8_1350 VGND VGND VPWR VPWR sky130_fd_sc_hd__decap_6
XTAP_TAPCELL_ROW_20_2_3106 VGND VPWR sky130_fd_sc_hd__tapvpwrvgnd_1
XFILLER_76_53 VPWR VGND VPWR VGND sky130_ef_sc_hd__decap_12
XFILLER_4_1203 VGND VGND VPWR VPWR sky130_fd_sc_hd__fill_1
XFILLER_8_1394 VPWR VGND VPWR VGND sky130_ef_sc_hd__decap_12
XFILLER_219_585 VGND VGND VPWR VPWR sky130_fd_sc_hd__decap_3
XFILLER_98_1232 VPWR VGND VPWR VGND sky130_ef_sc_hd__decap_12
XFILLER_76_97 VPWR VGND VPWR VGND sky130_ef_sc_hd__decap_12
XFILLER_202_29 VPWR VGND VPWR VGND sky130_ef_sc_hd__decap_12
XFILLER_189_1393 VGND VGND VPWR VPWR sky130_fd_sc_hd__decap_6
XFILLER_185_1213 VPWR VGND VPWR VGND sky130_ef_sc_hd__decap_12
XTAP_TAPCELL_ROW_133_1_1283 VGND VPWR sky130_fd_sc_hd__tapvpwrvgnd_1
XFILLER_185_1257 VPWR VGND VPWR VGND sky130_ef_sc_hd__decap_12
XFILLER_92_41 VPWR VGND VPWR VGND sky130_ef_sc_hd__decap_12
XFILLER_178_109 VPWR VGND VPWR VGND sky130_ef_sc_hd__decap_12
XFILLER_92_85 VPWR VGND VPWR VGND sky130_ef_sc_hd__decap_12
XFILLER_76_1574 VGND VGND VPWR VPWR sky130_fd_sc_hd__decap_6
XFILLER_203_953 VPWR VGND VPWR VGND sky130_ef_sc_hd__decap_12
XFILLER_124_1506 VPWR VGND VPWR VGND sky130_ef_sc_hd__decap_12
XFILLER_72_1438 VPWR VGND VPWR VGND sky130_ef_sc_hd__decap_12
X_407_ _128_ _129_ _134_ _142_ VGND VGND VPWR VPWR _143_ sky130_fd_sc_hd__o31ai_1
XFILLER_204_1541 VPWR VGND VPWR VGND sky130_ef_sc_hd__decap_12
XFILLER_187_665 VGND VGND VPWR VPWR sky130_fd_sc_hd__decap_6
XFILLER_186_153 VPWR VGND VPWR VGND sky130_ef_sc_hd__decap_12
X_338_ u_ctrl.cmp_addr\[0\] b_addr\[0\] net154 VGND VGND VPWR VPWR _090_ sky130_fd_sc_hd__mux2_1
XFILLER_186_197 VPWR VGND VPWR VGND sky130_ef_sc_hd__decap_12
XFILLER_200_1427 VGND VGND VPWR VPWR sky130_fd_sc_hd__fill_1
XFILLER_196_1353 VPWR VGND VPWR VGND sky130_ef_sc_hd__decap_12
XPHY_EDGE_ROW_157_2_Left_589 VGND VGND VPWR VPWR sky130_fd_sc_hd__decap_3
XFILLER_196_1397 VPWR VGND VPWR VGND sky130_ef_sc_hd__decap_12
XFILLER_192_1217 VPWR VGND VPWR VGND sky130_ef_sc_hd__decap_12
XFILLER_100_1550 VPWR VGND VPWR VGND sky130_ef_sc_hd__decap_12
XFILLER_135_1602 VGND VGND VPWR VPWR sky130_fd_sc_hd__decap_3
XFILLER_102_109 VPWR VGND VPWR VGND sky130_ef_sc_hd__decap_12
XFILLER_100_1594 VGND VGND VPWR VPWR sky130_fd_sc_hd__decap_8
XFILLER_83_1534 VPWR VGND VPWR VGND sky130_ef_sc_hd__decap_12
XFILLER_44_3 VPWR VGND VPWR VGND sky130_ef_sc_hd__decap_12
XFILLER_170_587 VGND VGND VPWR VPWR sky130_fd_sc_hd__fill_1
XPHY_EDGE_ROW_94_2_Left_526 VGND VGND VPWR VPWR sky130_fd_sc_hd__decap_3
XFILLER_83_1578 VPWR VGND VPWR VGND sky130_ef_sc_hd__decap_12
XFILLER_44_1518 VGND VGND VPWR VPWR sky130_fd_sc_hd__decap_6
XFILLER_42_1220 VPWR VGND VPWR VGND sky130_ef_sc_hd__decap_12
XANTENNA__459__X _191_ VGND VGND VPWR VPWR sky130_fd_sc_hd__diode_2
XPHY_EDGE_ROW_14_1_Left_233 VGND VGND VPWR VPWR sky130_fd_sc_hd__decap_3
XFILLER_211_1567 VGND VGND VPWR VPWR sky130_fd_sc_hd__fill_1
XFILLER_2_83 VGND VGND VPWR VPWR sky130_fd_sc_hd__fill_1
XTAP_TAPCELL_ROW_203_2534 VGND VPWR sky130_fd_sc_hd__tapvpwrvgnd_1
XTAP_TAPCELL_ROW_203_2523 VGND VPWR sky130_fd_sc_hd__tapvpwrvgnd_1
XTAP_TAPCELL_ROW_203_2512 VGND VPWR sky130_fd_sc_hd__tapvpwrvgnd_1
XFILLER_112_29 VPWR VGND VPWR VGND sky130_ef_sc_hd__decap_12
XFILLER_168_1477 VGND VGND VPWR VPWR sky130_fd_sc_hd__decap_6
XANTENNA__628__CLK clknet_3_1_0_clk VGND VGND VPWR VPWR sky130_fd_sc_hd__diode_2
XTAP_TAPCELL_ROW_0_759 VGND VPWR sky130_fd_sc_hd__tapvpwrvgnd_1
XFILLER_20_1562 VPWR VGND VPWR VGND sky130_ef_sc_hd__decap_12
XFILLER_24_115 VPWR VGND VPWR VGND sky130_ef_sc_hd__decap_12
XFILLER_197_429 VPWR VGND VPWR VGND sky130_ef_sc_hd__decap_12
XTAP_TAPCELL_ROW_195_2302 VGND VPWR sky130_fd_sc_hd__tapvpwrvgnd_1
XFILLER_178_643 VGND VGND VPWR VPWR sky130_fd_sc_hd__fill_1
XFILLER_90_1538 VPWR VGND VPWR VGND sky130_ef_sc_hd__decap_12
XTAP_TAPCELL_ROW_33_2_3195 VGND VPWR sky130_fd_sc_hd__tapvpwrvgnd_1
XTAP_TAPCELL_ROW_216_2906 VGND VPWR sky130_fd_sc_hd__tapvpwrvgnd_1
XFILLER_166_805 VGND VGND VPWR VPWR sky130_fd_sc_hd__decap_6
XTAP_TAPCELL_ROW_9_2_3036 VGND VPWR sky130_fd_sc_hd__tapvpwrvgnd_1
XFILLER_14_1300 VGND VGND VPWR VPWR sky130_fd_sc_hd__fill_1
XFILLER_166_849 VPWR VGND VPWR VGND sky130_ef_sc_hd__decap_12
XFILLER_165_337 VPWR VGND VPWR VGND sky130_ef_sc_hd__decap_12
XTAP_TAPCELL_ROW_158_1_1334 VGND VPWR sky130_fd_sc_hd__tapvpwrvgnd_1
XFILLER_88_1412 VGND VGND VPWR VPWR sky130_fd_sc_hd__fill_1
XPHY_EDGE_ROW_78_2_Right_135 VGND VGND VPWR VPWR sky130_fd_sc_hd__decap_3
XTAP_TAPCELL_ROW_13_2_3060 VGND VPWR sky130_fd_sc_hd__tapvpwrvgnd_1
XFILLER_21_15 VGND VGND VPWR VPWR sky130_fd_sc_hd__decap_8
XFILLER_192_189 VGND VGND VPWR VPWR sky130_fd_sc_hd__decap_6
XTAP_TAPCELL_ROW_189_2117 VGND VPWR sky130_fd_sc_hd__tapvpwrvgnd_1
XFILLER_180_307 VGND VGND VPWR VPWR sky130_fd_sc_hd__fill_1
XFILLER_174_893 VPWR VGND VPWR VGND sky130_ef_sc_hd__decap_12
XFILLER_137_15 VPWR VGND VPWR VGND sky130_ef_sc_hd__decap_12
XTAP_TAPCELL_ROW_189_2139 VGND VPWR sky130_fd_sc_hd__tapvpwrvgnd_1
XTAP_TAPCELL_ROW_189_2128 VGND VPWR sky130_fd_sc_hd__tapvpwrvgnd_1
XFILLER_175_1437 VPWR VGND VPWR VGND sky130_ef_sc_hd__decap_12
XPHY_EDGE_ROW_162_1_Right_748 VGND VGND VPWR VPWR sky130_fd_sc_hd__decap_3
XFILLER_217_81 VPWR VGND VPWR VGND sky130_ef_sc_hd__decap_12
XFILLER_138_1270 VPWR VGND VPWR VGND sky130_ef_sc_hd__decap_12
XFILLER_212_1309 VGND VGND VPWR VPWR sky130_fd_sc_hd__decap_6
XFILLER_153_69 VPWR VGND VPWR VGND sky130_ef_sc_hd__decap_12
XFILLER_25_1440 VGND VGND VPWR VPWR sky130_fd_sc_hd__fill_1
XFILLER_99_1552 VGND VGND VPWR VPWR sky130_fd_sc_hd__fill_1
XFILLER_5_1567 VGND VGND VPWR VPWR sky130_fd_sc_hd__fill_1
XFILLER_216_533 VPWR VGND VPWR VGND sky130_ef_sc_hd__decap_12
XFILLER_186_1533 VGND VGND VPWR VPWR sky130_fd_sc_hd__decap_6
XFILLER_186_1577 VPWR VGND VPWR VGND sky130_ef_sc_hd__decap_12
XFILLER_15_104 VGND VGND VPWR VPWR sky130_fd_sc_hd__decap_8
XFILLER_203_205 VPWR VGND VPWR VGND sky130_ef_sc_hd__decap_12
XFILLER_203_249 VPWR VGND VPWR VGND sky130_ef_sc_hd__decap_12
XTAP_TAPCELL_ROW_178_1821 VGND VPWR sky130_fd_sc_hd__tapvpwrvgnd_1
XTAP_TAPCELL_ROW_178_1810 VGND VPWR sky130_fd_sc_hd__tapvpwrvgnd_1
XANTENNA__545__A net139 VGND VGND VPWR VPWR sky130_fd_sc_hd__diode_2
XFILLER_19_1244 VPWR VGND VPWR VGND sky130_ef_sc_hd__decap_12
XFILLER_58_1282 VPWR VGND VPWR VGND sky130_ef_sc_hd__decap_12
XFILLER_200_923 VGND VGND VPWR VPWR sky130_fd_sc_hd__fill_1
XTAP_TAPCELL_ROW_174_1707 VGND VPWR sky130_fd_sc_hd__tapvpwrvgnd_1
XFILLER_169_665 VGND VGND VPWR VPWR sky130_fd_sc_hd__decap_6
XFILLER_168_153 VPWR VGND VPWR VGND sky130_ef_sc_hd__decap_12
XFILLER_145_1274 VPWR VGND VPWR VGND sky130_ef_sc_hd__decap_12
XFILLER_62_77 VGND VGND VPWR VPWR sky130_fd_sc_hd__decap_6
XFILLER_211_293 VPWR VGND VPWR VGND sky130_ef_sc_hd__decap_12
XFILLER_184_613 VPWR VGND VPWR VGND sky130_ef_sc_hd__decap_12
XFILLER_178_77 VGND VGND VPWR VPWR sky130_fd_sc_hd__decap_6
XFILLER_106_1258 VPWR VGND VPWR VGND sky130_ef_sc_hd__decap_12
XFILLER_36_1580 VGND VGND VPWR VPWR sky130_fd_sc_hd__fill_1
XFILLER_184_657 VPWR VGND VPWR VGND sky130_ef_sc_hd__decap_12
XFILLER_168_197 VPWR VGND VPWR VGND sky130_ef_sc_hd__decap_12
XFILLER_183_167 VGND VGND VPWR VPWR sky130_fd_sc_hd__fill_1
XFILLER_171_329 VGND VGND VPWR VPWR sky130_fd_sc_hd__decap_6
XFILLER_158_1602 VGND VGND VPWR VPWR sky130_fd_sc_hd__decap_3
XTAP_TAPCELL_ROW_14_1_1045 VGND VPWR sky130_fd_sc_hd__tapvpwrvgnd_1
XFILLER_194_65 VPWR VGND VPWR VGND sky130_ef_sc_hd__decap_12
XFILLER_193_1537 VPWR VGND VPWR VGND sky130_ef_sc_hd__decap_12
XFILLER_178_1061 VPWR VGND VPWR VGND sky130_ef_sc_hd__decap_12
XANTENNA__280__A b_addr\[3\] VGND VGND VPWR VPWR sky130_fd_sc_hd__diode_2
XFILLER_65_1220 VPWR VGND VPWR VGND sky130_ef_sc_hd__decap_12
XFILLER_11_81 VGND VGND VPWR VPWR sky130_fd_sc_hd__decap_3
XFILLER_156_1370 VPWR VGND VPWR VGND sky130_ef_sc_hd__decap_12
XFILLER_127_81 VPWR VGND VPWR VGND sky130_ef_sc_hd__decap_12
XFILLER_117_1310 VPWR VGND VPWR VGND sky130_ef_sc_hd__decap_12
XFILLER_117_1354 VPWR VGND VPWR VGND sky130_ef_sc_hd__decap_12
XTAP_TAPCELL_ROW_70_2_3436 VGND VPWR sky130_fd_sc_hd__tapvpwrvgnd_1
XFILLER_65_1286 VPWR VGND VPWR VGND sky130_ef_sc_hd__decap_12
XFILLER_6_1309 VGND VGND VPWR VPWR sky130_fd_sc_hd__decap_6
XFILLER_117_1398 VPWR VGND VPWR VGND sky130_ef_sc_hd__decap_12
XFILLER_213_39 VPWR VGND VPWR VGND sky130_ef_sc_hd__decap_12
XFILLER_219_393 VPWR VGND VPWR VGND sky130_ef_sc_hd__decap_12
XPHY_EDGE_ROW_124_1_Right_710 VGND VGND VPWR VPWR sky130_fd_sc_hd__decap_3
XTAP_TAPCELL_ROW_50_2_3301 VGND VPWR sky130_fd_sc_hd__tapvpwrvgnd_1
XFILLER_185_1021 VPWR VGND VPWR VGND sky130_ef_sc_hd__decap_12
XFILLER_185_1065 VPWR VGND VPWR VGND sky130_ef_sc_hd__decap_12
XFILLER_179_429 VPWR VGND VPWR VGND sky130_ef_sc_hd__decap_12
XTAP_TAPCELL_ROW_18_2_3097 VGND VPWR sky130_fd_sc_hd__tapvpwrvgnd_1
XFILLER_163_1341 VGND VGND VPWR VPWR sky130_fd_sc_hd__decap_3
XFILLER_128_1450 VPWR VGND VPWR VGND sky130_ef_sc_hd__decap_12
XFILLER_76_1382 VPWR VGND VPWR VGND sky130_ef_sc_hd__decap_12
XANTENNA__455__A net147 VGND VGND VPWR VPWR sky130_fd_sc_hd__diode_2
XFILLER_37_1322 VGND VGND VPWR VPWR sky130_fd_sc_hd__decap_6
XFILLER_203_783 VGND VGND VPWR VPWR sky130_fd_sc_hd__fill_1
XFILLER_128_1494 VPWR VGND VPWR VGND sky130_ef_sc_hd__decap_12
XFILLER_124_1314 VPWR VGND VPWR VGND sky130_ef_sc_hd__decap_12
XFILLER_72_1246 VPWR VGND VPWR VGND sky130_ef_sc_hd__decap_12
XFILLER_37_1366 VPWR VGND VPWR VGND sky130_ef_sc_hd__decap_12
XFILLER_187_473 VPWR VGND VPWR VGND sky130_ef_sc_hd__decap_12
XFILLER_163_1385 VPWR VGND VPWR VGND sky130_ef_sc_hd__decap_12
XFILLER_124_1358 VPWR VGND VPWR VGND sky130_ef_sc_hd__decap_12
XFILLER_204_1371 VGND VGND VPWR VPWR sky130_fd_sc_hd__fill_1
Xinput31 func_wdata[27] VGND VGND VPWR VPWR net31 sky130_fd_sc_hd__clkbuf_1
Xinput20 func_wdata[17] VGND VGND VPWR VPWR net20 sky130_fd_sc_hd__clkbuf_1
Xinput42 func_wdata[8] VGND VGND VPWR VPWR net42 sky130_fd_sc_hd__clkbuf_1
XFILLER_196_1161 VPWR VGND VPWR VGND sky130_ef_sc_hd__decap_12
XFILLER_174_189 VGND VGND VPWR VPWR sky130_fd_sc_hd__decap_6
XFILLER_171_841 VPWR VGND VPWR VGND sky130_ef_sc_hd__decap_12
XFILLER_7_881 VPWR VGND VPWR VGND sky130_ef_sc_hd__decap_12
XFILLER_139_1590 VPWR VGND VPWR VGND sky130_ef_sc_hd__decap_12
XFILLER_135_1410 VPWR VGND VPWR VGND sky130_ef_sc_hd__decap_12
XFILLER_83_1342 VPWR VGND VPWR VGND sky130_ef_sc_hd__decap_12
XFILLER_48_1462 VGND VGND VPWR VPWR sky130_fd_sc_hd__decap_6
XTAP_TAPCELL_ROW_209_2710 VGND VPWR sky130_fd_sc_hd__tapvpwrvgnd_1
XFILLER_135_1454 VPWR VGND VPWR VGND sky130_ef_sc_hd__decap_12
XFILLER_83_1386 VPWR VGND VPWR VGND sky130_ef_sc_hd__decap_12
XFILLER_44_1326 VPWR VGND VPWR VGND sky130_ef_sc_hd__decap_12
XFILLER_22_1602 VGND VGND VPWR VPWR sky130_fd_sc_hd__decap_3
XFILLER_135_1498 VPWR VGND VPWR VGND sky130_ef_sc_hd__decap_12
XFILLER_123_39 VPWR VGND VPWR VGND sky130_ef_sc_hd__decap_12
XFILLER_213_503 VGND VGND VPWR VPWR sky130_fd_sc_hd__fill_1
XFILLER_168_1241 VPWR VGND VPWR VGND sky130_ef_sc_hd__decap_12
XFILLER_16_15 VPWR VGND VPWR VGND sky130_ef_sc_hd__decap_12
XFILLER_168_1285 VPWR VGND VPWR VGND sky130_ef_sc_hd__decap_12
XFILLER_164_1105 VPWR VGND VPWR VGND sky130_ef_sc_hd__decap_12
XFILLER_0_1453 VGND VGND VPWR VPWR sky130_fd_sc_hd__decap_3
XFILLER_20_1370 VPWR VGND VPWR VGND sky130_ef_sc_hd__decap_12
XFILLER_201_709 VPWR VGND VPWR VGND sky130_ef_sc_hd__decap_12
XFILLER_198_749 VGND VGND VPWR VPWR sky130_fd_sc_hd__decap_6
XFILLER_197_237 VPWR VGND VPWR VGND sky130_ef_sc_hd__decap_12
XFILLER_164_1149 VPWR VGND VPWR VGND sky130_ef_sc_hd__decap_12
XFILLER_146_1550 VPWR VGND VPWR VGND sky130_ef_sc_hd__decap_12
XFILLER_94_1482 VPWR VGND VPWR VGND sky130_ef_sc_hd__decap_12
XFILLER_90_1302 VPWR VGND VPWR VGND sky130_ef_sc_hd__decap_12
XFILLER_0_1497 VPWR VGND VPWR VGND sky130_ef_sc_hd__decap_12
XFILLER_55_1422 VPWR VGND VPWR VGND sky130_ef_sc_hd__decap_12
XFILLER_205_1113 VGND VGND VPWR VPWR sky130_fd_sc_hd__decap_6
XFILLER_142_1414 VPWR VGND VPWR VGND sky130_ef_sc_hd__decap_12
XFILLER_107_1534 VPWR VGND VPWR VGND sky130_ef_sc_hd__decap_12
XFILLER_16_1406 VGND VGND VPWR VPWR sky130_fd_sc_hd__decap_6
XFILLER_55_1466 VPWR VGND VPWR VGND sky130_ef_sc_hd__decap_12
XFILLER_205_1157 VPWR VGND VPWR VGND sky130_ef_sc_hd__decap_12
XFILLER_166_613 VPWR VGND VPWR VGND sky130_ef_sc_hd__decap_12
XFILLER_146_1594 VGND VGND VPWR VPWR sky130_fd_sc_hd__decap_8
XFILLER_107_1578 VPWR VGND VPWR VGND sky130_ef_sc_hd__decap_12
XTAP_TAPCELL_ROW_63_2_3390 VGND VPWR sky130_fd_sc_hd__tapvpwrvgnd_1
XFILLER_32_47 VGND VGND VPWR VPWR sky130_fd_sc_hd__fill_1
XFILLER_166_657 VPWR VGND VPWR VGND sky130_ef_sc_hd__decap_12
XTAP_TAPCELL_ROW_94_1_1206 VGND VPWR sky130_fd_sc_hd__tapvpwrvgnd_1
XFILLER_165_167 VGND VGND VPWR VPWR sky130_fd_sc_hd__fill_1
XFILLER_88_1220 VPWR VGND VPWR VGND sky130_ef_sc_hd__decap_12
XPHY_EDGE_ROW_79_2_Right_136 VGND VGND VPWR VPWR sky130_fd_sc_hd__decap_3
XFILLER_179_1381 VPWR VGND VPWR VGND sky130_ef_sc_hd__decap_12
XFILLER_175_1201 VPWR VGND VPWR VGND sky130_ef_sc_hd__decap_12
XFILLER_4_317 VGND VGND VPWR VPWR sky130_fd_sc_hd__decap_3
XFILLER_175_1245 VPWR VGND VPWR VGND sky130_ef_sc_hd__decap_12
XFILLER_175_1289 VPWR VGND VPWR VGND sky130_ef_sc_hd__decap_12
XFILLER_153_1510 VPWR VGND VPWR VGND sky130_ef_sc_hd__decap_12
XFILLER_66_1562 VPWR VGND VPWR VGND sky130_ef_sc_hd__decap_12
XFILLER_0_501 VGND VGND VPWR VPWR sky130_fd_sc_hd__decap_3
XFILLER_216_1253 VGND VGND VPWR VPWR sky130_fd_sc_hd__decap_6
XTAP_TAPCELL_ROW_167_1511 VGND VPWR sky130_fd_sc_hd__tapvpwrvgnd_1
XTAP_TAPCELL_ROW_167_1500 VGND VPWR sky130_fd_sc_hd__tapvpwrvgnd_1
XFILLER_27_1546 VGND VGND VPWR VPWR sky130_fd_sc_hd__decap_6
XTAP_TAPCELL_ROW_55_2_3338 VGND VPWR sky130_fd_sc_hd__tapvpwrvgnd_1
XFILLER_62_1426 VPWR VGND VPWR VGND sky130_ef_sc_hd__decap_12
XFILLER_216_1297 VPWR VGND VPWR VGND sky130_ef_sc_hd__decap_12
XFILLER_212_1117 VPWR VGND VPWR VGND sky130_ef_sc_hd__decap_12
XFILLER_209_809 VPWR VGND VPWR VGND sky130_ef_sc_hd__decap_12
XFILLER_196_3 VPWR VGND VPWR VGND sky130_ef_sc_hd__decap_12
XFILLER_153_1554 VPWR VGND VPWR VGND sky130_ef_sc_hd__decap_12
XFILLER_114_1538 VPWR VGND VPWR VGND sky130_ef_sc_hd__decap_12
XFILLER_0_589 VGND VGND VPWR VPWR sky130_fd_sc_hd__fill_1
XFILLER_57_44 VPWR VGND VPWR VGND sky130_ef_sc_hd__decap_12
XTAP_TAPCELL_ROW_35_2_3203 VGND VPWR sky130_fd_sc_hd__tapvpwrvgnd_1
XTAP_TAPCELL_ROW_4_895 VGND VPWR sky130_fd_sc_hd__tapvpwrvgnd_1
XANTENNA__406__A1 b_addr\[3\] VGND VGND VPWR VPWR sky130_fd_sc_hd__diode_2
XFILLER_217_853 VPWR VGND VPWR VGND sky130_ef_sc_hd__decap_12
XFILLER_186_1341 VPWR VGND VPWR VGND sky130_ef_sc_hd__decap_12
XFILLER_217_897 VPWR VGND VPWR VGND sky130_ef_sc_hd__decap_12
XFILLER_216_363 VGND VGND VPWR VPWR sky130_fd_sc_hd__fill_1
XFILLER_204_525 VGND VGND VPWR VPWR sky130_fd_sc_hd__decap_6
XFILLER_189_727 VGND VGND VPWR VPWR sky130_fd_sc_hd__fill_1
XFILLER_186_1385 VPWR VGND VPWR VGND sky130_ef_sc_hd__decap_12
XFILLER_182_1205 VPWR VGND VPWR VGND sky130_ef_sc_hd__decap_12
XFILLER_95_1268 VGND VGND VPWR VPWR sky130_fd_sc_hd__decap_4
XFILLER_204_569 VPWR VGND VPWR VGND sky130_ef_sc_hd__decap_12
XFILLER_73_1522 VPWR VGND VPWR VGND sky130_ef_sc_hd__decap_12
XFILLER_73_1566 VPWR VGND VPWR VGND sky130_ef_sc_hd__decap_12
XFILLER_34_1506 VPWR VGND VPWR VGND sky130_ef_sc_hd__decap_12
XFILLER_185_933 VPWR VGND VPWR VGND sky130_ef_sc_hd__decap_12
XFILLER_169_473 VPWR VGND VPWR VGND sky130_ef_sc_hd__decap_12
XFILLER_201_1511 VGND VGND VPWR VPWR sky130_fd_sc_hd__fill_1
XFILLER_185_977 VPWR VGND VPWR VGND sky130_ef_sc_hd__decap_12
XFILLER_184_421 VPWR VGND VPWR VGND sky130_ef_sc_hd__decap_12
XFILLER_7_133 VGND VGND VPWR VPWR sky130_fd_sc_hd__decap_6
XFILLER_197_1481 VPWR VGND VPWR VGND sky130_ef_sc_hd__decap_12
XFILLER_193_1301 VPWR VGND VPWR VGND sky130_ef_sc_hd__decap_12
XFILLER_171_137 VPWR VGND VPWR VGND sky130_ef_sc_hd__decap_12
XFILLER_193_1345 VPWR VGND VPWR VGND sky130_ef_sc_hd__decap_12
XTAP_TAPCELL_ROW_152_2_3966 VGND VPWR sky130_fd_sc_hd__tapvpwrvgnd_1
XFILLER_4_862 VGND VGND VPWR VPWR sky130_fd_sc_hd__fill_2
XFILLER_10_1550 VPWR VGND VPWR VGND sky130_ef_sc_hd__decap_12
XFILLER_180_693 VGND VGND VPWR VPWR sky130_fd_sc_hd__decap_6
XFILLER_4_895 VGND VGND VPWR VPWR sky130_fd_sc_hd__decap_8
XFILLER_10_1594 VGND VGND VPWR VPWR sky130_fd_sc_hd__decap_8
XFILLER_45_1602 VGND VGND VPWR VPWR sky130_fd_sc_hd__decap_3
XFILLER_80_1526 VPWR VGND VPWR VGND sky130_ef_sc_hd__decap_12
XFILLER_6_1117 VPWR VGND VPWR VGND sky130_ef_sc_hd__decap_12
XPHY_EDGE_ROW_201_Left_420 VGND VGND VPWR VPWR sky130_fd_sc_hd__decap_3
XFILLER_169_1561 VGND VGND VPWR VPWR sky130_fd_sc_hd__decap_6
XFILLER_207_385 VGND VGND VPWR VPWR sky130_fd_sc_hd__decap_6
XFILLER_165_1425 VPWR VGND VPWR VGND sky130_ef_sc_hd__decap_12
XPHY_EDGE_ROW_125_1_Right_711 VGND VGND VPWR VPWR sky130_fd_sc_hd__decap_3
XFILLER_179_237 VPWR VGND VPWR VGND sky130_ef_sc_hd__decap_12
XFILLER_165_1469 VPWR VGND VPWR VGND sky130_ef_sc_hd__decap_12
XFILLER_188_793 VPWR VGND VPWR VGND sky130_ef_sc_hd__decap_12
XTAP_TAPCELL_ROW_48_2_3292 VGND VPWR sky130_fd_sc_hd__tapvpwrvgnd_1
XFILLER_206_1477 VGND VGND VPWR VPWR sky130_fd_sc_hd__decap_6
XFILLER_187_281 VPWR VGND VPWR VGND sky130_ef_sc_hd__decap_12
XFILLER_190_413 VGND VGND VPWR VPWR sky130_fd_sc_hd__decap_6
XFILLER_176_1521 VPWR VGND VPWR VGND sky130_ef_sc_hd__decap_12
XPHY_EDGE_ROW_38_2_Left_470 VGND VGND VPWR VPWR sky130_fd_sc_hd__decap_3
XFILLER_190_457 VPWR VGND VPWR VGND sky130_ef_sc_hd__decap_12
XFILLER_176_1565 VPWR VGND VPWR VGND sky130_ef_sc_hd__decap_12
XFILLER_172_1429 VPWR VGND VPWR VGND sky130_ef_sc_hd__decap_12
XFILLER_171_671 VGND VGND VPWR VPWR sky130_fd_sc_hd__fill_1
XPHY_EDGE_ROW_4_Right_4 VGND VGND VPWR VPWR sky130_fd_sc_hd__decap_3
XTAP_TAPCELL_ROW_41_2_3246 VGND VPWR sky130_fd_sc_hd__tapvpwrvgnd_1
XFILLER_48_1270 VPWR VGND VPWR VGND sky130_ef_sc_hd__decap_12
XFILLER_213_1437 VPWR VGND VPWR VGND sky130_ef_sc_hd__decap_12
XFILLER_134_27 VGND VGND VPWR VPWR sky130_fd_sc_hd__fill_1
XFILLER_217_105 VGND VGND VPWR VPWR sky130_fd_sc_hd__decap_6
XFILLER_84_121 VGND VGND VPWR VPWR sky130_fd_sc_hd__decap_6
XFILLER_170_1197 VGND VGND VPWR VPWR sky130_fd_sc_hd__decap_6
XTAP_TAPCELL_ROW_1_810 VGND VPWR sky130_fd_sc_hd__tapvpwrvgnd_1
XFILLER_217_149 VPWR VGND VPWR VGND sky130_ef_sc_hd__decap_12
XFILLER_150_15 VPWR VGND VPWR VGND sky130_ef_sc_hd__decap_12
XTAP_TAPCELL_ROW_1_832 VGND VPWR sky130_fd_sc_hd__tapvpwrvgnd_1
XTAP_TAPCELL_ROW_1_821 VGND VPWR sky130_fd_sc_hd__tapvpwrvgnd_1
XFILLER_198_513 VPWR VGND VPWR VGND sky130_ef_sc_hd__decap_12
XFILLER_183_1525 VPWR VGND VPWR VGND sky130_ef_sc_hd__decap_12
XFILLER_214_867 VGND VGND VPWR VPWR sky130_fd_sc_hd__fill_1
XFILLER_168_1093 VPWR VGND VPWR VGND sky130_ef_sc_hd__decap_12
XFILLER_0_1261 VPWR VGND VPWR VGND sky130_ef_sc_hd__decap_12
XTAP_TAPCELL_ROW_38_1_1093 VGND VPWR sky130_fd_sc_hd__tapvpwrvgnd_1
XFILLER_201_517 VPWR VGND VPWR VGND sky130_ef_sc_hd__decap_12
XFILLER_198_557 VPWR VGND VPWR VGND sky130_ef_sc_hd__decap_12
XFILLER_183_1569 VPWR VGND VPWR VGND sky130_ef_sc_hd__decap_12
XFILLER_199_1009 VPWR VGND VPWR VGND sky130_ef_sc_hd__decap_12
XFILLER_167_933 VPWR VGND VPWR VGND sky130_ef_sc_hd__decap_12
XFILLER_159_57 VPWR VGND VPWR VGND sky130_ef_sc_hd__decap_12
XFILLER_107_1342 VPWR VGND VPWR VGND sky130_ef_sc_hd__decap_12
XFILLER_43_57 VPWR VGND VPWR VGND sky130_ef_sc_hd__decap_12
XFILLER_55_1274 VPWR VGND VPWR VGND sky130_ef_sc_hd__decap_12
XFILLER_166_421 VPWR VGND VPWR VGND sky130_ef_sc_hd__decap_12
XFILLER_142_1244 VGND VGND VPWR VPWR sky130_fd_sc_hd__fill_1
XFILLER_107_1386 VPWR VGND VPWR VGND sky130_ef_sc_hd__decap_12
XFILLER_16_1258 VPWR VGND VPWR VGND sky130_ef_sc_hd__decap_12
XFILLER_182_925 VPWR VGND VPWR VGND sky130_ef_sc_hd__decap_12
XFILLER_167_977 VPWR VGND VPWR VGND sky130_ef_sc_hd__decap_12
XTAP_TAPCELL_ROW_126_1_1269 VGND VPWR sky130_fd_sc_hd__tapvpwrvgnd_1
XFILLER_193_273 VGND VGND VPWR VPWR sky130_fd_sc_hd__decap_6
XFILLER_111_3 VPWR VGND VPWR VGND sky130_ef_sc_hd__decap_12
XFILLER_68_1602 VGND VGND VPWR VPWR sky130_fd_sc_hd__decap_3
XFILLER_4_103 VGND VGND VPWR VPWR sky130_fd_sc_hd__fill_1
XFILLER_218_1315 VGND VGND VPWR VPWR sky130_fd_sc_hd__fill_1
XFILLER_209_3 VPWR VGND VPWR VGND sky130_ef_sc_hd__decap_12
XTAP_TAPCELL_ROW_137_2_3868 VGND VPWR sky130_fd_sc_hd__tapvpwrvgnd_1
XFILLER_4_29 VPWR VGND VPWR VGND sky130_ef_sc_hd__decap_12
XFILLER_108_83 VGND VGND VPWR VPWR sky130_fd_sc_hd__fill_1
XFILLER_66_1370 VPWR VGND VPWR VGND sky130_ef_sc_hd__decap_12
XFILLER_27_1310 VPWR VGND VPWR VGND sky130_ef_sc_hd__decap_12
XFILLER_216_1061 VPWR VGND VPWR VGND sky130_ef_sc_hd__decap_12
XFILLER_191_55 VGND VGND VPWR VPWR sky130_fd_sc_hd__fill_1
XFILLER_118_1482 VPWR VGND VPWR VGND sky130_ef_sc_hd__decap_12
XFILLER_114_1302 VPWR VGND VPWR VGND sky130_ef_sc_hd__decap_12
XFILLER_68_65 VPWR VGND VPWR VGND sky130_ef_sc_hd__decap_12
XFILLER_27_1354 VPWR VGND VPWR VGND sky130_ef_sc_hd__decap_12
XFILLER_209_617 VPWR VGND VPWR VGND sky130_ef_sc_hd__decap_12
XFILLER_153_1384 VGND VGND VPWR VPWR sky130_fd_sc_hd__fill_1
XTAP_TAPCELL_ROW_85_2_3533 VGND VPWR sky130_fd_sc_hd__tapvpwrvgnd_1
XANTENNA_input31_A func_wdata[27] VGND VGND VPWR VPWR sky130_fd_sc_hd__diode_2
XFILLER_27_1398 VPWR VGND VPWR VGND sky130_ef_sc_hd__decap_12
XFILLER_84_53 VPWR VGND VPWR VGND sky130_ef_sc_hd__decap_12
XFILLER_84_97 VPWR VGND VPWR VGND sky130_ef_sc_hd__decap_12
XFILLER_210_29 VPWR VGND VPWR VGND sky130_ef_sc_hd__decap_12
XFILLER_204_333 VPWR VGND VPWR VGND sky130_ef_sc_hd__decap_12
XFILLER_17_91 VPWR VGND VPWR VGND sky130_ef_sc_hd__decap_12
X_586_ clknet_3_1_0_clk _020_ VGND VGND VPWR VPWR b_addr\[2\] sky130_fd_sc_hd__dfxtp_2
XFILLER_205_889 VGND VGND VPWR VPWR sky130_fd_sc_hd__decap_6
XFILLER_204_377 VPWR VGND VPWR VGND sky130_ef_sc_hd__decap_12
XFILLER_182_1035 VGND VGND VPWR VPWR sky130_fd_sc_hd__fill_1
XFILLER_73_1330 VPWR VGND VPWR VGND sky130_ef_sc_hd__decap_12
XFILLER_38_1450 VPWR VGND VPWR VGND sky130_ef_sc_hd__decap_12
XFILLER_160_1300 VGND VGND VPWR VPWR sky130_fd_sc_hd__fill_1
XFILLER_125_1442 VPWR VGND VPWR VGND sky130_ef_sc_hd__decap_12
XFILLER_34_1314 VPWR VGND VPWR VGND sky130_ef_sc_hd__decap_12
XFILLER_38_1494 VPWR VGND VPWR VGND sky130_ef_sc_hd__decap_12
XFILLER_185_741 VPWR VGND VPWR VGND sky130_ef_sc_hd__decap_12
XFILLER_169_281 VPWR VGND VPWR VGND sky130_ef_sc_hd__decap_12
XFILLER_34_1358 VPWR VGND VPWR VGND sky130_ef_sc_hd__decap_12
XFILLER_219_27 VGND VGND VPWR VPWR sky130_fd_sc_hd__fill_1
XFILLER_185_785 VPWR VGND VPWR VGND sky130_ef_sc_hd__decap_12
XFILLER_184_251 VGND VGND VPWR VPWR sky130_fd_sc_hd__fill_1
XFILLER_121_1328 VGND VGND VPWR VPWR sky130_fd_sc_hd__fill_1
XFILLER_172_413 VGND VGND VPWR VPWR sky130_fd_sc_hd__decap_6
XPHY_EDGE_ROW_23_1_Left_242 VGND VGND VPWR VPWR sky130_fd_sc_hd__decap_3
XFILLER_172_457 VPWR VGND VPWR VGND sky130_ef_sc_hd__decap_12
XTAP_TAPCELL_ROW_26_2_3148 VGND VPWR sky130_fd_sc_hd__tapvpwrvgnd_1
XFILLER_193_1175 VGND VGND VPWR VPWR sky130_fd_sc_hd__fill_1
XFILLER_84_1470 VPWR VGND VPWR VGND sky130_ef_sc_hd__decap_12
XFILLER_45_1410 VPWR VGND VPWR VGND sky130_ef_sc_hd__decap_12
XFILLER_49_1590 VPWR VGND VPWR VGND sky130_ef_sc_hd__decap_12
XFILLER_119_1268 VGND VGND VPWR VPWR sky130_fd_sc_hd__decap_4
XFILLER_45_1454 VPWR VGND VPWR VGND sky130_ef_sc_hd__decap_12
XFILLER_136_1582 VPWR VGND VPWR VGND sky130_ef_sc_hd__decap_12
XFILLER_80_1356 VGND VGND VPWR VPWR sky130_fd_sc_hd__fill_1
XFILLER_132_1468 VGND VGND VPWR VPWR sky130_fd_sc_hd__fill_1
XFILLER_66_121 VGND VGND VPWR VPWR sky130_fd_sc_hd__decap_6
XFILLER_45_1498 VPWR VGND VPWR VGND sky130_ef_sc_hd__decap_12
XFILLER_215_609 VGND VGND VPWR VPWR sky130_fd_sc_hd__decap_6
XFILLER_81_113 VPWR VGND VPWR VGND sky130_ef_sc_hd__decap_12
XPHY_EDGE_ROW_6_Left_226 VGND VGND VPWR VPWR sky130_fd_sc_hd__decap_3
XFILLER_207_193 VPWR VGND VPWR VGND sky130_ef_sc_hd__decap_12
XFILLER_165_1233 VPWR VGND VPWR VGND sky130_ef_sc_hd__decap_12
XPHY_EDGE_ROW_126_1_Right_712 VGND VGND VPWR VPWR sky130_fd_sc_hd__decap_3
XFILLER_120_29 VPWR VGND VPWR VGND sky130_ef_sc_hd__decap_12
XFILLER_208_1539 VGND VGND VPWR VPWR sky130_fd_sc_hd__fill_1
XFILLER_195_505 VPWR VGND VPWR VGND sky130_ef_sc_hd__decap_12
XFILLER_1_1581 VPWR VGND VPWR VGND sky130_ef_sc_hd__decap_12
XFILLER_56_1550 VPWR VGND VPWR VGND sky130_ef_sc_hd__decap_12
XFILLER_206_1241 VPWR VGND VPWR VGND sky130_ef_sc_hd__decap_12
XFILLER_17_1534 VPWR VGND VPWR VGND sky130_ef_sc_hd__decap_12
XFILLER_52_1414 VPWR VGND VPWR VGND sky130_ef_sc_hd__decap_12
XFILLER_206_1285 VPWR VGND VPWR VGND sky130_ef_sc_hd__decap_12
XFILLER_202_1105 VPWR VGND VPWR VGND sky130_ef_sc_hd__decap_12
XFILLER_91_1496 VGND VGND VPWR VPWR sky130_fd_sc_hd__fill_1
XFILLER_13_27 VPWR VGND VPWR VGND sky130_ef_sc_hd__decap_12
XFILLER_56_1594 VGND VGND VPWR VPWR sky130_fd_sc_hd__decap_8
XFILLER_202_1149 VPWR VGND VPWR VGND sky130_ef_sc_hd__decap_12
XFILLER_164_925 VPWR VGND VPWR VGND sky130_ef_sc_hd__decap_12
XFILLER_129_27 VPWR VGND VPWR VGND sky130_ef_sc_hd__decap_12
XFILLER_104_1526 VPWR VGND VPWR VGND sky130_ef_sc_hd__decap_12
XFILLER_17_1578 VPWR VGND VPWR VGND sky130_ef_sc_hd__decap_12
XFILLER_190_221 VPWR VGND VPWR VGND sky130_ef_sc_hd__decap_12
XFILLER_175_273 VGND VGND VPWR VPWR sky130_fd_sc_hd__decap_6
XTAP_TAPCELL_ROW_123_2_3776 VGND VPWR sky130_fd_sc_hd__tapvpwrvgnd_1
XANTENNA__362__B b_addr\[2\] VGND VGND VPWR VPWR sky130_fd_sc_hd__diode_2
XFILLER_191_777 VGND VGND VPWR VPWR sky130_fd_sc_hd__decap_6
XFILLER_209_93 VPWR VGND VPWR VGND sky130_ef_sc_hd__decap_12
XFILLER_190_265 VPWR VGND VPWR VGND sky130_ef_sc_hd__decap_12
XFILLER_145_15 VPWR VGND VPWR VGND sky130_ef_sc_hd__decap_12
XFILLER_102_1294 VGND VGND VPWR VPWR sky130_fd_sc_hd__decap_6
XFILLER_85_1256 VPWR VGND VPWR VGND sky130_ef_sc_hd__decap_12
XFILLER_176_1373 VPWR VGND VPWR VGND sky130_ef_sc_hd__decap_12
XFILLER_63_1510 VPWR VGND VPWR VGND sky130_ef_sc_hd__decap_12
XFILLER_213_1201 VPWR VGND VPWR VGND sky130_ef_sc_hd__decap_12
XFILLER_172_1259 VGND VGND VPWR VPWR sky130_fd_sc_hd__fill_1
XTAP_TAPCELL_ROW_71_2_3441 VGND VPWR sky130_fd_sc_hd__tapvpwrvgnd_1
XFILLER_217_1381 VPWR VGND VPWR VGND sky130_ef_sc_hd__decap_12
XFILLER_213_1245 VPWR VGND VPWR VGND sky130_ef_sc_hd__decap_12
XFILLER_150_1524 VGND VGND VPWR VPWR sky130_fd_sc_hd__fill_1
XFILLER_63_1554 VPWR VGND VPWR VGND sky130_ef_sc_hd__decap_12
XTAP_TAPCELL_ROW_6_957 VGND VPWR sky130_fd_sc_hd__tapvpwrvgnd_1
XTAP_TAPCELL_ROW_6_968 VGND VPWR sky130_fd_sc_hd__tapvpwrvgnd_1
XFILLER_24_1538 VPWR VGND VPWR VGND sky130_ef_sc_hd__decap_12
XFILLER_219_937 VPWR VGND VPWR VGND sky130_ef_sc_hd__decap_12
XPHY_EDGE_ROW_99_1_Left_318 VGND VGND VPWR VPWR sky130_fd_sc_hd__decap_3
XFILLER_218_469 VGND VGND VPWR VPWR sky130_fd_sc_hd__decap_6
XFILLER_213_1289 VPWR VGND VPWR VGND sky130_ef_sc_hd__decap_12
XFILLER_161_69 VPWR VGND VPWR VGND sky130_ef_sc_hd__decap_12
XFILLER_199_833 VGND VGND VPWR VPWR sky130_fd_sc_hd__decap_6
XFILLER_198_321 VPWR VGND VPWR VGND sky130_ef_sc_hd__decap_12
XTAP_TAPCELL_ROW_181_1894 VGND VPWR sky130_fd_sc_hd__tapvpwrvgnd_1
X_440_ net147 net91 VGND VGND VPWR VPWR _172_ sky130_fd_sc_hd__xnor2_1
XFILLER_199_877 VPWR VGND VPWR VGND sky130_ef_sc_hd__decap_12
XFILLER_159_3 VPWR VGND VPWR VGND sky130_ef_sc_hd__decap_12
X_371_ u_ctrl.elem_idx\[1\] _109_ _110_ _112_ VGND VGND VPWR VPWR _113_ sky130_fd_sc_hd__a22o_1
XFILLER_202_837 VPWR VGND VPWR VGND sky130_ef_sc_hd__decap_12
XFILLER_198_365 VPWR VGND VPWR VGND sky130_ef_sc_hd__decap_12
XFILLER_183_1399 VGND VGND VPWR VPWR sky130_fd_sc_hd__fill_1
XFILLER_167_741 VPWR VGND VPWR VGND sky130_ef_sc_hd__decap_12
XANTENNA__553__A net136 VGND VGND VPWR VPWR sky130_fd_sc_hd__diode_2
XFILLER_210_881 VPWR VGND VPWR VGND sky130_ef_sc_hd__decap_12
XFILLER_167_785 VPWR VGND VPWR VGND sky130_ef_sc_hd__decap_12
XFILLER_166_251 VGND VGND VPWR VPWR sky130_fd_sc_hd__fill_1
XFILLER_70_77 VGND VGND VPWR VPWR sky130_fd_sc_hd__decap_6
XFILLER_186_77 VGND VGND VPWR VPWR sky130_fd_sc_hd__decap_6
XTAP_TAPCELL_ROW_12_2_3056 VGND VPWR sky130_fd_sc_hd__tapvpwrvgnd_1
XFILLER_182_755 VGND VGND VPWR VPWR sky130_fd_sc_hd__fill_1
XFILLER_170_917 VGND VGND VPWR VPWR sky130_fd_sc_hd__decap_6
XFILLER_120_1350 VGND VGND VPWR VPWR sky130_fd_sc_hd__decap_6
XFILLER_6_979 VGND VGND VPWR VPWR sky130_fd_sc_hd__fill_1
XFILLER_120_1394 VPWR VGND VPWR VGND sky130_ef_sc_hd__decap_12
XFILLER_119_93 VPWR VGND VPWR VGND sky130_ef_sc_hd__decap_12
XFILLER_190_1315 VGND VGND VPWR VPWR sky130_fd_sc_hd__fill_1
XFILLER_7_1201 VGND VGND VPWR VPWR sky130_fd_sc_hd__decap_3
XFILLER_135_81 VPWR VGND VPWR VGND sky130_ef_sc_hd__decap_12
XFILLER_0_150 VGND VGND VPWR VPWR sky130_fd_sc_hd__decap_4
XFILLER_1_673 VGND VGND VPWR VPWR sky130_fd_sc_hd__fill_1
XFILLER_1_684 VGND VGND VPWR VPWR sky130_fd_sc_hd__fill_1
XFILLER_7_1245 VPWR VGND VPWR VGND sky130_ef_sc_hd__decap_12
XTAP_TAPCELL_ROW_162_2_4034 VGND VPWR sky130_fd_sc_hd__tapvpwrvgnd_1
XFILLER_0_194 VGND VGND VPWR VPWR sky130_fd_sc_hd__fill_2
XFILLER_48_121 VGND VGND VPWR VPWR sky130_fd_sc_hd__decap_6
XFILLER_209_447 VGND VGND VPWR VPWR sky130_fd_sc_hd__fill_1
XFILLER_7_1289 VPWR VGND VPWR VGND sky130_ef_sc_hd__decap_12
XFILLER_218_981 VPWR VGND VPWR VGND sky130_ef_sc_hd__decap_12
XFILLER_131_1490 VGND VGND VPWR VPWR sky130_fd_sc_hd__decap_6
XFILLER_63_113 VPWR VGND VPWR VGND sky130_ef_sc_hd__decap_12
XTAP_TAPCELL_ROW_21_1_1060 VGND VPWR sky130_fd_sc_hd__tapvpwrvgnd_1
XFILLER_205_653 VPWR VGND VPWR VGND sky130_ef_sc_hd__decap_12
XFILLER_204_141 VPWR VGND VPWR VGND sky130_ef_sc_hd__decap_12
XFILLER_166_1553 VPWR VGND VPWR VGND sky130_ef_sc_hd__decap_12
XFILLER_162_1406 VGND VGND VPWR VPWR sky130_fd_sc_hd__decap_6
XFILLER_205_697 VPWR VGND VPWR VGND sky130_ef_sc_hd__decap_12
XFILLER_177_505 VPWR VGND VPWR VGND sky130_ef_sc_hd__decap_12
XFILLER_166_1597 VGND VGND VPWR VPWR sky130_fd_sc_hd__decap_8
X_569_ clknet_3_0_0_clk _007_ VGND VGND VPWR VPWR u_ctrl.cmp_addr\[1\] sky130_fd_sc_hd__dfxtp_1
XFILLER_207_1561 VGND VGND VPWR VPWR sky130_fd_sc_hd__decap_6
XANTENNA__463__A net148 VGND VGND VPWR VPWR sky130_fd_sc_hd__diode_2
XFILLER_203_1425 VPWR VGND VPWR VGND sky130_ef_sc_hd__decap_12
XFILLER_125_1272 VGND VGND VPWR VPWR sky130_fd_sc_hd__fill_1
XTAP_TAPCELL_ROW_108_2_3678 VGND VPWR sky130_fd_sc_hd__tapvpwrvgnd_1
XFILLER_74_3 VPWR VGND VPWR VGND sky130_ef_sc_hd__decap_12
XFILLER_203_1469 VPWR VGND VPWR VGND sky130_ef_sc_hd__decap_12
XTAP_TAPCELL_ROW_191_2190 VGND VPWR sky130_fd_sc_hd__tapvpwrvgnd_1
XFILLER_173_777 VGND VGND VPWR VPWR sky130_fd_sc_hd__decap_6
XFILLER_172_221 VPWR VGND VPWR VGND sky130_ef_sc_hd__decap_12
XTAP_TAPCELL_ROW_212_2772 VGND VPWR sky130_fd_sc_hd__tapvpwrvgnd_1
XFILLER_172_265 VPWR VGND VPWR VGND sky130_ef_sc_hd__decap_12
XTAP_TAPCELL_ROW_212_2794 VGND VPWR sky130_fd_sc_hd__tapvpwrvgnd_1
XTAP_TAPCELL_ROW_212_2783 VGND VPWR sky130_fd_sc_hd__tapvpwrvgnd_1
XFILLER_173_1513 VPWR VGND VPWR VGND sky130_ef_sc_hd__decap_12
XTAP_TAPCELL_ROW_56_2_3343 VGND VPWR sky130_fd_sc_hd__tapvpwrvgnd_1
XFILLER_5_83 VPWR VGND VPWR VGND sky130_ef_sc_hd__decap_12
XFILLER_214_1521 VPWR VGND VPWR VGND sky130_ef_sc_hd__decap_12
XFILLER_214_1565 VPWR VGND VPWR VGND sky130_ef_sc_hd__decap_12
XFILLER_171_1281 VGND VGND VPWR VPWR sky130_fd_sc_hd__decap_6
XFILLER_132_1232 VPWR VGND VPWR VGND sky130_ef_sc_hd__decap_12
XFILLER_210_1429 VPWR VGND VPWR VGND sky130_ef_sc_hd__decap_12
XFILLER_215_417 VPWR VGND VPWR VGND sky130_ef_sc_hd__decap_12
XFILLER_131_39 VPWR VGND VPWR VGND sky130_ef_sc_hd__decap_12
XTAP_TAPCELL_ROW_206_2598 VGND VPWR sky130_fd_sc_hd__tapvpwrvgnd_1
XFILLER_110_1574 VGND VGND VPWR VPWR sky130_fd_sc_hd__decap_6
XTAP_TAPCELL_ROW_198_2377 VGND VPWR sky130_fd_sc_hd__tapvpwrvgnd_1
XFILLER_24_15 VGND VGND VPWR VPWR sky130_fd_sc_hd__fill_1
XTAP_TAPCELL_ROW_198_2388 VGND VPWR sky130_fd_sc_hd__tapvpwrvgnd_1
XFILLER_196_825 VPWR VGND VPWR VGND sky130_ef_sc_hd__decap_12
XFILLER_180_1539 VGND VGND VPWR VPWR sky130_fd_sc_hd__fill_1
XFILLER_165_1063 VGND VGND VPWR VPWR sky130_fd_sc_hd__fill_1
XPHY_EDGE_ROW_127_1_Right_713 VGND VGND VPWR VPWR sky130_fd_sc_hd__decap_3
XFILLER_210_133 VGND VGND VPWR VPWR sky130_fd_sc_hd__decap_6
XFILLER_196_869 VPWR VGND VPWR VGND sky130_ef_sc_hd__decap_12
XFILLER_195_335 VGND VGND VPWR VPWR sky130_fd_sc_hd__fill_1
XFILLER_17_1342 VPWR VGND VPWR VGND sky130_ef_sc_hd__decap_12
XFILLER_210_177 VPWR VGND VPWR VGND sky130_ef_sc_hd__decap_12
XFILLER_206_1093 VPWR VGND VPWR VGND sky130_ef_sc_hd__decap_12
XFILLER_108_1470 VPWR VGND VPWR VGND sky130_ef_sc_hd__decap_12
XFILLER_17_1386 VPWR VGND VPWR VGND sky130_ef_sc_hd__decap_12
XFILLER_52_1244 VGND VGND VPWR VPWR sky130_fd_sc_hd__fill_1
XFILLER_104_1356 VGND VGND VPWR VPWR sky130_fd_sc_hd__fill_1
XFILLER_191_541 VPWR VGND VPWR VGND sky130_ef_sc_hd__decap_12
XFILLER_164_755 VGND VGND VPWR VPWR sky130_fd_sc_hd__fill_1
XFILLER_163_221 VGND VGND VPWR VPWR sky130_fd_sc_hd__decap_3
XFILLER_191_585 VPWR VGND VPWR VGND sky130_ef_sc_hd__decap_12
XFILLER_163_265 VPWR VGND VPWR VGND sky130_ef_sc_hd__decap_12
XTAP_TAPCELL_ROW_153_2_3971 VGND VPWR sky130_fd_sc_hd__tapvpwrvgnd_1
XTAP_TAPCELL_ROW_170_1595 VGND VPWR sky130_fd_sc_hd__tapvpwrvgnd_1
XTAP_TAPCELL_ROW_170_1584 VGND VPWR sky130_fd_sc_hd__tapvpwrvgnd_1
XTAP_TAPCELL_ROW_170_1573 VGND VPWR sky130_fd_sc_hd__tapvpwrvgnd_1
XFILLER_219_701 VPWR VGND VPWR VGND sky130_ef_sc_hd__decap_12
XFILLER_24_1302 VPWR VGND VPWR VGND sky130_ef_sc_hd__decap_12
XFILLER_105_51 VGND VGND VPWR VPWR sky130_fd_sc_hd__decap_4
XFILLER_63_1384 VGND VGND VPWR VPWR sky130_fd_sc_hd__fill_1
XFILLER_28_1482 VPWR VGND VPWR VGND sky130_ef_sc_hd__decap_12
XFILLER_218_233 VPWR VGND VPWR VGND sky130_ef_sc_hd__decap_12
XTAP_TAPCELL_ROW_183_1967 VGND VPWR sky130_fd_sc_hd__tapvpwrvgnd_1
XTAP_TAPCELL_ROW_183_1956 VGND VPWR sky130_fd_sc_hd__tapvpwrvgnd_1
XTAP_TAPCELL_ROW_183_1945 VGND VPWR sky130_fd_sc_hd__tapvpwrvgnd_1
XTAP_TAPCELL_ROW_145_2_3919 VGND VPWR sky130_fd_sc_hd__tapvpwrvgnd_1
XFILLER_115_1496 VGND VGND VPWR VPWR sky130_fd_sc_hd__fill_1
XFILLER_98_1414 VPWR VGND VPWR VGND sky130_ef_sc_hd__decap_12
XFILLER_4_1429 VPWR VGND VPWR VGND sky130_ef_sc_hd__decap_12
XFILLER_218_277 VPWR VGND VPWR VGND sky130_ef_sc_hd__decap_12
XFILLER_65_55 VGND VGND VPWR VPWR sky130_fd_sc_hd__fill_1
XFILLER_45_113 VPWR VGND VPWR VGND sky130_ef_sc_hd__decap_12
XFILLER_215_951 VGND VGND VPWR VPWR sky130_fd_sc_hd__fill_1
XFILLER_202_601 VPWR VGND VPWR VGND sky130_ef_sc_hd__decap_12
XFILLER_199_641 VPWR VGND VPWR VGND sky130_ef_sc_hd__decap_12
XFILLER_2_1197 VGND VGND VPWR VPWR sky130_fd_sc_hd__decap_6
X_423_ b_addr\[6\] _084_ _103_ VGND VGND VPWR VPWR _157_ sky130_fd_sc_hd__and3_1
XFILLER_201_111 VGND VGND VPWR VPWR sky130_fd_sc_hd__fill_1
XFILLER_199_685 VPWR VGND VPWR VGND sky130_ef_sc_hd__decap_12
XFILLER_148_1294 VGND VGND VPWR VPWR sky130_fd_sc_hd__decap_6
XFILLER_202_645 VPWR VGND VPWR VGND sky130_ef_sc_hd__decap_12
XFILLER_198_195 VGND VGND VPWR VPWR sky130_fd_sc_hd__fill_1
XFILLER_109_1256 VPWR VGND VPWR VGND sky130_ef_sc_hd__decap_12
XFILLER_70_1300 VGND VGND VPWR VPWR sky130_fd_sc_hd__fill_1
X_354_ net152 _075_ VGND VGND VPWR VPWR _098_ sky130_fd_sc_hd__nand2_1
XFILLER_35_1442 VPWR VGND VPWR VGND sky130_ef_sc_hd__decap_12
XFILLER_186_357 VGND VGND VPWR VPWR sky130_fd_sc_hd__decap_6
XFILLER_122_1412 VGND VGND VPWR VPWR sky130_fd_sc_hd__fill_1
X_285_ _076_ _082_ net155 VGND VGND VPWR VPWR _002_ sky130_fd_sc_hd__a21boi_1
XFILLER_31_1328 VGND VGND VPWR VPWR sky130_fd_sc_hd__fill_1
XFILLER_170_725 VPWR VGND VPWR VGND sky130_ef_sc_hd__decap_12
XTAP_TAPCELL_ROW_42_2_3251 VGND VPWR sky130_fd_sc_hd__tapvpwrvgnd_1
XFILLER_170_769 VPWR VGND VPWR VGND sky130_ef_sc_hd__decap_12
XFILLER_155_1232 VPWR VGND VPWR VGND sky130_ef_sc_hd__decap_12
XFILLER_155_1298 VPWR VGND VPWR VGND sky130_ef_sc_hd__decap_12
XFILLER_81_1440 VGND VGND VPWR VPWR sky130_fd_sc_hd__fill_1
XFILLER_2_993 VPWR VGND VPWR VGND sky130_ef_sc_hd__decap_12
XFILLER_29_1268 VGND VGND VPWR VPWR sky130_fd_sc_hd__decap_4
XFILLER_133_1552 VGND VGND VPWR VPWR sky130_fd_sc_hd__fill_1
XFILLER_1_481 VGND VGND VPWR VPWR sky130_fd_sc_hd__fill_2
XFILLER_46_1582 VPWR VGND VPWR VGND sky130_ef_sc_hd__decap_12
XFILLER_42_1468 VGND VGND VPWR VPWR sky130_fd_sc_hd__fill_1
Xinput7 func_addr[4] VGND VGND VPWR VPWR net7 sky130_fd_sc_hd__clkbuf_1
XFILLER_188_1085 VGND VGND VPWR VPWR sky130_fd_sc_hd__decap_6
XFILLER_206_973 VGND VGND VPWR VPWR sky130_fd_sc_hd__decap_6
XTAP_TAPCELL_ROW_52_1_1121 VGND VPWR sky130_fd_sc_hd__tapvpwrvgnd_1
XFILLER_205_461 VPWR VGND VPWR VGND sky130_ef_sc_hd__decap_12
XTAP_TAPCELL_ROW_201_2473 VGND VPWR sky130_fd_sc_hd__tapvpwrvgnd_1
XTAP_TAPCELL_ROW_201_2462 VGND VPWR sky130_fd_sc_hd__tapvpwrvgnd_1
XFILLER_178_825 VPWR VGND VPWR VGND sky130_ef_sc_hd__decap_12
XFILLER_75_1244 VPWR VGND VPWR VGND sky130_ef_sc_hd__decap_12
XTAP_TAPCELL_ROW_193_2241 VGND VPWR sky130_fd_sc_hd__tapvpwrvgnd_1
XTAP_TAPCELL_ROW_193_2230 VGND VPWR sky130_fd_sc_hd__tapvpwrvgnd_1
XFILLER_178_869 VPWR VGND VPWR VGND sky130_ef_sc_hd__decap_12
XFILLER_177_335 VGND VGND VPWR VPWR sky130_fd_sc_hd__fill_1
XFILLER_162_1258 VPWR VGND VPWR VGND sky130_ef_sc_hd__decap_12
XFILLER_127_1378 VGND VGND VPWR VPWR sky130_fd_sc_hd__decap_6
XFILLER_92_1580 VGND VGND VPWR VPWR sky130_fd_sc_hd__fill_1
XFILLER_203_1233 VPWR VGND VPWR VGND sky130_ef_sc_hd__decap_12
XTAP_TAPCELL_ROW_193_2252 VGND VPWR sky130_fd_sc_hd__tapvpwrvgnd_1
XANTENNA__509__B1 net135 VGND VGND VPWR VPWR sky130_fd_sc_hd__diode_2
XFILLER_193_839 VGND VGND VPWR VPWR sky130_fd_sc_hd__fill_1
XFILLER_14_1526 VPWR VGND VPWR VGND sky130_ef_sc_hd__decap_12
XTAP_TAPCELL_ROW_214_2845 VGND VPWR sky130_fd_sc_hd__tapvpwrvgnd_1
XTAP_TAPCELL_ROW_214_2834 VGND VPWR sky130_fd_sc_hd__tapvpwrvgnd_1
XFILLER_195_1001 VGND VGND VPWR VPWR sky130_fd_sc_hd__decap_6
XFILLER_173_541 VPWR VGND VPWR VGND sky130_ef_sc_hd__decap_12
XTAP_TAPCELL_ROW_138_2_3873 VGND VPWR sky130_fd_sc_hd__tapvpwrvgnd_1
XFILLER_195_1045 VPWR VGND VPWR VGND sky130_ef_sc_hd__decap_12
XFILLER_173_585 VPWR VGND VPWR VGND sky130_ef_sc_hd__decap_12
XFILLER_195_1089 VPWR VGND VPWR VGND sky130_ef_sc_hd__decap_12
XFILLER_12_1294 VGND VGND VPWR VPWR sky130_fd_sc_hd__decap_6
XTAP_TAPCELL_ROW_187_2067 VGND VPWR sky130_fd_sc_hd__tapvpwrvgnd_1
XTAP_TAPCELL_ROW_187_2056 VGND VPWR sky130_fd_sc_hd__tapvpwrvgnd_1
XFILLER_173_1343 VGND VGND VPWR VPWR sky130_fd_sc_hd__fill_1
XTAP_TAPCELL_ROW_187_2078 VGND VPWR sky130_fd_sc_hd__tapvpwrvgnd_1
XFILLER_134_1338 VPWR VGND VPWR VGND sky130_ef_sc_hd__decap_12
XFILLER_206_83 VGND VGND VPWR VPWR sky130_fd_sc_hd__fill_1
XTAP_TAPCELL_ROW_131_2_3827 VGND VPWR sky130_fd_sc_hd__tapvpwrvgnd_1
XFILLER_19_15 VPWR VGND VPWR VGND sky130_ef_sc_hd__decap_12
XFILLER_60_1524 VGND VGND VPWR VPWR sky130_fd_sc_hd__fill_1
XFILLER_214_1373 VPWR VGND VPWR VGND sky130_ef_sc_hd__decap_12
XFILLER_142_27 VGND VGND VPWR VPWR sky130_fd_sc_hd__fill_1
XFILLER_210_1259 VGND VGND VPWR VPWR sky130_fd_sc_hd__fill_1
XFILLER_27_113 VPWR VGND VPWR VGND sky130_ef_sc_hd__decap_12
XFILLER_216_737 VPWR VGND VPWR VGND sky130_ef_sc_hd__decap_12
XFILLER_215_225 VPWR VGND VPWR VGND sky130_ef_sc_hd__decap_12
XFILLER_167_1169 VGND VGND VPWR VPWR sky130_fd_sc_hd__decap_6
XFILLER_110_1382 VPWR VGND VPWR VGND sky130_ef_sc_hd__decap_12
XFILLER_93_1322 VGND VGND VPWR VPWR sky130_fd_sc_hd__decap_6
XTAP_TAPCELL_ROW_86_1_1189 VGND VPWR sky130_fd_sc_hd__tapvpwrvgnd_1
XFILLER_184_1483 VGND VGND VPWR VPWR sky130_fd_sc_hd__fill_1
XFILLER_145_1434 VGND VGND VPWR VPWR sky130_fd_sc_hd__decap_6
XFILLER_93_1366 VPWR VGND VPWR VGND sky130_ef_sc_hd__decap_12
XFILLER_35_69 VPWR VGND VPWR VGND sky130_ef_sc_hd__decap_12
XPHY_EDGE_ROW_128_1_Right_714 VGND VGND VPWR VPWR sky130_fd_sc_hd__decap_3
XFILLER_168_357 VGND VGND VPWR VPWR sky130_fd_sc_hd__decap_6
XFILLER_145_1478 VPWR VGND VPWR VGND sky130_ef_sc_hd__decap_12
XFILLER_211_497 VGND VGND VPWR VPWR sky130_fd_sc_hd__decap_6
XFILLER_196_699 VGND VGND VPWR VPWR sky130_fd_sc_hd__fill_1
XFILLER_183_305 VPWR VGND VPWR VGND sky130_ef_sc_hd__decap_12
XTAP_TAPCELL_ROW_176_1760 VGND VPWR sky130_fd_sc_hd__tapvpwrvgnd_1
XFILLER_51_57 VPWR VGND VPWR VGND sky130_ef_sc_hd__decap_12
XFILLER_192_861 VGND VGND VPWR VPWR sky130_fd_sc_hd__decap_6
XFILLER_183_349 VPWR VGND VPWR VGND sky130_ef_sc_hd__decap_12
XTAP_TAPCELL_ROW_172_1646 VGND VPWR sky130_fd_sc_hd__tapvpwrvgnd_1
XTAP_TAPCELL_ROW_172_1635 VGND VPWR sky130_fd_sc_hd__tapvpwrvgnd_1
XFILLER_167_57 VPWR VGND VPWR VGND sky130_ef_sc_hd__decap_12
XTAP_TAPCELL_ROW_27_2_3153 VGND VPWR sky130_fd_sc_hd__tapvpwrvgnd_1
XFILLER_30_1350 VGND VGND VPWR VPWR sky130_fd_sc_hd__decap_6
XFILLER_191_393 VPWR VGND VPWR VGND sky130_ef_sc_hd__decap_12
XFILLER_174_1129 VPWR VGND VPWR VGND sky130_ef_sc_hd__decap_12
XFILLER_30_1394 VPWR VGND VPWR VGND sky130_ef_sc_hd__decap_12
XFILLER_219_1273 VPWR VGND VPWR VGND sky130_ef_sc_hd__decap_12
XFILLER_4_3 VPWR VGND VPWR VGND sky130_ef_sc_hd__decap_12
XFILLER_156_1574 VGND VGND VPWR VPWR sky130_fd_sc_hd__decap_6
XFILLER_152_1438 VPWR VGND VPWR VGND sky130_ef_sc_hd__decap_12
XFILLER_116_83 VGND VGND VPWR VPWR sky130_fd_sc_hd__fill_1
XFILLER_76_65 VPWR VGND VPWR VGND sky130_ef_sc_hd__decap_12
XTAP_TAPCELL_ROW_20_2_3107 VGND VPWR sky130_fd_sc_hd__tapvpwrvgnd_1
XFILLER_98_1244 VGND VGND VPWR VPWR sky130_fd_sc_hd__fill_1
XFILLER_4_1259 VGND VGND VPWR VPWR sky130_fd_sc_hd__fill_1
XFILLER_18_124 VGND VGND VPWR VPWR sky130_fd_sc_hd__fill_1
XFILLER_185_1225 VGND VGND VPWR VPWR sky130_fd_sc_hd__decap_6
XTAP_TAPCELL_ROW_133_1_1284 VGND VPWR sky130_fd_sc_hd__tapvpwrvgnd_1
XPHY_EDGE_ROW_90_1_Right_676 VGND VGND VPWR VPWR sky130_fd_sc_hd__decap_3
XPHY_EDGE_ROW_32_1_Left_251 VGND VGND VPWR VPWR sky130_fd_sc_hd__decap_3
XFILLER_41_1490 VGND VGND VPWR VPWR sky130_fd_sc_hd__decap_6
XFILLER_185_1269 VPWR VGND VPWR VGND sky130_ef_sc_hd__decap_12
XFILLER_92_53 VPWR VGND VPWR VGND sky130_ef_sc_hd__decap_12
XFILLER_203_921 VPWR VGND VPWR VGND sky130_ef_sc_hd__decap_12
XFILLER_92_97 VPWR VGND VPWR VGND sky130_ef_sc_hd__decap_12
XFILLER_72_1406 VGND VGND VPWR VPWR sky130_fd_sc_hd__decap_6
XFILLER_203_965 VPWR VGND VPWR VGND sky130_ef_sc_hd__decap_12
XFILLER_186_121 VPWR VGND VPWR VGND sky130_ef_sc_hd__decap_12
X_406_ b_addr\[3\] b_addr\[2\] _104_ VGND VGND VPWR VPWR _142_ sky130_fd_sc_hd__o21ai_1
XFILLER_202_475 VGND VGND VPWR VPWR sky130_fd_sc_hd__fill_1
XFILLER_124_1518 VGND VGND VPWR VPWR sky130_fd_sc_hd__decap_6
X_337_ net152 net155 _081_ VGND VGND VPWR VPWR _000_ sky130_fd_sc_hd__and3_1
XFILLER_204_1553 VPWR VGND VPWR VGND sky130_ef_sc_hd__decap_12
XFILLER_186_165 VPWR VGND VPWR VGND sky130_ef_sc_hd__decap_12
XFILLER_179_1007 VGND VGND VPWR VPWR sky130_fd_sc_hd__fill_1
XFILLER_175_839 VGND VGND VPWR VPWR sky130_fd_sc_hd__fill_1
XTAP_TAPCELL_ROW_124_2_3781 VGND VPWR sky130_fd_sc_hd__tapvpwrvgnd_1
XFILLER_122_1220 VPWR VGND VPWR VGND sky130_ef_sc_hd__decap_12
XFILLER_35_1272 VGND VGND VPWR VPWR sky130_fd_sc_hd__fill_1
XFILLER_204_1597 VGND VGND VPWR VPWR sky130_fd_sc_hd__decap_8
XFILLER_6_562 VPWR VGND VPWR VGND sky130_ef_sc_hd__decap_12
XFILLER_196_1365 VGND VGND VPWR VPWR sky130_fd_sc_hd__decap_6
XFILLER_192_1229 VPWR VGND VPWR VGND sky130_ef_sc_hd__decap_12
XFILLER_170_533 VPWR VGND VPWR VGND sky130_ef_sc_hd__decap_12
XFILLER_100_1562 VPWR VGND VPWR VGND sky130_ef_sc_hd__decap_12
XFILLER_83_1546 VGND VGND VPWR VPWR sky130_fd_sc_hd__decap_6
XFILLER_37_3 VPWR VGND VPWR VGND sky130_ef_sc_hd__decap_12
XTAP_TAPCELL_ROW_116_2_3729 VGND VPWR sky130_fd_sc_hd__tapvpwrvgnd_1
XFILLER_110_121 VGND VGND VPWR VPWR sky130_fd_sc_hd__decap_6
XFILLER_211_1513 VPWR VGND VPWR VGND sky130_ef_sc_hd__decap_12
XFILLER_42_1232 VPWR VGND VPWR VGND sky130_ef_sc_hd__decap_12
XTAP_TAPCELL_ROW_203_2535 VGND VPWR sky130_fd_sc_hd__tapvpwrvgnd_1
XTAP_TAPCELL_ROW_203_2524 VGND VPWR sky130_fd_sc_hd__tapvpwrvgnd_1
XTAP_TAPCELL_ROW_203_2513 VGND VPWR sky130_fd_sc_hd__tapvpwrvgnd_1
XFILLER_77_1328 VGND VGND VPWR VPWR sky130_fd_sc_hd__fill_1
XFILLER_164_1309 VGND VGND VPWR VPWR sky130_fd_sc_hd__decap_6
XFILLER_20_1574 VGND VGND VPWR VPWR sky130_fd_sc_hd__decap_6
XFILLER_213_729 VPWR VGND VPWR VGND sky130_ef_sc_hd__decap_12
XFILLER_206_781 VPWR VGND VPWR VGND sky130_ef_sc_hd__decap_12
XTAP_TAPCELL_ROW_195_2303 VGND VPWR sky130_fd_sc_hd__tapvpwrvgnd_1
XFILLER_90_1506 VPWR VGND VPWR VGND sky130_ef_sc_hd__decap_12
XTAP_TAPCELL_ROW_216_2907 VGND VPWR sky130_fd_sc_hd__tapvpwrvgnd_1
XTAP_TAPCELL_ROW_9_2_3037 VGND VPWR sky130_fd_sc_hd__tapvpwrvgnd_1
XFILLER_178_699 VGND VGND VPWR VPWR sky130_fd_sc_hd__fill_1
XFILLER_165_305 VPWR VGND VPWR VGND sky130_ef_sc_hd__decap_12
XFILLER_105_1440 VGND VGND VPWR VPWR sky130_fd_sc_hd__fill_1
XANTENNA_fanout131_A _087_ VGND VGND VPWR VPWR sky130_fd_sc_hd__diode_2
XFILLER_18_1470 VPWR VGND VPWR VGND sky130_ef_sc_hd__decap_12
XFILLER_203_1063 VGND VGND VPWR VPWR sky130_fd_sc_hd__fill_1
XFILLER_181_809 VPWR VGND VPWR VGND sky130_ef_sc_hd__decap_12
XFILLER_165_349 VPWR VGND VPWR VGND sky130_ef_sc_hd__decap_12
XTAP_TAPCELL_ROW_13_2_3061 VGND VPWR sky130_fd_sc_hd__tapvpwrvgnd_1
XFILLER_14_1356 VGND VGND VPWR VPWR sky130_fd_sc_hd__fill_1
XTAP_TAPCELL_ROW_189_2118 VGND VPWR sky130_fd_sc_hd__tapvpwrvgnd_1
XFILLER_174_861 VGND VGND VPWR VPWR sky130_fd_sc_hd__decap_6
XFILLER_137_27 VPWR VGND VPWR VGND sky130_ef_sc_hd__decap_12
XTAP_TAPCELL_ROW_189_2129 VGND VPWR sky130_fd_sc_hd__tapvpwrvgnd_1
XFILLER_173_393 VPWR VGND VPWR VGND sky130_ef_sc_hd__decap_12
XFILLER_88_1468 VGND VGND VPWR VPWR sky130_fd_sc_hd__fill_1
XFILLER_175_1449 VGND VGND VPWR VPWR sky130_fd_sc_hd__decap_6
XPHY_EDGE_ROW_160_1_Left_379 VGND VGND VPWR VPWR sky130_fd_sc_hd__decap_3
XFILLER_217_93 VPWR VGND VPWR VGND sky130_ef_sc_hd__decap_12
XFILLER_153_15 VPWR VGND VPWR VGND sky130_ef_sc_hd__decap_12
XFILLER_138_1282 VPWR VGND VPWR VGND sky130_ef_sc_hd__decap_12
XFILLER_5_1513 VPWR VGND VPWR VGND sky130_ef_sc_hd__decap_12
XFILLER_216_501 VPWR VGND VPWR VGND sky130_ef_sc_hd__decap_12
XTAP_TAPCELL_ROW_165_1450 VGND VPWR sky130_fd_sc_hd__tapvpwrvgnd_1
XFILLER_116_1580 VGND VGND VPWR VPWR sky130_fd_sc_hd__fill_1
XFILLER_25_1496 VGND VGND VPWR VPWR sky130_fd_sc_hd__fill_1
XFILLER_216_545 VPWR VGND VPWR VGND sky130_ef_sc_hd__decap_12
XFILLER_189_909 VPWR VGND VPWR VGND sky130_ef_sc_hd__decap_12
XFILLER_3_1281 VGND VGND VPWR VPWR sky130_fd_sc_hd__decap_6
XFILLER_216_589 VPWR VGND VPWR VGND sky130_ef_sc_hd__decap_12
XFILLER_203_217 VGND VGND VPWR VPWR sky130_fd_sc_hd__decap_6
XFILLER_188_419 VGND VGND VPWR VPWR sky130_fd_sc_hd__fill_1
XFILLER_186_1589 VGND VGND VPWR VPWR sky130_fd_sc_hd__decap_6
XFILLER_182_1409 VPWR VGND VPWR VGND sky130_ef_sc_hd__decap_12
XTAP_TAPCELL_ROW_178_1800 VGND VPWR sky130_fd_sc_hd__tapvpwrvgnd_1
XFILLER_102_41 VPWR VGND VPWR VGND sky130_ef_sc_hd__decap_12
XANTENNA_clkbuf_3_7_0_clk_X clknet_3_7_0_clk VGND VGND VPWR VPWR sky130_fd_sc_hd__diode_2
XFILLER_197_953 VPWR VGND VPWR VGND sky130_ef_sc_hd__decap_12
XTAP_TAPCELL_ROW_178_1822 VGND VPWR sky130_fd_sc_hd__tapvpwrvgnd_1
XTAP_TAPCELL_ROW_178_1811 VGND VPWR sky130_fd_sc_hd__tapvpwrvgnd_1
XFILLER_145_1220 VPWR VGND VPWR VGND sky130_ef_sc_hd__decap_12
XFILLER_102_85 VPWR VGND VPWR VGND sky130_ef_sc_hd__decap_12
XFILLER_58_1294 VGND VGND VPWR VPWR sky130_fd_sc_hd__decap_6
XFILLER_211_261 VPWR VGND VPWR VGND sky130_ef_sc_hd__decap_12
XFILLER_168_121 VPWR VGND VPWR VGND sky130_ef_sc_hd__decap_12
XFILLER_141_3 VPWR VGND VPWR VGND sky130_ef_sc_hd__decap_12
XFILLER_19_1256 VPWR VGND VPWR VGND sky130_ef_sc_hd__decap_12
XFILLER_184_625 VPWR VGND VPWR VGND sky130_ef_sc_hd__decap_12
XFILLER_183_113 VPWR VGND VPWR VGND sky130_ef_sc_hd__decap_12
XTAP_TAPCELL_ROW_174_1708 VGND VPWR sky130_fd_sc_hd__tapvpwrvgnd_1
XFILLER_168_165 VPWR VGND VPWR VGND sky130_ef_sc_hd__decap_12
XFILLER_145_1286 VPWR VGND VPWR VGND sky130_ef_sc_hd__decap_12
XPHY_EDGE_ROW_133_2_Right_190 VGND VGND VPWR VPWR sky130_fd_sc_hd__decap_3
XPHY_EDGE_ROW_129_1_Right_715 VGND VGND VPWR VPWR sky130_fd_sc_hd__decap_3
XFILLER_32_1412 VGND VGND VPWR VPWR sky130_fd_sc_hd__fill_1
XFILLER_200_979 VGND VGND VPWR VPWR sky130_fd_sc_hd__fill_1
XFILLER_184_669 VPWR VGND VPWR VGND sky130_ef_sc_hd__decap_12
XTAP_TAPCELL_ROW_109_1_1235 VGND VPWR sky130_fd_sc_hd__tapvpwrvgnd_1
XFILLER_7_29 VPWR VGND VPWR VGND sky130_ef_sc_hd__decap_12
XANTENNA__561__A net136 VGND VGND VPWR VPWR sky130_fd_sc_hd__diode_2
XTAP_TAPCELL_ROW_14_1_1046 VGND VPWR sky130_fd_sc_hd__tapvpwrvgnd_1
XFILLER_193_1505 VGND VGND VPWR VPWR sky130_fd_sc_hd__decap_6
XFILLER_178_1073 VPWR VGND VPWR VGND sky130_ef_sc_hd__decap_12
XANTENNA__280__B b_addr\[2\] VGND VGND VPWR VPWR sky130_fd_sc_hd__diode_2
XFILLER_194_77 VGND VGND VPWR VPWR sky130_fd_sc_hd__decap_6
XFILLER_193_1549 VPWR VGND VPWR VGND sky130_ef_sc_hd__decap_12
XFILLER_3_532 VGND VGND VPWR VPWR sky130_fd_sc_hd__fill_1
XFILLER_127_93 VPWR VGND VPWR VGND sky130_ef_sc_hd__decap_12
XFILLER_117_1322 VGND VGND VPWR VPWR sky130_fd_sc_hd__decap_6
XFILLER_65_1232 VPWR VGND VPWR VGND sky130_ef_sc_hd__decap_12
XFILLER_156_1382 VPWR VGND VPWR VGND sky130_ef_sc_hd__decap_12
XFILLER_152_1246 VPWR VGND VPWR VGND sky130_ef_sc_hd__decap_12
XFILLER_117_1366 VPWR VGND VPWR VGND sky130_ef_sc_hd__decap_12
XFILLER_65_1298 VPWR VGND VPWR VGND sky130_ef_sc_hd__decap_12
XFILLER_43_1552 VGND VGND VPWR VPWR sky130_fd_sc_hd__fill_1
XFILLER_219_361 VGND VGND VPWR VPWR sky130_fd_sc_hd__decap_3
XFILLER_143_81 VPWR VGND VPWR VGND sky130_ef_sc_hd__decap_12
XTAP_TAPCELL_ROW_50_2_3302 VGND VPWR sky130_fd_sc_hd__tapvpwrvgnd_1
XFILLER_185_1033 VPWR VGND VPWR VGND sky130_ef_sc_hd__decap_12
XFILLER_185_1077 VPWR VGND VPWR VGND sky130_ef_sc_hd__decap_12
XPHY_EDGE_ROW_91_1_Right_677 VGND VGND VPWR VPWR sky130_fd_sc_hd__decap_3
XFILLER_76_1350 VGND VGND VPWR VPWR sky130_fd_sc_hd__decap_6
XTAP_TAPCELL_ROW_18_2_3098 VGND VPWR sky130_fd_sc_hd__tapvpwrvgnd_1
XFILLER_187_441 VGND VGND VPWR VPWR sky130_fd_sc_hd__decap_6
XFILLER_128_1462 VGND VGND VPWR VPWR sky130_fd_sc_hd__decap_6
XFILLER_124_1326 VPWR VGND VPWR VGND sky130_ef_sc_hd__decap_12
XFILLER_76_1394 VPWR VGND VPWR VGND sky130_ef_sc_hd__decap_12
XFILLER_72_1258 VPWR VGND VPWR VGND sky130_ef_sc_hd__decap_12
XFILLER_37_1378 VGND VGND VPWR VPWR sky130_fd_sc_hd__decap_6
XFILLER_187_485 VPWR VGND VPWR VGND sky130_ef_sc_hd__decap_12
XFILLER_163_1397 VGND VGND VPWR VPWR sky130_fd_sc_hd__decap_3
XFILLER_200_1203 VGND VGND VPWR VPWR sky130_fd_sc_hd__fill_1
XFILLER_198_1427 VGND VGND VPWR VPWR sky130_fd_sc_hd__fill_1
XFILLER_163_809 VGND VGND VPWR VPWR sky130_fd_sc_hd__decap_3
XFILLER_102_1602 VGND VGND VPWR VPWR sky130_fd_sc_hd__decap_3
Xinput21 func_wdata[18] VGND VGND VPWR VPWR net21 sky130_fd_sc_hd__clkbuf_1
Xinput10 func_addr[7] VGND VGND VPWR VPWR net10 sky130_fd_sc_hd__clkbuf_1
XANTENNA__471__A _174_ VGND VGND VPWR VPWR sky130_fd_sc_hd__diode_2
Xinput32 func_wdata[28] VGND VGND VPWR VPWR net32 sky130_fd_sc_hd__clkbuf_1
Xinput43 func_wdata[9] VGND VGND VPWR VPWR net43 sky130_fd_sc_hd__clkbuf_1
XFILLER_196_1173 VPWR VGND VPWR VGND sky130_ef_sc_hd__decap_12
XFILLER_7_893 VGND VGND VPWR VPWR sky130_fd_sc_hd__decap_3
XFILLER_192_1037 VPWR VGND VPWR VGND sky130_ef_sc_hd__decap_12
XFILLER_171_853 VPWR VGND VPWR VGND sky130_ef_sc_hd__decap_12
XFILLER_100_1370 VPWR VGND VPWR VGND sky130_ef_sc_hd__decap_12
XFILLER_83_1310 VPWR VGND VPWR VGND sky130_ef_sc_hd__decap_12
XFILLER_171_897 VPWR VGND VPWR VGND sky130_ef_sc_hd__decap_12
XFILLER_170_363 VGND VGND VPWR VPWR sky130_fd_sc_hd__fill_1
XFILLER_87_1490 VGND VGND VPWR VPWR sky130_fd_sc_hd__decap_6
XFILLER_83_1354 VPWR VGND VPWR VGND sky130_ef_sc_hd__decap_12
XTAP_TAPCELL_ROW_209_2700 VGND VPWR sky130_fd_sc_hd__tapvpwrvgnd_1
XFILLER_135_1422 VPWR VGND VPWR VGND sky130_ef_sc_hd__decap_12
XFILLER_44_1338 VPWR VGND VPWR VGND sky130_ef_sc_hd__decap_12
XFILLER_135_1466 VPWR VGND VPWR VGND sky130_ef_sc_hd__decap_12
XFILLER_83_1398 VPWR VGND VPWR VGND sky130_ef_sc_hd__decap_12
XFILLER_211_1343 VGND VGND VPWR VPWR sky130_fd_sc_hd__fill_1
XTAP_TAPCELL_ROW_146_2_3924 VGND VPWR sky130_fd_sc_hd__tapvpwrvgnd_1
XFILLER_203_51 VGND VGND VPWR VPWR sky130_fd_sc_hd__decap_4
XFILLER_168_1253 VGND VGND VPWR VPWR sky130_fd_sc_hd__decap_6
XFILLER_197_205 VPWR VGND VPWR VGND sky130_ef_sc_hd__decap_12
XFILLER_164_1117 VPWR VGND VPWR VGND sky130_ef_sc_hd__decap_12
XTAP_TAPCELL_ROW_126_2_3800 VGND VPWR sky130_fd_sc_hd__tapvpwrvgnd_1
XFILLER_16_27 VGND VGND VPWR VPWR sky130_fd_sc_hd__fill_1
XFILLER_20_1382 VPWR VGND VPWR VGND sky130_ef_sc_hd__decap_12
XFILLER_213_559 VGND VGND VPWR VPWR sky130_fd_sc_hd__fill_1
XFILLER_168_1297 VPWR VGND VPWR VGND sky130_ef_sc_hd__decap_12
XFILLER_94_1450 VPWR VGND VPWR VGND sky130_ef_sc_hd__decap_12
XFILLER_90_1314 VPWR VGND VPWR VGND sky130_ef_sc_hd__decap_12
XFILLER_55_1434 VGND VGND VPWR VPWR sky130_fd_sc_hd__decap_6
XFILLER_200_209 VPWR VGND VPWR VGND sky130_ef_sc_hd__decap_12
XFILLER_197_249 VPWR VGND VPWR VGND sky130_ef_sc_hd__decap_12
XFILLER_179_953 VPWR VGND VPWR VGND sky130_ef_sc_hd__decap_12
XFILLER_146_1562 VPWR VGND VPWR VGND sky130_ef_sc_hd__decap_12
XFILLER_94_1494 VPWR VGND VPWR VGND sky130_ef_sc_hd__decap_12
XFILLER_194_923 VGND VGND VPWR VPWR sky130_fd_sc_hd__fill_1
XFILLER_166_625 VPWR VGND VPWR VGND sky130_ef_sc_hd__decap_12
XFILLER_142_1426 VPWR VGND VPWR VGND sky130_ef_sc_hd__decap_12
XFILLER_107_1546 VGND VGND VPWR VPWR sky130_fd_sc_hd__decap_6
XFILLER_90_1358 VPWR VGND VPWR VGND sky130_ef_sc_hd__decap_12
XFILLER_32_15 VPWR VGND VPWR VGND sky130_ef_sc_hd__decap_12
XFILLER_55_1478 VPWR VGND VPWR VGND sky130_ef_sc_hd__decap_12
XFILLER_205_1169 VGND VGND VPWR VPWR sky130_fd_sc_hd__decap_6
XFILLER_166_669 VPWR VGND VPWR VGND sky130_ef_sc_hd__decap_12
XFILLER_165_113 VPWR VGND VPWR VGND sky130_ef_sc_hd__decap_12
XFILLER_148_15 VPWR VGND VPWR VGND sky130_ef_sc_hd__decap_12
XFILLER_32_59 VGND VGND VPWR VPWR sky130_fd_sc_hd__fill_1
XFILLER_181_617 VPWR VGND VPWR VGND sky130_ef_sc_hd__decap_12
XFILLER_88_1232 VPWR VGND VPWR VGND sky130_ef_sc_hd__decap_12
XFILLER_175_1213 VPWR VGND VPWR VGND sky130_ef_sc_hd__decap_12
XFILLER_179_1393 VGND VGND VPWR VPWR sky130_fd_sc_hd__decap_6
XFILLER_175_1257 VPWR VGND VPWR VGND sky130_ef_sc_hd__decap_12
XTAP_TAPCELL_ROW_167_1512 VGND VPWR sky130_fd_sc_hd__tapvpwrvgnd_1
XTAP_TAPCELL_ROW_167_1501 VGND VPWR sky130_fd_sc_hd__tapvpwrvgnd_1
XFILLER_153_1522 VPWR VGND VPWR VGND sky130_ef_sc_hd__decap_12
XFILLER_66_1574 VGND VGND VPWR VPWR sky130_fd_sc_hd__decap_6
XFILLER_212_1129 VPWR VGND VPWR VGND sky130_ef_sc_hd__decap_12
XFILLER_153_1566 VPWR VGND VPWR VGND sky130_ef_sc_hd__decap_12
XFILLER_114_1506 VPWR VGND VPWR VGND sky130_ef_sc_hd__decap_12
XFILLER_0_557 VGND VGND VPWR VPWR sky130_fd_sc_hd__decap_3
XFILLER_62_1438 VPWR VGND VPWR VGND sky130_ef_sc_hd__decap_12
XFILLER_208_309 VPWR VGND VPWR VGND sky130_ef_sc_hd__decap_12
XFILLER_9_1490 VGND VGND VPWR VPWR sky130_fd_sc_hd__decap_6
XTAP_TAPCELL_ROW_35_2_3204 VGND VPWR sky130_fd_sc_hd__tapvpwrvgnd_1
XFILLER_217_821 VPWR VGND VPWR VGND sky130_ef_sc_hd__decap_12
XFILLER_189_3 VPWR VGND VPWR VGND sky130_ef_sc_hd__decap_12
XFILLER_5_1343 VGND VGND VPWR VPWR sky130_fd_sc_hd__fill_1
XANTENNA__406__A2 b_addr\[2\] VGND VGND VPWR VPWR sky130_fd_sc_hd__diode_2
XFILLER_217_865 VPWR VGND VPWR VGND sky130_ef_sc_hd__decap_12
XFILLER_113_51 VGND VGND VPWR VPWR sky130_fd_sc_hd__decap_4
XTAP_TAPCELL_ROW_4_896 VGND VPWR sky130_fd_sc_hd__tapvpwrvgnd_1
XFILLER_186_1353 VPWR VGND VPWR VGND sky130_ef_sc_hd__decap_12
XFILLER_182_1217 VPWR VGND VPWR VGND sky130_ef_sc_hd__decap_12
XFILLER_73_55 VGND VGND VPWR VPWR sky130_fd_sc_hd__fill_1
XFILLER_189_55 VGND VGND VPWR VPWR sky130_fd_sc_hd__fill_1
XFILLER_186_1397 VPWR VGND VPWR VGND sky130_ef_sc_hd__decap_12
XFILLER_169_441 VGND VGND VPWR VPWR sky130_fd_sc_hd__decap_6
XFILLER_125_1602 VGND VGND VPWR VPWR sky130_fd_sc_hd__decap_3
XFILLER_73_1534 VPWR VGND VPWR VGND sky130_ef_sc_hd__decap_12
XFILLER_212_581 VGND VGND VPWR VPWR sky130_fd_sc_hd__decap_6
XFILLER_197_783 VGND VGND VPWR VPWR sky130_fd_sc_hd__fill_1
XFILLER_169_485 VPWR VGND VPWR VGND sky130_ef_sc_hd__decap_12
XFILLER_160_1526 VPWR VGND VPWR VGND sky130_ef_sc_hd__decap_12
XFILLER_73_1578 VPWR VGND VPWR VGND sky130_ef_sc_hd__decap_12
XFILLER_34_1518 VGND VGND VPWR VPWR sky130_fd_sc_hd__decap_6
XFILLER_185_945 VGND VGND VPWR VPWR sky130_fd_sc_hd__decap_6
XFILLER_184_433 VPWR VGND VPWR VGND sky130_ef_sc_hd__decap_12
XPHY_EDGE_ROW_134_2_Right_191 VGND VGND VPWR VPWR sky130_fd_sc_hd__decap_3
XFILLER_32_1220 VPWR VGND VPWR VGND sky130_ef_sc_hd__decap_12
XFILLER_185_989 VPWR VGND VPWR VGND sky130_ef_sc_hd__decap_12
XFILLER_184_477 VPWR VGND VPWR VGND sky130_ef_sc_hd__decap_12
XPHY_EDGE_ROW_10_2_Right_67 VGND VGND VPWR VPWR sky130_fd_sc_hd__decap_3
XFILLER_208_29 VPWR VGND VPWR VGND sky130_ef_sc_hd__decap_12
XFILLER_201_1567 VGND VGND VPWR VPWR sky130_fd_sc_hd__fill_1
XFILLER_171_105 VGND VGND VPWR VPWR sky130_fd_sc_hd__decap_6
XANTENNA__342__A1 b_addr\[2\] VGND VGND VPWR VPWR sky130_fd_sc_hd__diode_2
XFILLER_7_167 VGND VGND VPWR VPWR sky130_fd_sc_hd__fill_1
XTAP_TAPCELL_ROW_45_1_1107 VGND VPWR sky130_fd_sc_hd__tapvpwrvgnd_1
XFILLER_217_1007 VGND VGND VPWR VPWR sky130_fd_sc_hd__fill_1
XFILLER_197_1493 VPWR VGND VPWR VGND sky130_ef_sc_hd__decap_12
XFILLER_193_1313 VPWR VGND VPWR VGND sky130_ef_sc_hd__decap_12
XFILLER_171_149 VPWR VGND VPWR VGND sky130_ef_sc_hd__decap_12
XTAP_TAPCELL_ROW_152_2_3967 VGND VPWR sky130_fd_sc_hd__tapvpwrvgnd_1
XFILLER_98_41 VPWR VGND VPWR VGND sky130_ef_sc_hd__decap_12
XANTENNA__618__CLK clknet_3_7_0_clk VGND VGND VPWR VPWR sky130_fd_sc_hd__diode_2
XFILLER_10_1562 VPWR VGND VPWR VGND sky130_ef_sc_hd__decap_12
XFILLER_193_1357 VPWR VGND VPWR VGND sky130_ef_sc_hd__decap_12
XFILLER_98_85 VPWR VGND VPWR VGND sky130_ef_sc_hd__decap_12
XFILLER_80_1538 VPWR VGND VPWR VGND sky130_ef_sc_hd__decap_12
XFILLER_93_111 VGND VGND VPWR VPWR sky130_fd_sc_hd__fill_1
XFILLER_6_1129 VPWR VGND VPWR VGND sky130_ef_sc_hd__decap_12
XFILLER_78_1412 VGND VGND VPWR VPWR sky130_fd_sc_hd__fill_1
XPHY_EDGE_ROW_75_2_Left_507 VGND VGND VPWR VPWR sky130_fd_sc_hd__decap_3
XFILLER_179_205 VPWR VGND VPWR VGND sky130_ef_sc_hd__decap_12
XFILLER_165_1437 VPWR VGND VPWR VGND sky130_ef_sc_hd__decap_12
XPHY_EDGE_ROW_92_1_Right_678 VGND VGND VPWR VPWR sky130_fd_sc_hd__decap_3
XFILLER_195_709 VPWR VGND VPWR VGND sky130_ef_sc_hd__decap_12
XFILLER_179_249 VPWR VGND VPWR VGND sky130_ef_sc_hd__decap_12
XFILLER_176_923 VGND VGND VPWR VPWR sky130_fd_sc_hd__fill_1
XFILLER_163_1161 VPWR VGND VPWR VGND sky130_ef_sc_hd__decap_12
XFILLER_128_1270 VPWR VGND VPWR VGND sky130_ef_sc_hd__decap_12
XTAP_TAPCELL_ROW_48_2_3293 VGND VPWR sky130_fd_sc_hd__tapvpwrvgnd_1
XFILLER_202_1309 VGND VGND VPWR VPWR sky130_fd_sc_hd__decap_6
XFILLER_187_293 VPWR VGND VPWR VGND sky130_ef_sc_hd__decap_12
XFILLER_147_113 VPWR VGND VPWR VGND sky130_ef_sc_hd__decap_12
XFILLER_15_1440 VGND VGND VPWR VPWR sky130_fd_sc_hd__fill_1
XFILLER_163_617 VPWR VGND VPWR VGND sky130_ef_sc_hd__decap_12
XFILLER_118_29 VPWR VGND VPWR VGND sky130_ef_sc_hd__decap_12
XFILLER_89_1552 VGND VGND VPWR VPWR sky130_fd_sc_hd__fill_1
XFILLER_190_469 VGND VGND VPWR VPWR sky130_fd_sc_hd__decap_6
XFILLER_176_1533 VGND VGND VPWR VPWR sky130_fd_sc_hd__decap_6
XFILLER_176_1577 VPWR VGND VPWR VGND sky130_ef_sc_hd__decap_12
XTAP_TAPCELL_ROW_41_2_3247 VGND VPWR sky130_fd_sc_hd__tapvpwrvgnd_1
XFILLER_48_1282 VPWR VGND VPWR VGND sky130_ef_sc_hd__decap_12
XTAP_TAPCELL_ROW_21_2_3112 VGND VPWR sky130_fd_sc_hd__tapvpwrvgnd_1
XFILLER_213_1449 VGND VGND VPWR VPWR sky130_fd_sc_hd__decap_6
XFILLER_135_1274 VPWR VGND VPWR VGND sky130_ef_sc_hd__decap_12
XFILLER_214_83 VGND VGND VPWR VPWR sky130_fd_sc_hd__fill_1
XTAP_TAPCELL_ROW_1_811 VGND VPWR sky130_fd_sc_hd__tapvpwrvgnd_1
XFILLER_27_15 VGND VGND VPWR VPWR sky130_fd_sc_hd__fill_2
XFILLER_27_26 VPWR VGND VPWR VGND sky130_ef_sc_hd__decap_12
XFILLER_26_1580 VGND VGND VPWR VPWR sky130_fd_sc_hd__fill_1
XFILLER_150_27 VGND VGND VPWR VPWR sky130_fd_sc_hd__fill_1
XFILLER_148_1602 VGND VGND VPWR VPWR sky130_fd_sc_hd__decap_3
XTAP_TAPCELL_ROW_1_833 VGND VPWR sky130_fd_sc_hd__tapvpwrvgnd_1
XTAP_TAPCELL_ROW_1_822 VGND VPWR sky130_fd_sc_hd__tapvpwrvgnd_1
XFILLER_214_813 VPWR VGND VPWR VGND sky130_ef_sc_hd__decap_12
XFILLER_168_1061 VPWR VGND VPWR VGND sky130_ef_sc_hd__decap_12
XFILLER_198_525 VGND VGND VPWR VPWR sky130_fd_sc_hd__decap_6
XFILLER_183_1537 VPWR VGND VPWR VGND sky130_ef_sc_hd__decap_12
XTAP_TAPCELL_ROW_38_1_1094 VGND VPWR sky130_fd_sc_hd__tapvpwrvgnd_1
XFILLER_198_569 VPWR VGND VPWR VGND sky130_ef_sc_hd__decap_12
XFILLER_107_1310 VPWR VGND VPWR VGND sky130_ef_sc_hd__decap_12
XFILLER_0_1273 VPWR VGND VPWR VGND sky130_ef_sc_hd__decap_12
XFILLER_55_1220 VPWR VGND VPWR VGND sky130_ef_sc_hd__decap_12
XFILLER_201_529 VPWR VGND VPWR VGND sky130_ef_sc_hd__decap_12
XFILLER_179_783 VGND VGND VPWR VPWR sky130_fd_sc_hd__fill_1
XFILLER_146_1370 VPWR VGND VPWR VGND sky130_ef_sc_hd__decap_12
XFILLER_43_69 VPWR VGND VPWR VGND sky130_ef_sc_hd__decap_12
XFILLER_167_945 VGND VGND VPWR VPWR sky130_fd_sc_hd__decap_6
XFILLER_166_433 VPWR VGND VPWR VGND sky130_ef_sc_hd__decap_12
XFILLER_159_69 VPWR VGND VPWR VGND sky130_ef_sc_hd__decap_12
XFILLER_107_1354 VPWR VGND VPWR VGND sky130_ef_sc_hd__decap_12
XFILLER_55_1286 VPWR VGND VPWR VGND sky130_ef_sc_hd__decap_12
XFILLER_167_989 VPWR VGND VPWR VGND sky130_ef_sc_hd__decap_12
XFILLER_166_477 VPWR VGND VPWR VGND sky130_ef_sc_hd__decap_12
XFILLER_107_1398 VPWR VGND VPWR VGND sky130_ef_sc_hd__decap_12
XFILLER_182_937 VPWR VGND VPWR VGND sky130_ef_sc_hd__decap_12
XFILLER_153_105 VGND VGND VPWR VPWR sky130_fd_sc_hd__decap_6
XPHY_EDGE_ROW_189_Left_408 VGND VGND VPWR VPWR sky130_fd_sc_hd__decap_3
XFILLER_181_447 VGND VGND VPWR VPWR sky130_fd_sc_hd__fill_1
XFILLER_175_1021 VPWR VGND VPWR VGND sky130_ef_sc_hd__decap_12
XFILLER_175_57 VPWR VGND VPWR VGND sky130_ef_sc_hd__decap_12
XTAP_TAPCELL_ROW_137_2_3869 VGND VPWR sky130_fd_sc_hd__tapvpwrvgnd_1
XFILLER_104_3 VPWR VGND VPWR VGND sky130_ef_sc_hd__decap_12
XPHY_EDGE_ROW_54_1_Right_640 VGND VGND VPWR VPWR sky130_fd_sc_hd__decap_3
XFILLER_190_981 VPWR VGND VPWR VGND sky130_ef_sc_hd__decap_12
XFILLER_175_1065 VPWR VGND VPWR VGND sky130_ef_sc_hd__decap_12
XPHY_EDGE_ROW_41_1_Left_260 VGND VGND VPWR VPWR sky130_fd_sc_hd__decap_3
XFILLER_27_1322 VGND VGND VPWR VPWR sky130_fd_sc_hd__decap_6
XFILLER_153_1330 VPWR VGND VPWR VGND sky130_ef_sc_hd__decap_12
XFILLER_118_1450 VPWR VGND VPWR VGND sky130_ef_sc_hd__decap_12
XFILLER_68_77 VGND VGND VPWR VPWR sky130_fd_sc_hd__decap_6
XFILLER_66_1382 VPWR VGND VPWR VGND sky130_ef_sc_hd__decap_12
XFILLER_0_354 VGND VGND VPWR VPWR sky130_fd_sc_hd__decap_3
XFILLER_216_1073 VPWR VGND VPWR VGND sky130_ef_sc_hd__decap_12
XFILLER_118_1494 VPWR VGND VPWR VGND sky130_ef_sc_hd__decap_12
XFILLER_114_1314 VPWR VGND VPWR VGND sky130_ef_sc_hd__decap_12
XFILLER_75_111 VGND VGND VPWR VPWR sky130_fd_sc_hd__fill_1
XFILLER_1_899 VPWR VGND VPWR VGND sky130_ef_sc_hd__decap_12
XFILLER_27_1366 VPWR VGND VPWR VGND sky130_ef_sc_hd__decap_12
XFILLER_62_1246 VPWR VGND VPWR VGND sky130_ef_sc_hd__decap_12
XFILLER_209_629 VPWR VGND VPWR VGND sky130_ef_sc_hd__decap_12
XFILLER_124_83 VGND VGND VPWR VPWR sky130_fd_sc_hd__fill_1
XFILLER_114_1358 VPWR VGND VPWR VGND sky130_ef_sc_hd__decap_12
XANTENNA_input24_A func_wdata[20] VGND VGND VPWR VPWR sky130_fd_sc_hd__diode_2
XFILLER_208_139 VGND VGND VPWR VPWR sky130_fd_sc_hd__fill_1
XPHY_EDGE_ROW_198_Left_417 VGND VGND VPWR VPWR sky130_fd_sc_hd__decap_3
XFILLER_84_65 VPWR VGND VPWR VGND sky130_ef_sc_hd__decap_12
XFILLER_217_673 VPWR VGND VPWR VGND sky130_ef_sc_hd__decap_12
XFILLER_204_301 VGND VGND VPWR VPWR sky130_fd_sc_hd__decap_6
XFILLER_189_503 VGND VGND VPWR VPWR sky130_fd_sc_hd__fill_1
XFILLER_186_1161 VPWR VGND VPWR VGND sky130_ef_sc_hd__decap_12
X_585_ clknet_3_0_0_clk _019_ VGND VGND VPWR VPWR b_addr\[1\] sky130_fd_sc_hd__dfxtp_2
XFILLER_204_345 VPWR VGND VPWR VGND sky130_ef_sc_hd__decap_12
XFILLER_177_709 VPWR VGND VPWR VGND sky130_ef_sc_hd__decap_12
XFILLER_204_389 VPWR VGND VPWR VGND sky130_ef_sc_hd__decap_12
XFILLER_129_1590 VPWR VGND VPWR VGND sky130_ef_sc_hd__decap_12
XFILLER_125_1410 VPWR VGND VPWR VGND sky130_ef_sc_hd__decap_12
XFILLER_73_1342 VPWR VGND VPWR VGND sky130_ef_sc_hd__decap_12
XFILLER_38_1462 VGND VGND VPWR VPWR sky130_fd_sc_hd__decap_6
XFILLER_199_1511 VGND VGND VPWR VPWR sky130_fd_sc_hd__fill_1
XFILLER_169_293 VPWR VGND VPWR VGND sky130_ef_sc_hd__decap_12
XFILLER_160_1356 VGND VGND VPWR VPWR sky130_fd_sc_hd__fill_1
XFILLER_129_113 VPWR VGND VPWR VGND sky130_ef_sc_hd__decap_12
XFILLER_125_1454 VPWR VGND VPWR VGND sky130_ef_sc_hd__decap_12
XFILLER_73_1386 VPWR VGND VPWR VGND sky130_ef_sc_hd__decap_12
XANTENNA__292__Y _087_ VGND VGND VPWR VPWR sky130_fd_sc_hd__diode_2
XFILLER_34_1326 VPWR VGND VPWR VGND sky130_ef_sc_hd__decap_12
XFILLER_185_753 VPWR VGND VPWR VGND sky130_ef_sc_hd__decap_12
XFILLER_125_1498 VPWR VGND VPWR VGND sky130_ef_sc_hd__decap_12
XFILLER_12_1602 VGND VGND VPWR VPWR sky130_fd_sc_hd__decap_3
XFILLER_33_91 VGND VGND VPWR VPWR sky130_fd_sc_hd__decap_4
XFILLER_185_797 VPWR VGND VPWR VGND sky130_ef_sc_hd__decap_12
XPHY_EDGE_ROW_135_2_Right_192 VGND VGND VPWR VPWR sky130_fd_sc_hd__decap_3
XFILLER_193_1121 VPWR VGND VPWR VGND sky130_ef_sc_hd__decap_12
XFILLER_172_469 VGND VGND VPWR VPWR sky130_fd_sc_hd__decap_6
XTAP_TAPCELL_ROW_26_2_3149 VGND VPWR sky130_fd_sc_hd__tapvpwrvgnd_1
XFILLER_10_1370 VPWR VGND VPWR VGND sky130_ef_sc_hd__decap_12
XANTENNA__590__CLK clknet_3_2_0_clk VGND VGND VPWR VPWR sky130_fd_sc_hd__diode_2
XFILLER_136_1550 VPWR VGND VPWR VGND sky130_ef_sc_hd__decap_12
XFILLER_84_1482 VPWR VGND VPWR VGND sky130_ef_sc_hd__decap_12
XFILLER_80_1302 VPWR VGND VPWR VGND sky130_ef_sc_hd__decap_12
XFILLER_45_1422 VPWR VGND VPWR VGND sky130_ef_sc_hd__decap_12
XFILLER_136_1594 VGND VGND VPWR VPWR sky130_fd_sc_hd__decap_8
XFILLER_132_1414 VPWR VGND VPWR VGND sky130_ef_sc_hd__decap_12
XFILLER_45_1466 VPWR VGND VPWR VGND sky130_ef_sc_hd__decap_12
XFILLER_214_109 VPWR VGND VPWR VGND sky130_ef_sc_hd__decap_12
XFILLER_207_161 VGND VGND VPWR VPWR sky130_fd_sc_hd__decap_6
XFILLER_165_1201 VPWR VGND VPWR VGND sky130_ef_sc_hd__decap_12
XFILLER_81_125 VGND VGND VPWR VPWR sky130_fd_sc_hd__fill_2
XFILLER_78_1220 VPWR VGND VPWR VGND sky130_ef_sc_hd__decap_12
XFILLER_169_1381 VPWR VGND VPWR VGND sky130_ef_sc_hd__decap_12
XFILLER_165_1245 VPWR VGND VPWR VGND sky130_ef_sc_hd__decap_12
XFILLER_1_1593 VPWR VGND VPWR VGND sky130_ef_sc_hd__decap_12
XFILLER_200_41 VPWR VGND VPWR VGND sky130_ef_sc_hd__decap_12
XFILLER_195_517 VPWR VGND VPWR VGND sky130_ef_sc_hd__decap_12
XFILLER_165_1289 VPWR VGND VPWR VGND sky130_ef_sc_hd__decap_12
XFILLER_143_1510 VPWR VGND VPWR VGND sky130_ef_sc_hd__decap_12
XPHY_EDGE_ROW_93_1_Right_679 VGND VGND VPWR VPWR sky130_fd_sc_hd__decap_3
XFILLER_91_1442 VPWR VGND VPWR VGND sky130_ef_sc_hd__decap_12
Xu_sram.u_mem_170 VGND VGND VPWR VPWR net170 u_sram.u_mem_170/LO sky130_fd_sc_hd__conb_1
XFILLER_56_1562 VPWR VGND VPWR VGND sky130_ef_sc_hd__decap_12
XFILLER_206_1253 VGND VGND VPWR VPWR sky130_fd_sc_hd__decap_6
XFILLER_200_85 VPWR VGND VPWR VGND sky130_ef_sc_hd__decap_12
XFILLER_143_1554 VPWR VGND VPWR VGND sky130_ef_sc_hd__decap_12
XFILLER_13_39 VGND VGND VPWR VPWR sky130_fd_sc_hd__fill_1
XFILLER_17_1546 VGND VGND VPWR VPWR sky130_fd_sc_hd__decap_6
XFILLER_52_1426 VPWR VGND VPWR VGND sky130_ef_sc_hd__decap_12
XFILLER_206_1297 VPWR VGND VPWR VGND sky130_ef_sc_hd__decap_12
XFILLER_202_1117 VPWR VGND VPWR VGND sky130_ef_sc_hd__decap_12
XFILLER_129_39 VPWR VGND VPWR VGND sky130_ef_sc_hd__decap_12
XFILLER_104_1538 VPWR VGND VPWR VGND sky130_ef_sc_hd__decap_12
XFILLER_164_937 VPWR VGND VPWR VGND sky130_ef_sc_hd__decap_12
XFILLER_135_105 VGND VGND VPWR VPWR sky130_fd_sc_hd__decap_6
XTAP_TAPCELL_ROW_123_2_3777 VGND VPWR sky130_fd_sc_hd__tapvpwrvgnd_1
XANTENNA__362__C b_addr\[1\] VGND VGND VPWR VPWR sky130_fd_sc_hd__diode_2
XFILLER_190_233 VPWR VGND VPWR VGND sky130_ef_sc_hd__decap_12
XFILLER_190_277 VPWR VGND VPWR VGND sky130_ef_sc_hd__decap_12
XFILLER_176_1341 VPWR VGND VPWR VGND sky130_ef_sc_hd__decap_12
XFILLER_172_981 VPWR VGND VPWR VGND sky130_ef_sc_hd__decap_12
XFILLER_145_27 VPWR VGND VPWR VGND sky130_ef_sc_hd__decap_12
XFILLER_2_619 VGND VGND VPWR VPWR sky130_fd_sc_hd__fill_1
XFILLER_176_1385 VPWR VGND VPWR VGND sky130_ef_sc_hd__decap_12
XFILLER_172_1205 VPWR VGND VPWR VGND sky130_ef_sc_hd__decap_12
XFILLER_85_1268 VGND VGND VPWR VPWR sky130_fd_sc_hd__decap_4
XFILLER_1_129 VGND VGND VPWR VPWR sky130_fd_sc_hd__fill_1
XTAP_TAPCELL_ROW_71_2_3442 VGND VPWR sky130_fd_sc_hd__tapvpwrvgnd_1
XFILLER_63_1522 VPWR VGND VPWR VGND sky130_ef_sc_hd__decap_12
XFILLER_217_1393 VGND VGND VPWR VPWR sky130_fd_sc_hd__decap_6
XFILLER_213_1213 VPWR VGND VPWR VGND sky130_ef_sc_hd__decap_12
XFILLER_63_1566 VPWR VGND VPWR VGND sky130_ef_sc_hd__decap_12
XTAP_TAPCELL_ROW_6_958 VGND VPWR sky130_fd_sc_hd__tapvpwrvgnd_1
XTAP_TAPCELL_ROW_6_969 VGND VPWR sky130_fd_sc_hd__tapvpwrvgnd_1
XFILLER_24_1506 VPWR VGND VPWR VGND sky130_ef_sc_hd__decap_12
XFILLER_57_111 VGND VGND VPWR VPWR sky130_fd_sc_hd__fill_1
XFILLER_219_949 VGND VGND VPWR VPWR sky130_fd_sc_hd__decap_3
XFILLER_213_1257 VPWR VGND VPWR VGND sky130_ef_sc_hd__decap_12
XFILLER_161_15 VPWR VGND VPWR VGND sky130_ef_sc_hd__decap_12
XFILLER_214_643 VGND VGND VPWR VPWR sky130_fd_sc_hd__fill_1
XFILLER_187_1481 VPWR VGND VPWR VGND sky130_ef_sc_hd__decap_12
XFILLER_183_1301 VPWR VGND VPWR VGND sky130_ef_sc_hd__decap_12
XTAP_TAPCELL_ROW_181_1895 VGND VPWR sky130_fd_sc_hd__tapvpwrvgnd_1
XTAP_TAPCELL_ROW_69_1_1155 VGND VPWR sky130_fd_sc_hd__tapvpwrvgnd_1
XFILLER_202_805 VGND VGND VPWR VPWR sky130_fd_sc_hd__decap_6
XFILLER_198_333 VPWR VGND VPWR VGND sky130_ef_sc_hd__decap_12
XFILLER_183_1345 VPWR VGND VPWR VGND sky130_ef_sc_hd__decap_12
X_370_ u_ctrl.elem_idx\[1\] u_ctrl.elem_idx\[0\] VGND VGND VPWR VPWR _112_ sky130_fd_sc_hd__xor2_1
XFILLER_202_849 VPWR VGND VPWR VGND sky130_ef_sc_hd__decap_12
XFILLER_199_889 VGND VGND VPWR VPWR sky130_fd_sc_hd__decap_6
XFILLER_198_377 VPWR VGND VPWR VGND sky130_ef_sc_hd__decap_12
XFILLER_110_41 VPWR VGND VPWR VGND sky130_ef_sc_hd__decap_12
XFILLER_35_1602 VGND VGND VPWR VPWR sky130_fd_sc_hd__decap_3
XFILLER_201_337 VPWR VGND VPWR VGND sky130_ef_sc_hd__decap_12
XFILLER_110_85 VPWR VGND VPWR VGND sky130_ef_sc_hd__decap_12
XFILLER_70_1526 VPWR VGND VPWR VGND sky130_ef_sc_hd__decap_12
XFILLER_182_701 VPWR VGND VPWR VGND sky130_ef_sc_hd__decap_12
XFILLER_167_753 VPWR VGND VPWR VGND sky130_ef_sc_hd__decap_12
XFILLER_210_893 VPWR VGND VPWR VGND sky130_ef_sc_hd__decap_12
XFILLER_167_797 VPWR VGND VPWR VGND sky130_ef_sc_hd__decap_12
XFILLER_6_925 VPWR VGND VPWR VGND sky130_ef_sc_hd__decap_12
XTAP_TAPCELL_ROW_12_2_3057 VGND VPWR sky130_fd_sc_hd__tapvpwrvgnd_1
XFILLER_194_1441 VPWR VGND VPWR VGND sky130_ef_sc_hd__decap_12
XFILLER_163_981 VPWR VGND VPWR VGND sky130_ef_sc_hd__decap_12
XPHY_EDGE_ROW_55_1_Right_641 VGND VGND VPWR VPWR sky130_fd_sc_hd__decap_3
XFILLER_194_1485 VPWR VGND VPWR VGND sky130_ef_sc_hd__decap_12
XFILLER_1_630 VGND VGND VPWR VPWR sky130_fd_sc_hd__decap_4
XFILLER_135_93 VPWR VGND VPWR VGND sky130_ef_sc_hd__decap_12
XFILLER_7_1257 VGND VGND VPWR VPWR sky130_fd_sc_hd__decap_3
XFILLER_218_993 VPWR VGND VPWR VGND sky130_ef_sc_hd__decap_12
XTAP_TAPCELL_ROW_116_1_1250 VGND VPWR sky130_fd_sc_hd__tapvpwrvgnd_1
XFILLER_63_125 VGND VGND VPWR VPWR sky130_fd_sc_hd__fill_2
XFILLER_166_1521 VPWR VGND VPWR VGND sky130_ef_sc_hd__decap_12
XFILLER_151_81 VPWR VGND VPWR VGND sky130_ef_sc_hd__decap_12
XFILLER_205_665 VGND VGND VPWR VPWR sky130_fd_sc_hd__decap_6
XFILLER_204_153 VPWR VGND VPWR VGND sky130_ef_sc_hd__decap_12
XFILLER_166_1565 VPWR VGND VPWR VGND sky130_ef_sc_hd__decap_12
X_568_ clknet_3_1_0_clk _006_ VGND VGND VPWR VPWR u_ctrl.cmp_addr\[0\] sky130_fd_sc_hd__dfxtp_1
XFILLER_177_517 VPWR VGND VPWR VGND sky130_ef_sc_hd__decap_12
XFILLER_204_197 VPWR VGND VPWR VGND sky130_ef_sc_hd__decap_12
X_499_ net151 _192_ net129 net138 _223_ VGND VGND VPWR VPWR _033_ sky130_fd_sc_hd__o311a_1
XFILLER_38_1270 VPWR VGND VPWR VGND sky130_ef_sc_hd__decap_12
XFILLER_203_1437 VPWR VGND VPWR VGND sky130_ef_sc_hd__decap_12
XFILLER_185_561 VPWR VGND VPWR VGND sky130_ef_sc_hd__decap_12
XTAP_TAPCELL_ROW_108_2_3679 VGND VPWR sky130_fd_sc_hd__tapvpwrvgnd_1
XTAP_TAPCELL_ROW_191_2180 VGND VPWR sky130_fd_sc_hd__tapvpwrvgnd_1
XFILLER_117_105 VGND VGND VPWR VPWR sky130_fd_sc_hd__decap_6
XTAP_TAPCELL_ROW_191_2191 VGND VPWR sky130_fd_sc_hd__tapvpwrvgnd_1
XFILLER_172_233 VPWR VGND VPWR VGND sky130_ef_sc_hd__decap_12
XPHY_EDGE_ROW_136_2_Right_193 VGND VGND VPWR VPWR sky130_fd_sc_hd__decap_3
XFILLER_67_3 VPWR VGND VPWR VGND sky130_ef_sc_hd__decap_12
XFILLER_172_277 VPWR VGND VPWR VGND sky130_ef_sc_hd__decap_12
XTAP_TAPCELL_ROW_212_2795 VGND VPWR sky130_fd_sc_hd__tapvpwrvgnd_1
XTAP_TAPCELL_ROW_212_2784 VGND VPWR sky130_fd_sc_hd__tapvpwrvgnd_1
XTAP_TAPCELL_ROW_212_2773 VGND VPWR sky130_fd_sc_hd__tapvpwrvgnd_1
XFILLER_173_1525 VPWR VGND VPWR VGND sky130_ef_sc_hd__decap_12
XFILLER_5_51 VGND VGND VPWR VPWR sky130_fd_sc_hd__decap_4
XFILLER_173_1569 VPWR VGND VPWR VGND sky130_ef_sc_hd__decap_12
XTAP_TAPCELL_ROW_56_2_3344 VGND VPWR sky130_fd_sc_hd__tapvpwrvgnd_1
XFILLER_214_1533 VGND VGND VPWR VPWR sky130_fd_sc_hd__decap_6
XFILLER_214_1577 VPWR VGND VPWR VGND sky130_ef_sc_hd__decap_12
XFILLER_189_1009 VPWR VGND VPWR VGND sky130_ef_sc_hd__decap_12
XFILLER_132_1244 VGND VGND VPWR VPWR sky130_fd_sc_hd__fill_1
XPHY_EDGE_ROW_19_2_Left_451 VGND VGND VPWR VPWR sky130_fd_sc_hd__decap_3
XFILLER_39_111 VGND VGND VPWR VPWR sky130_fd_sc_hd__fill_1
XFILLER_45_1274 VPWR VGND VPWR VGND sky130_ef_sc_hd__decap_12
XFILLER_215_429 VPWR VGND VPWR VGND sky130_ef_sc_hd__decap_12
XTAP_TAPCELL_ROW_206_2599 VGND VPWR sky130_fd_sc_hd__tapvpwrvgnd_1
XFILLER_58_1602 VGND VGND VPWR VPWR sky130_fd_sc_hd__decap_3
XFILLER_211_51 VGND VGND VPWR VPWR sky130_fd_sc_hd__decap_4
XFILLER_208_1315 VGND VGND VPWR VPWR sky130_fd_sc_hd__fill_1
XTAP_TAPCELL_ROW_198_2378 VGND VPWR sky130_fd_sc_hd__tapvpwrvgnd_1
XTAP_TAPCELL_ROW_198_2389 VGND VPWR sky130_fd_sc_hd__tapvpwrvgnd_1
XFILLER_196_837 VPWR VGND VPWR VGND sky130_ef_sc_hd__decap_12
XFILLER_17_1310 VPWR VGND VPWR VGND sky130_ef_sc_hd__decap_12
XFILLER_24_27 VGND VGND VPWR VPWR sky130_fd_sc_hd__fill_1
XFILLER_91_1272 VGND VGND VPWR VPWR sky130_fd_sc_hd__fill_1
XFILLER_56_1370 VPWR VGND VPWR VGND sky130_ef_sc_hd__decap_12
XFILLER_206_1061 VPWR VGND VPWR VGND sky130_ef_sc_hd__decap_12
XFILLER_164_701 VPWR VGND VPWR VGND sky130_ef_sc_hd__decap_12
XFILLER_108_1482 VPWR VGND VPWR VGND sky130_ef_sc_hd__decap_12
XFILLER_104_1302 VPWR VGND VPWR VGND sky130_ef_sc_hd__decap_12
XFILLER_17_1354 VPWR VGND VPWR VGND sky130_ef_sc_hd__decap_12
XFILLER_210_189 VGND VGND VPWR VPWR sky130_fd_sc_hd__decap_6
XFILLER_143_1384 VGND VGND VPWR VPWR sky130_fd_sc_hd__fill_1
XFILLER_17_1398 VPWR VGND VPWR VGND sky130_ef_sc_hd__decap_12
XFILLER_40_15 VPWR VGND VPWR VGND sky130_ef_sc_hd__decap_12
XFILLER_191_553 VGND VGND VPWR VPWR sky130_fd_sc_hd__decap_6
XFILLER_156_15 VPWR VGND VPWR VGND sky130_ef_sc_hd__decap_12
XFILLER_163_277 VGND VGND VPWR VPWR sky130_fd_sc_hd__decap_3
XTAP_TAPCELL_ROW_153_2_3972 VGND VPWR sky130_fd_sc_hd__tapvpwrvgnd_1
XFILLER_191_597 VPWR VGND VPWR VGND sky130_ef_sc_hd__decap_12
XTAP_TAPCELL_ROW_170_1596 VGND VPWR sky130_fd_sc_hd__tapvpwrvgnd_1
XTAP_TAPCELL_ROW_170_1585 VGND VPWR sky130_fd_sc_hd__tapvpwrvgnd_1
XTAP_TAPCELL_ROW_170_1574 VGND VPWR sky130_fd_sc_hd__tapvpwrvgnd_1
XFILLER_3_939 VGND VGND VPWR VPWR sky130_fd_sc_hd__decap_4
XFILLER_172_1035 VGND VGND VPWR VPWR sky130_fd_sc_hd__fill_1
XFILLER_150_1300 VGND VGND VPWR VPWR sky130_fd_sc_hd__fill_1
XFILLER_63_1330 VPWR VGND VPWR VGND sky130_ef_sc_hd__decap_12
XFILLER_28_1450 VPWR VGND VPWR VGND sky130_ef_sc_hd__decap_12
XFILLER_49_57 VPWR VGND VPWR VGND sky130_ef_sc_hd__decap_12
XFILLER_219_713 VPWR VGND VPWR VGND sky130_ef_sc_hd__decap_12
XFILLER_213_1021 VPWR VGND VPWR VGND sky130_ef_sc_hd__decap_12
XFILLER_115_1442 VPWR VGND VPWR VGND sky130_ef_sc_hd__decap_12
XFILLER_24_1314 VPWR VGND VPWR VGND sky130_ef_sc_hd__decap_12
XFILLER_28_1494 VPWR VGND VPWR VGND sky130_ef_sc_hd__decap_12
XFILLER_219_757 VPWR VGND VPWR VGND sky130_ef_sc_hd__decap_12
XFILLER_218_245 VGND VGND VPWR VPWR sky130_fd_sc_hd__decap_6
XFILLER_213_1065 VPWR VGND VPWR VGND sky130_ef_sc_hd__decap_12
XTAP_TAPCELL_ROW_183_1968 VGND VPWR sky130_fd_sc_hd__tapvpwrvgnd_1
XTAP_TAPCELL_ROW_183_1957 VGND VPWR sky130_fd_sc_hd__tapvpwrvgnd_1
XTAP_TAPCELL_ROW_183_1946 VGND VPWR sky130_fd_sc_hd__tapvpwrvgnd_1
XFILLER_111_1328 VGND VGND VPWR VPWR sky130_fd_sc_hd__fill_1
XFILLER_98_1426 VPWR VGND VPWR VGND sky130_ef_sc_hd__decap_12
XFILLER_24_1358 VPWR VGND VPWR VGND sky130_ef_sc_hd__decap_12
XFILLER_171_3 VPWR VGND VPWR VGND sky130_ef_sc_hd__decap_12
XFILLER_45_125 VGND VGND VPWR VPWR sky130_fd_sc_hd__fill_2
XFILLER_218_289 VPWR VGND VPWR VGND sky130_ef_sc_hd__decap_12
XFILLER_199_653 VPWR VGND VPWR VGND sky130_ef_sc_hd__decap_12
XFILLER_121_51 VGND VGND VPWR VPWR sky130_fd_sc_hd__decap_4
X_422_ _140_ _149_ _155_ VGND VGND VPWR VPWR _156_ sky130_fd_sc_hd__or3_1
XFILLER_202_613 VPWR VGND VPWR VGND sky130_ef_sc_hd__decap_12
XFILLER_198_141 VPWR VGND VPWR VGND sky130_ef_sc_hd__decap_12
XFILLER_183_1175 VGND VGND VPWR VPWR sky130_fd_sc_hd__fill_1
XFILLER_202_657 VPWR VGND VPWR VGND sky130_ef_sc_hd__decap_12
XFILLER_199_697 VPWR VGND VPWR VGND sky130_ef_sc_hd__decap_12
XFILLER_109_1268 VGND VGND VPWR VPWR sky130_fd_sc_hd__decap_4
XFILLER_81_55 VGND VGND VPWR VPWR sky130_fd_sc_hd__fill_1
XFILLER_74_1470 VPWR VGND VPWR VGND sky130_ef_sc_hd__decap_12
X_353_ net156 _097_ VGND VGND VPWR VPWR _013_ sky130_fd_sc_hd__and2_1
XFILLER_35_1410 VPWR VGND VPWR VGND sky130_ef_sc_hd__decap_12
XFILLER_39_1590 VPWR VGND VPWR VGND sky130_ef_sc_hd__decap_12
XFILLER_201_167 VGND VGND VPWR VPWR sky130_fd_sc_hd__fill_1
XFILLER_197_55 VGND VGND VPWR VPWR sky130_fd_sc_hd__fill_1
XFILLER_161_1440 VGND VGND VPWR VPWR sky130_fd_sc_hd__fill_1
XFILLER_126_1582 VPWR VGND VPWR VGND sky130_ef_sc_hd__decap_12
XFILLER_70_1356 VGND VGND VPWR VPWR sky130_fd_sc_hd__fill_1
XFILLER_14_71 VGND VGND VPWR VPWR sky130_fd_sc_hd__decap_3
X_284_ _079_ _080_ net153 VGND VGND VPWR VPWR _082_ sky130_fd_sc_hd__o21ai_1
XFILLER_35_1454 VPWR VGND VPWR VGND sky130_ef_sc_hd__decap_12
XFILLER_167_561 VPWR VGND VPWR VGND sky130_ef_sc_hd__decap_12
XFILLER_35_1498 VPWR VGND VPWR VGND sky130_ef_sc_hd__decap_12
XFILLER_182_531 VGND VGND VPWR VPWR sky130_fd_sc_hd__fill_1
XPHY_EDGE_ROW_147_2_Left_579 VGND VGND VPWR VPWR sky130_fd_sc_hd__decap_3
XFILLER_122_1468 VGND VGND VPWR VPWR sky130_fd_sc_hd__fill_1
XFILLER_6_755 VGND VGND VPWR VPWR sky130_fd_sc_hd__fill_1
XFILLER_216_29 VPWR VGND VPWR VGND sky130_ef_sc_hd__decap_12
XFILLER_170_737 VPWR VGND VPWR VGND sky130_ef_sc_hd__decap_12
XPHY_EDGE_ROW_84_2_Left_516 VGND VGND VPWR VPWR sky130_fd_sc_hd__decap_3
XTAP_TAPCELL_ROW_42_2_3252 VGND VPWR sky130_fd_sc_hd__tapvpwrvgnd_1
XFILLER_155_1244 VPWR VGND VPWR VGND sky130_ef_sc_hd__decap_12
XFILLER_46_8 VPWR VGND VPWR VGND sky130_ef_sc_hd__decap_12
XPHY_EDGE_ROW_56_1_Right_642 VGND VGND VPWR VPWR sky130_fd_sc_hd__decap_3
XFILLER_46_1550 VPWR VGND VPWR VGND sky130_ef_sc_hd__decap_12
XFILLER_7_1021 VPWR VGND VPWR VGND sky130_ef_sc_hd__decap_12
XFILLER_42_1414 VPWR VGND VPWR VGND sky130_ef_sc_hd__decap_12
XFILLER_46_1594 VGND VGND VPWR VPWR sky130_fd_sc_hd__decap_8
XFILLER_209_223 VGND VGND VPWR VPWR sky130_fd_sc_hd__fill_1
XFILLER_81_1496 VGND VGND VPWR VPWR sky130_fd_sc_hd__fill_1
XFILLER_7_1065 VPWR VGND VPWR VGND sky130_ef_sc_hd__decap_12
Xinput8 func_addr[5] VGND VGND VPWR VPWR net8 sky130_fd_sc_hd__clkbuf_1
XTAP_TAPCELL_ROW_147_1_1311 VGND VPWR sky130_fd_sc_hd__tapvpwrvgnd_1
XTAP_TAPCELL_ROW_52_1_1122 VGND VPWR sky130_fd_sc_hd__tapvpwrvgnd_1
XFILLER_205_473 VPWR VGND VPWR VGND sky130_ef_sc_hd__decap_12
XTAP_TAPCELL_ROW_201_2474 VGND VPWR sky130_fd_sc_hd__tapvpwrvgnd_1
XTAP_TAPCELL_ROW_201_2463 VGND VPWR sky130_fd_sc_hd__tapvpwrvgnd_1
XFILLER_166_1373 VPWR VGND VPWR VGND sky130_ef_sc_hd__decap_12
XFILLER_75_1256 VPWR VGND VPWR VGND sky130_ef_sc_hd__decap_12
XTAP_TAPCELL_ROW_193_2231 VGND VPWR sky130_fd_sc_hd__tapvpwrvgnd_1
XFILLER_178_837 VPWR VGND VPWR VGND sky130_ef_sc_hd__decap_12
XFILLER_53_1510 VPWR VGND VPWR VGND sky130_ef_sc_hd__decap_12
XFILLER_207_1381 VPWR VGND VPWR VGND sky130_ef_sc_hd__decap_12
XFILLER_203_1201 VPWR VGND VPWR VGND sky130_ef_sc_hd__decap_12
XTAP_TAPCELL_ROW_193_2253 VGND VPWR sky130_fd_sc_hd__tapvpwrvgnd_1
XTAP_TAPCELL_ROW_193_2242 VGND VPWR sky130_fd_sc_hd__tapvpwrvgnd_1
XANTENNA__509__A1 net149 VGND VGND VPWR VPWR sky130_fd_sc_hd__diode_2
XFILLER_53_1554 VPWR VGND VPWR VGND sky130_ef_sc_hd__decap_12
XTAP_TAPCELL_ROW_218_2960 VGND VPWR sky130_fd_sc_hd__tapvpwrvgnd_1
XFILLER_203_1245 VPWR VGND VPWR VGND sky130_ef_sc_hd__decap_12
XFILLER_186_881 VPWR VGND VPWR VGND sky130_ef_sc_hd__decap_12
XFILLER_140_1524 VGND VGND VPWR VPWR sky130_fd_sc_hd__fill_1
XFILLER_14_1538 VPWR VGND VPWR VGND sky130_ef_sc_hd__decap_12
XTAP_TAPCELL_ROW_214_2846 VGND VPWR sky130_fd_sc_hd__tapvpwrvgnd_1
XTAP_TAPCELL_ROW_214_2835 VGND VPWR sky130_fd_sc_hd__tapvpwrvgnd_1
XFILLER_203_1289 VPWR VGND VPWR VGND sky130_ef_sc_hd__decap_12
XFILLER_185_391 VGND VGND VPWR VPWR sky130_fd_sc_hd__fill_1
XFILLER_173_553 VGND VGND VPWR VPWR sky130_fd_sc_hd__decap_6
XTAP_TAPCELL_ROW_138_2_3874 VGND VPWR sky130_fd_sc_hd__tapvpwrvgnd_1
XFILLER_195_1057 VGND VGND VPWR VPWR sky130_fd_sc_hd__decap_6
XFILLER_173_597 VPWR VGND VPWR VGND sky130_ef_sc_hd__decap_12
XPHY_EDGE_ROW_137_2_Right_194 VGND VGND VPWR VPWR sky130_fd_sc_hd__decap_3
XFILLER_10_29 VPWR VGND VPWR VGND sky130_ef_sc_hd__decap_12
XTAP_TAPCELL_ROW_187_2057 VGND VPWR sky130_fd_sc_hd__tapvpwrvgnd_1
XFILLER_126_29 VPWR VGND VPWR VGND sky130_ef_sc_hd__decap_12
XTAP_TAPCELL_ROW_187_2079 VGND VPWR sky130_fd_sc_hd__tapvpwrvgnd_1
XTAP_TAPCELL_ROW_187_2068 VGND VPWR sky130_fd_sc_hd__tapvpwrvgnd_1
XFILLER_214_1341 VPWR VGND VPWR VGND sky130_ef_sc_hd__decap_12
XFILLER_173_1399 VGND VGND VPWR VPWR sky130_fd_sc_hd__fill_1
XTAP_TAPCELL_ROW_131_2_3828 VGND VPWR sky130_fd_sc_hd__tapvpwrvgnd_1
XFILLER_19_27 VPWR VGND VPWR VGND sky130_ef_sc_hd__decap_12
XFILLER_214_1385 VPWR VGND VPWR VGND sky130_ef_sc_hd__decap_12
XFILLER_210_1205 VPWR VGND VPWR VGND sky130_ef_sc_hd__decap_12
XFILLER_27_125 VGND VGND VPWR VPWR sky130_fd_sc_hd__fill_2
XFILLER_216_749 VGND VGND VPWR VPWR sky130_fd_sc_hd__decap_6
XFILLER_215_237 VPWR VGND VPWR VGND sky130_ef_sc_hd__decap_12
XFILLER_110_1350 VGND VGND VPWR VPWR sky130_fd_sc_hd__decap_6
XFILLER_35_15 VPWR VGND VPWR VGND sky130_ef_sc_hd__decap_12
XFILLER_196_601 VPWR VGND VPWR VGND sky130_ef_sc_hd__decap_12
XFILLER_110_1394 VPWR VGND VPWR VGND sky130_ef_sc_hd__decap_12
XFILLER_196_645 VPWR VGND VPWR VGND sky130_ef_sc_hd__decap_12
XFILLER_195_111 VGND VGND VPWR VPWR sky130_fd_sc_hd__fill_1
XFILLER_180_1315 VGND VGND VPWR VPWR sky130_fd_sc_hd__fill_1
XFILLER_93_1378 VGND VGND VPWR VPWR sky130_fd_sc_hd__decap_6
XFILLER_183_317 VPWR VGND VPWR VGND sky130_ef_sc_hd__decap_12
XTAP_TAPCELL_ROW_176_1761 VGND VPWR sky130_fd_sc_hd__tapvpwrvgnd_1
XTAP_TAPCELL_ROW_176_1750 VGND VPWR sky130_fd_sc_hd__tapvpwrvgnd_1
XFILLER_51_69 VPWR VGND VPWR VGND sky130_ef_sc_hd__decap_12
XTAP_TAPCELL_ROW_172_1647 VGND VPWR sky130_fd_sc_hd__tapvpwrvgnd_1
XTAP_TAPCELL_ROW_172_1636 VGND VPWR sky130_fd_sc_hd__tapvpwrvgnd_1
XFILLER_167_69 VPWR VGND VPWR VGND sky130_ef_sc_hd__decap_12
XFILLER_164_531 VGND VGND VPWR VPWR sky130_fd_sc_hd__fill_1
XFILLER_191_361 VPWR VGND VPWR VGND sky130_ef_sc_hd__decap_12
XTAP_TAPCELL_ROW_27_2_3154 VGND VPWR sky130_fd_sc_hd__tapvpwrvgnd_1
XFILLER_121_1490 VGND VGND VPWR VPWR sky130_fd_sc_hd__decap_6
XFILLER_183_57 VPWR VGND VPWR VGND sky130_ef_sc_hd__decap_12
XFILLER_3_758 VPWR VGND VPWR VGND sky130_ef_sc_hd__decap_12
XANTENNA_clkbuf_3_3_0_clk_X clknet_3_3_0_clk VGND VGND VPWR VPWR sky130_fd_sc_hd__diode_2
XFILLER_219_1285 VGND VGND VPWR VPWR sky130_fd_sc_hd__decap_3
XFILLER_191_1455 VGND VGND VPWR VPWR sky130_fd_sc_hd__fill_1
XFILLER_152_1406 VGND VGND VPWR VPWR sky130_fd_sc_hd__decap_6
XFILLER_4_1205 VPWR VGND VPWR VGND sky130_ef_sc_hd__decap_12
XANTENNA__559__A net136 VGND VGND VPWR VPWR sky130_fd_sc_hd__diode_2
XTAP_TAPCELL_ROW_20_2_3108 VGND VPWR sky130_fd_sc_hd__tapvpwrvgnd_1
XFILLER_207_727 VGND VGND VPWR VPWR sky130_fd_sc_hd__fill_1
XFILLER_115_1272 VGND VGND VPWR VPWR sky130_fd_sc_hd__fill_1
XFILLER_76_77 VGND VGND VPWR VPWR sky130_fd_sc_hd__decap_6
XFILLER_132_83 VGND VGND VPWR VPWR sky130_fd_sc_hd__fill_1
XFILLER_203_933 VPWR VGND VPWR VGND sky130_ef_sc_hd__decap_12
XFILLER_199_461 VPWR VGND VPWR VGND sky130_ef_sc_hd__decap_12
XFILLER_163_1513 VPWR VGND VPWR VGND sky130_ef_sc_hd__decap_12
XFILLER_92_65 VPWR VGND VPWR VGND sky130_ef_sc_hd__decap_12
XFILLER_202_421 VPWR VGND VPWR VGND sky130_ef_sc_hd__decap_12
X_405_ _139_ _140_ VGND VGND VPWR VPWR _141_ sky130_fd_sc_hd__or2_1
XFILLER_204_1521 VPWR VGND VPWR VGND sky130_ef_sc_hd__decap_12
XFILLER_203_977 VPWR VGND VPWR VGND sky130_ef_sc_hd__decap_12
XFILLER_186_133 VGND VGND VPWR VPWR sky130_fd_sc_hd__decap_6
X_336_ net11 net140 net152 VGND VGND VPWR VPWR _004_ sky130_fd_sc_hd__a21oi_1
XFILLER_204_1565 VPWR VGND VPWR VGND sky130_ef_sc_hd__decap_12
XFILLER_186_177 VPWR VGND VPWR VGND sky130_ef_sc_hd__decap_12
XFILLER_168_881 VPWR VGND VPWR VGND sky130_ef_sc_hd__decap_12
XFILLER_122_1232 VPWR VGND VPWR VGND sky130_ef_sc_hd__decap_12
XFILLER_200_1429 VPWR VGND VPWR VGND sky130_ef_sc_hd__decap_12
XFILLER_167_391 VGND VGND VPWR VPWR sky130_fd_sc_hd__fill_1
XTAP_TAPCELL_ROW_124_2_3782 VGND VPWR sky130_fd_sc_hd__tapvpwrvgnd_1
XPHY_EDGE_ROW_180_Left_399 VGND VGND VPWR VPWR sky130_fd_sc_hd__decap_3
XFILLER_170_501 VPWR VGND VPWR VGND sky130_ef_sc_hd__decap_12
XFILLER_183_895 VGND VGND VPWR VPWR sky130_fd_sc_hd__fill_1
XFILLER_157_1328 VGND VGND VPWR VPWR sky130_fd_sc_hd__fill_1
XFILLER_6_574 VPWR VGND VPWR VGND sky130_ef_sc_hd__decap_12
XFILLER_170_545 VPWR VGND VPWR VGND sky130_ef_sc_hd__decap_12
XFILLER_100_1574 VGND VGND VPWR VPWR sky130_fd_sc_hd__decap_6
XFILLER_170_589 VPWR VGND VPWR VGND sky130_ef_sc_hd__decap_12
XPHY_EDGE_ROW_57_1_Right_643 VGND VGND VPWR VPWR sky130_fd_sc_hd__decap_3
XFILLER_170_1539 VGND VGND VPWR VPWR sky130_fd_sc_hd__fill_1
XFILLER_211_1525 VPWR VGND VPWR VGND sky130_ef_sc_hd__decap_12
XFILLER_2_41 VPWR VGND VPWR VGND sky130_ef_sc_hd__decap_12
XFILLER_42_1244 VGND VGND VPWR VPWR sky130_fd_sc_hd__fill_1
XTAP_TAPCELL_ROW_207_2650 VGND VPWR sky130_fd_sc_hd__tapvpwrvgnd_1
XFILLER_2_85 VPWR VGND VPWR VGND sky130_ef_sc_hd__decap_12
XFILLER_211_1569 VPWR VGND VPWR VGND sky130_ef_sc_hd__decap_12
XTAP_TAPCELL_ROW_203_2536 VGND VPWR sky130_fd_sc_hd__tapvpwrvgnd_1
XTAP_TAPCELL_ROW_203_2525 VGND VPWR sky130_fd_sc_hd__tapvpwrvgnd_1
XTAP_TAPCELL_ROW_203_2514 VGND VPWR sky130_fd_sc_hd__tapvpwrvgnd_1
XTAP_TAPCELL_ROW_195_2304 VGND VPWR sky130_fd_sc_hd__tapvpwrvgnd_1
XFILLER_178_601 VPWR VGND VPWR VGND sky130_ef_sc_hd__decap_12
XFILLER_206_793 VPWR VGND VPWR VGND sky130_ef_sc_hd__decap_12
XFILLER_205_281 VPWR VGND VPWR VGND sky130_ef_sc_hd__decap_12
XFILLER_177_111 VGND VGND VPWR VPWR sky130_fd_sc_hd__fill_1
XFILLER_90_1518 VGND VGND VPWR VPWR sky130_fd_sc_hd__decap_6
XTAP_TAPCELL_ROW_216_2908 VGND VPWR sky130_fd_sc_hd__tapvpwrvgnd_1
XFILLER_178_645 VPWR VGND VPWR VGND sky130_ef_sc_hd__decap_12
XTAP_TAPCELL_ROW_9_2_3038 VGND VPWR sky130_fd_sc_hd__tapvpwrvgnd_1
XFILLER_193_615 VGND VGND VPWR VPWR sky130_fd_sc_hd__fill_1
XFILLER_165_317 VPWR VGND VPWR VGND sky130_ef_sc_hd__decap_12
XFILLER_14_1302 VPWR VGND VPWR VGND sky130_ef_sc_hd__decap_12
XFILLER_18_1482 VPWR VGND VPWR VGND sky130_ef_sc_hd__decap_12
XFILLER_197_1119 VGND VGND VPWR VPWR sky130_fd_sc_hd__fill_1
XFILLER_88_1414 VPWR VGND VPWR VGND sky130_ef_sc_hd__decap_12
XANTENNA_fanout124_A net125 VGND VGND VPWR VPWR sky130_fd_sc_hd__diode_2
XTAP_TAPCELL_ROW_13_2_3062 VGND VPWR sky130_fd_sc_hd__tapvpwrvgnd_1
XFILLER_53_1384 VGND VGND VPWR VPWR sky130_fd_sc_hd__fill_1
XFILLER_180_309 VPWR VGND VPWR VGND sky130_ef_sc_hd__decap_12
XFILLER_105_1496 VGND VGND VPWR VPWR sky130_fd_sc_hd__fill_1
XTAP_TAPCELL_ROW_189_2119 VGND VPWR sky130_fd_sc_hd__tapvpwrvgnd_1
XFILLER_173_361 VPWR VGND VPWR VGND sky130_ef_sc_hd__decap_12
XFILLER_137_39 VPWR VGND VPWR VGND sky130_ef_sc_hd__decap_12
XPHY_EDGE_ROW_138_2_Right_195 VGND VGND VPWR VPWR sky130_fd_sc_hd__decap_3
Xoutput120 net120 VGND VGND VPWR VPWR func_rdata[9] sky130_fd_sc_hd__buf_2
XFILLER_153_27 VPWR VGND VPWR VGND sky130_ef_sc_hd__decap_12
XFILLER_138_1294 VGND VGND VPWR VPWR sky130_fd_sc_hd__decap_6
XFILLER_101_111 VGND VGND VPWR VPWR sky130_fd_sc_hd__fill_1
XFILLER_0_739 VGND VGND VPWR VPWR sky130_fd_sc_hd__fill_1
XFILLER_60_1300 VGND VGND VPWR VPWR sky130_fd_sc_hd__fill_1
XFILLER_99_1510 VPWR VGND VPWR VGND sky130_ef_sc_hd__decap_12
XFILLER_5_1525 VPWR VGND VPWR VGND sky130_ef_sc_hd__decap_12
XANTENNA__379__A b_addr\[0\] VGND VGND VPWR VPWR sky130_fd_sc_hd__diode_2
XFILLER_25_1442 VPWR VGND VPWR VGND sky130_ef_sc_hd__decap_12
XFILLER_210_1035 VGND VGND VPWR VPWR sky130_fd_sc_hd__fill_1
XTAP_TAPCELL_ROW_165_1451 VGND VPWR sky130_fd_sc_hd__tapvpwrvgnd_1
XTAP_TAPCELL_ROW_165_1440 VGND VPWR sky130_fd_sc_hd__tapvpwrvgnd_1
XFILLER_112_1412 VGND VGND VPWR VPWR sky130_fd_sc_hd__fill_1
XFILLER_21_1328 VGND VGND VPWR VPWR sky130_fd_sc_hd__fill_1
XFILLER_216_513 VPWR VGND VPWR VGND sky130_ef_sc_hd__decap_12
XFILLER_99_1554 VPWR VGND VPWR VGND sky130_ef_sc_hd__decap_12
XFILLER_5_1569 VPWR VGND VPWR VGND sky130_ef_sc_hd__decap_12
XFILLER_216_557 VPWR VGND VPWR VGND sky130_ef_sc_hd__decap_12
XFILLER_102_53 VPWR VGND VPWR VGND sky130_ef_sc_hd__decap_12
XFILLER_197_921 VPWR VGND VPWR VGND sky130_ef_sc_hd__decap_12
XTAP_TAPCELL_ROW_178_1823 VGND VPWR sky130_fd_sc_hd__tapvpwrvgnd_1
XTAP_TAPCELL_ROW_178_1812 VGND VPWR sky130_fd_sc_hd__tapvpwrvgnd_1
XTAP_TAPCELL_ROW_178_1801 VGND VPWR sky130_fd_sc_hd__tapvpwrvgnd_1
XFILLER_145_1232 VPWR VGND VPWR VGND sky130_ef_sc_hd__decap_12
XFILLER_102_97 VPWR VGND VPWR VGND sky130_ef_sc_hd__decap_12
XFILLER_200_925 VPWR VGND VPWR VGND sky130_ef_sc_hd__decap_12
XFILLER_197_965 VPWR VGND VPWR VGND sky130_ef_sc_hd__decap_12
XFILLER_168_133 VGND VGND VPWR VPWR sky130_fd_sc_hd__decap_6
XFILLER_19_1268 VGND VGND VPWR VPWR sky130_fd_sc_hd__decap_4
XFILLER_211_273 VGND VGND VPWR VPWR sky130_fd_sc_hd__decap_6
XFILLER_196_475 VGND VGND VPWR VPWR sky130_fd_sc_hd__fill_1
XTAP_TAPCELL_ROW_174_1709 VGND VPWR sky130_fd_sc_hd__tapvpwrvgnd_1
XFILLER_168_177 VPWR VGND VPWR VGND sky130_ef_sc_hd__decap_12
XFILLER_145_1298 VPWR VGND VPWR VGND sky130_ef_sc_hd__decap_12
XFILLER_134_3 VPWR VGND VPWR VGND sky130_ef_sc_hd__decap_12
XTAP_TAPCELL_ROW_110_2_3690 VGND VPWR sky130_fd_sc_hd__tapvpwrvgnd_1
XTAP_TAPCELL_ROW_109_2_3684 VGND VPWR sky130_fd_sc_hd__tapvpwrvgnd_1
XFILLER_71_1440 VGND VGND VPWR VPWR sky130_fd_sc_hd__fill_1
XFILLER_7_305 VGND VGND VPWR VPWR sky130_fd_sc_hd__decap_3
XFILLER_36_1582 VPWR VGND VPWR VGND sky130_ef_sc_hd__decap_12
XFILLER_184_637 VGND VGND VPWR VPWR sky130_fd_sc_hd__decap_6
XFILLER_183_125 VPWR VGND VPWR VGND sky130_ef_sc_hd__decap_12
XFILLER_123_1552 VGND VGND VPWR VPWR sky130_fd_sc_hd__fill_1
XTAP_TAPCELL_ROW_109_1_1236 VGND VPWR sky130_fd_sc_hd__tapvpwrvgnd_1
XFILLER_183_169 VPWR VGND VPWR VGND sky130_ef_sc_hd__decap_12
XFILLER_7_349 VPWR VGND VPWR VGND sky130_ef_sc_hd__decap_12
XFILLER_32_1468 VGND VGND VPWR VPWR sky130_fd_sc_hd__fill_1
XFILLER_192_681 VPWR VGND VPWR VGND sky130_ef_sc_hd__decap_12
XFILLER_165_895 VGND VGND VPWR VPWR sky130_fd_sc_hd__fill_1
XANTENNA__280__C b_addr\[1\] VGND VGND VPWR VPWR sky130_fd_sc_hd__diode_2
XFILLER_178_1085 VGND VGND VPWR VPWR sky130_fd_sc_hd__decap_6
XFILLER_156_1350 VGND VGND VPWR VPWR sky130_fd_sc_hd__decap_6
XTAP_TAPCELL_ROW_102_2_3638 VGND VPWR sky130_fd_sc_hd__tapvpwrvgnd_1
XTAP_TAPCELL_ROW_76_1_1170 VGND VPWR sky130_fd_sc_hd__tapvpwrvgnd_1
XFILLER_65_1244 VPWR VGND VPWR VGND sky130_ef_sc_hd__decap_12
XFILLER_3_588 VGND VGND VPWR VPWR sky130_fd_sc_hd__fill_1
XFILLER_219_1093 VPWR VGND VPWR VGND sky130_ef_sc_hd__decap_12
XFILLER_156_1394 VPWR VGND VPWR VGND sky130_ef_sc_hd__decap_12
XFILLER_152_1258 VPWR VGND VPWR VGND sky130_ef_sc_hd__decap_12
XFILLER_117_1378 VGND VGND VPWR VPWR sky130_fd_sc_hd__decap_6
XFILLER_82_1580 VGND VGND VPWR VPWR sky130_fd_sc_hd__fill_1
XFILLER_185_1001 VGND VGND VPWR VPWR sky130_fd_sc_hd__decap_6
XFILLER_143_93 VPWR VGND VPWR VGND sky130_ef_sc_hd__decap_12
XFILLER_4_1035 VGND VGND VPWR VPWR sky130_fd_sc_hd__fill_1
XTAP_TAPCELL_ROW_50_2_3303 VGND VPWR sky130_fd_sc_hd__tapvpwrvgnd_1
XFILLER_185_1045 VPWR VGND VPWR VGND sky130_ef_sc_hd__decap_12
XFILLER_203_741 VPWR VGND VPWR VGND sky130_ef_sc_hd__decap_12
XFILLER_185_1089 VPWR VGND VPWR VGND sky130_ef_sc_hd__decap_12
XFILLER_202_251 VGND VGND VPWR VPWR sky130_fd_sc_hd__fill_1
XFILLER_159_111 VGND VGND VPWR VPWR sky130_fd_sc_hd__fill_1
XFILLER_203_785 VPWR VGND VPWR VGND sky130_ef_sc_hd__decap_12
XFILLER_175_615 VGND VGND VPWR VPWR sky130_fd_sc_hd__fill_1
XFILLER_124_1338 VPWR VGND VPWR VGND sky130_ef_sc_hd__decap_12
XFILLER_204_1373 VPWR VGND VPWR VGND sky130_ef_sc_hd__decap_12
XFILLER_187_497 VGND VGND VPWR VPWR sky130_fd_sc_hd__decap_6
Xinput11 func_ce VGND VGND VPWR VPWR net11 sky130_fd_sc_hd__clkbuf_1
Xinput22 func_wdata[19] VGND VGND VPWR VPWR net22 sky130_fd_sc_hd__clkbuf_1
X_319_ net30 net143 net134 VGND VGND VPWR VPWR s_wdata\[26\] sky130_fd_sc_hd__a21o_1
XFILLER_50_1524 VGND VGND VPWR VPWR sky130_fd_sc_hd__fill_1
Xinput33 func_wdata[29] VGND VGND VPWR VPWR net33 sky130_fd_sc_hd__clkbuf_1
Xinput44 func_we VGND VGND VPWR VPWR net44 sky130_fd_sc_hd__clkbuf_1
XPHY_EDGE_ROW_28_2_Left_460 VGND VGND VPWR VPWR sky130_fd_sc_hd__decap_3
XFILLER_200_1259 VGND VGND VPWR VPWR sky130_fd_sc_hd__fill_1
XFILLER_196_1141 VGND VGND VPWR VPWR sky130_fd_sc_hd__decap_6
XFILLER_171_821 VPWR VGND VPWR VGND sky130_ef_sc_hd__decap_12
XFILLER_196_1185 VPWR VGND VPWR VGND sky130_ef_sc_hd__decap_12
XFILLER_192_1005 VPWR VGND VPWR VGND sky130_ef_sc_hd__decap_12
XFILLER_171_865 VPWR VGND VPWR VGND sky130_ef_sc_hd__decap_12
XFILLER_192_1049 VPWR VGND VPWR VGND sky130_ef_sc_hd__decap_12
XFILLER_100_1382 VPWR VGND VPWR VGND sky130_ef_sc_hd__decap_12
XFILLER_88_109 VPWR VGND VPWR VGND sky130_ef_sc_hd__decap_12
XFILLER_83_1322 VGND VGND VPWR VPWR sky130_fd_sc_hd__decap_6
XTAP_TAPCELL_ROW_209_2701 VGND VPWR sky130_fd_sc_hd__tapvpwrvgnd_1
XFILLER_174_1483 VGND VGND VPWR VPWR sky130_fd_sc_hd__fill_1
XFILLER_135_1434 VGND VGND VPWR VPWR sky130_fd_sc_hd__decap_6
XFILLER_83_1366 VPWR VGND VPWR VGND sky130_ef_sc_hd__decap_12
XFILLER_135_1478 VPWR VGND VPWR VGND sky130_ef_sc_hd__decap_12
XPHY_EDGE_ROW_58_1_Right_644 VGND VGND VPWR VPWR sky130_fd_sc_hd__decap_3
XTAP_TAPCELL_ROW_146_2_3925 VGND VPWR sky130_fd_sc_hd__tapvpwrvgnd_1
XFILLER_211_1399 VGND VGND VPWR VPWR sky130_fd_sc_hd__fill_1
XFILLER_20_1350 VGND VGND VPWR VPWR sky130_fd_sc_hd__decap_6
XFILLER_213_505 VPWR VGND VPWR VGND sky130_ef_sc_hd__decap_12
XFILLER_197_217 VGND VGND VPWR VPWR sky130_fd_sc_hd__decap_6
XFILLER_179_921 VPWR VGND VPWR VGND sky130_ef_sc_hd__decap_12
XFILLER_164_1129 VPWR VGND VPWR VGND sky130_ef_sc_hd__decap_12
XFILLER_94_1462 VGND VGND VPWR VPWR sky130_fd_sc_hd__decap_6
XTAP_TAPCELL_ROW_20_1_1057 VGND VPWR sky130_fd_sc_hd__tapvpwrvgnd_1
XFILLER_20_1394 VPWR VGND VPWR VGND sky130_ef_sc_hd__decap_12
XFILLER_179_965 VPWR VGND VPWR VGND sky130_ef_sc_hd__decap_12
XFILLER_146_1574 VGND VGND VPWR VPWR sky130_fd_sc_hd__decap_6
XFILLER_90_1326 VPWR VGND VPWR VGND sky130_ef_sc_hd__decap_12
XFILLER_178_475 VGND VGND VPWR VPWR sky130_fd_sc_hd__fill_1
XFILLER_142_1438 VPWR VGND VPWR VGND sky130_ef_sc_hd__decap_12
XFILLER_32_27 VGND VGND VPWR VPWR sky130_fd_sc_hd__fill_1
XPHY_EDGE_ROW_39_2_Right_96 VGND VGND VPWR VPWR sky130_fd_sc_hd__decap_3
XFILLER_166_637 VGND VGND VPWR VPWR sky130_fd_sc_hd__decap_6
XFILLER_165_125 VPWR VGND VPWR VGND sky130_ef_sc_hd__decap_12
XFILLER_148_27 VGND VGND VPWR VPWR sky130_fd_sc_hd__fill_1
XFILLER_194_979 VGND VGND VPWR VPWR sky130_fd_sc_hd__fill_1
XFILLER_165_169 VPWR VGND VPWR VGND sky130_ef_sc_hd__decap_12
XFILLER_181_629 VPWR VGND VPWR VGND sky130_ef_sc_hd__decap_12
XFILLER_174_681 VPWR VGND VPWR VGND sky130_ef_sc_hd__decap_12
XFILLER_88_1244 VGND VGND VPWR VPWR sky130_fd_sc_hd__fill_1
XFILLER_218_1509 VPWR VGND VPWR VGND sky130_ef_sc_hd__decap_12
XFILLER_180_139 VGND VGND VPWR VPWR sky130_fd_sc_hd__fill_1
XFILLER_175_1225 VGND VGND VPWR VPWR sky130_fd_sc_hd__decap_6
XFILLER_164_15 VPWR VGND VPWR VGND sky130_ef_sc_hd__decap_12
XFILLER_31_1490 VGND VGND VPWR VPWR sky130_fd_sc_hd__decap_6
XFILLER_175_1269 VPWR VGND VPWR VGND sky130_ef_sc_hd__decap_12
XTAP_TAPCELL_ROW_167_1502 VGND VPWR sky130_fd_sc_hd__tapvpwrvgnd_1
XFILLER_153_1534 VPWR VGND VPWR VGND sky130_ef_sc_hd__decap_12
XPHY_EDGE_ROW_139_2_Right_196 VGND VGND VPWR VPWR sky130_fd_sc_hd__decap_3
XFILLER_0_514 VGND VGND VPWR VPWR sky130_fd_sc_hd__decap_4
XFILLER_62_1406 VGND VGND VPWR VPWR sky130_fd_sc_hd__decap_6
XTAP_TAPCELL_ROW_167_1513 VGND VPWR sky130_fd_sc_hd__tapvpwrvgnd_1
XFILLER_153_1578 VPWR VGND VPWR VGND sky130_ef_sc_hd__decap_12
XFILLER_114_1518 VGND VGND VPWR VPWR sky130_fd_sc_hd__decap_6
XTAP_TAPCELL_ROW_35_2_3205 VGND VPWR sky130_fd_sc_hd__tapvpwrvgnd_1
XFILLER_57_57 VPWR VGND VPWR VGND sky130_ef_sc_hd__decap_12
XFILLER_217_833 VGND VGND VPWR VPWR sky130_fd_sc_hd__decap_6
XFILLER_169_1007 VGND VGND VPWR VPWR sky130_fd_sc_hd__fill_1
XFILLER_112_1220 VPWR VGND VPWR VGND sky130_ef_sc_hd__decap_12
XFILLER_25_1272 VGND VGND VPWR VPWR sky130_fd_sc_hd__fill_1
XFILLER_217_877 VPWR VGND VPWR VGND sky130_ef_sc_hd__decap_12
XFILLER_216_321 VPWR VGND VPWR VGND sky130_ef_sc_hd__decap_12
XPHY_EDGE_ROW_156_2_Left_588 VGND VGND VPWR VPWR sky130_fd_sc_hd__decap_3
XFILLER_99_1384 VGND VGND VPWR VPWR sky130_fd_sc_hd__fill_1
XTAP_TAPCELL_ROW_4_897 VGND VPWR sky130_fd_sc_hd__tapvpwrvgnd_1
XFILLER_5_1399 VGND VGND VPWR VPWR sky130_fd_sc_hd__fill_1
XFILLER_216_365 VPWR VGND VPWR VGND sky130_ef_sc_hd__decap_12
XFILLER_186_1365 VGND VGND VPWR VPWR sky130_fd_sc_hd__decap_6
XFILLER_189_729 VPWR VGND VPWR VGND sky130_ef_sc_hd__decap_12
XFILLER_182_1229 VPWR VGND VPWR VGND sky130_ef_sc_hd__decap_12
XPHY_EDGE_ROW_93_2_Left_525 VGND VGND VPWR VPWR sky130_fd_sc_hd__decap_3
XFILLER_73_1546 VGND VGND VPWR VPWR sky130_fd_sc_hd__decap_6
XFILLER_184_401 VPWR VGND VPWR VGND sky130_ef_sc_hd__decap_12
XFILLER_160_1538 VPWR VGND VPWR VGND sky130_ef_sc_hd__decap_12
XFILLER_201_1513 VPWR VGND VPWR VGND sky130_ef_sc_hd__decap_12
XFILLER_200_755 VGND VGND VPWR VPWR sky130_fd_sc_hd__fill_1
XFILLER_184_445 VPWR VGND VPWR VGND sky130_ef_sc_hd__decap_12
XFILLER_169_497 VGND VGND VPWR VPWR sky130_fd_sc_hd__decap_6
XFILLER_7_113 VGND VGND VPWR VPWR sky130_fd_sc_hd__fill_2
XPHY_EDGE_ROW_13_1_Left_232 VGND VGND VPWR VPWR sky130_fd_sc_hd__decap_3
XFILLER_32_1232 VPWR VGND VPWR VGND sky130_ef_sc_hd__decap_12
XFILLER_184_489 VPWR VGND VPWR VGND sky130_ef_sc_hd__decap_12
XFILLER_158_1412 VGND VGND VPWR VPWR sky130_fd_sc_hd__fill_1
XFILLER_22_82 VGND VGND VPWR VPWR sky130_fd_sc_hd__fill_2
XTAP_TAPCELL_ROW_45_1_1108 VGND VPWR sky130_fd_sc_hd__tapvpwrvgnd_1
XFILLER_193_1325 VPWR VGND VPWR VGND sky130_ef_sc_hd__decap_12
XFILLER_98_53 VPWR VGND VPWR VGND sky130_ef_sc_hd__decap_12
XFILLER_67_1328 VGND VGND VPWR VPWR sky130_fd_sc_hd__fill_1
XFILLER_4_853 VGND VGND VPWR VPWR sky130_fd_sc_hd__fill_1
XFILLER_193_1369 VPWR VGND VPWR VGND sky130_ef_sc_hd__decap_12
XTAP_TAPCELL_ROW_152_2_3968 VGND VPWR sky130_fd_sc_hd__tapvpwrvgnd_1
XFILLER_10_1574 VGND VGND VPWR VPWR sky130_fd_sc_hd__decap_6
XFILLER_98_97 VPWR VGND VPWR VGND sky130_ef_sc_hd__decap_12
XFILLER_80_1506 VPWR VGND VPWR VGND sky130_ef_sc_hd__decap_12
XTAP_TAPCELL_ROW_132_2_3833 VGND VPWR sky130_fd_sc_hd__tapvpwrvgnd_1
XFILLER_208_811 VGND VGND VPWR VPWR sky130_fd_sc_hd__fill_1
XFILLER_219_181 VPWR VGND VPWR VGND sky130_ef_sc_hd__decap_12
XFILLER_78_1468 VGND VGND VPWR VPWR sky130_fd_sc_hd__fill_1
XFILLER_179_217 VGND VGND VPWR VPWR sky130_fd_sc_hd__decap_6
XFILLER_165_1449 VGND VGND VPWR VPWR sky130_fd_sc_hd__decap_6
XFILLER_91_1602 VGND VGND VPWR VPWR sky130_fd_sc_hd__decap_3
XFILLER_97_3 VPWR VGND VPWR VGND sky130_ef_sc_hd__decap_12
XFILLER_194_209 VPWR VGND VPWR VGND sky130_ef_sc_hd__decap_12
XFILLER_187_261 VPWR VGND VPWR VGND sky130_ef_sc_hd__decap_12
XFILLER_163_1173 VGND VGND VPWR VPWR sky130_fd_sc_hd__decap_3
XFILLER_128_1282 VPWR VGND VPWR VGND sky130_ef_sc_hd__decap_12
XFILLER_198_1203 VGND VGND VPWR VPWR sky130_fd_sc_hd__fill_1
XFILLER_147_125 VGND VGND VPWR VPWR sky130_fd_sc_hd__fill_2
XANTENNA__482__A net149 VGND VGND VPWR VPWR sky130_fd_sc_hd__diode_2
XFILLER_176_979 VGND VGND VPWR VPWR sky130_fd_sc_hd__fill_1
XFILLER_106_1580 VGND VGND VPWR VPWR sky130_fd_sc_hd__fill_1
XFILLER_163_629 VPWR VGND VPWR VGND sky130_ef_sc_hd__decap_12
XFILLER_15_1496 VGND VGND VPWR VPWR sky130_fd_sc_hd__fill_1
XFILLER_176_1589 VGND VGND VPWR VPWR sky130_fd_sc_hd__decap_6
XFILLER_172_1409 VPWR VGND VPWR VGND sky130_ef_sc_hd__decap_12
XFILLER_171_673 VPWR VGND VPWR VGND sky130_ef_sc_hd__decap_12
XFILLER_135_1220 VPWR VGND VPWR VGND sky130_ef_sc_hd__decap_12
XFILLER_134_29 VPWR VGND VPWR VGND sky130_ef_sc_hd__decap_12
XFILLER_48_1294 VGND VGND VPWR VPWR sky130_fd_sc_hd__decap_6
XFILLER_135_1286 VPWR VGND VPWR VGND sky130_ef_sc_hd__decap_12
XPHY_EDGE_ROW_89_1_Left_308 VGND VGND VPWR VPWR sky130_fd_sc_hd__decap_3
XTAP_TAPCELL_ROW_21_2_3113 VGND VPWR sky130_fd_sc_hd__tapvpwrvgnd_1
XPHY_EDGE_ROW_59_1_Right_645 VGND VGND VPWR VPWR sky130_fd_sc_hd__decap_3
XFILLER_22_1412 VGND VGND VPWR VPWR sky130_fd_sc_hd__fill_1
XPHY_EDGE_ROW_214_Right_59 VGND VGND VPWR VPWR sky130_fd_sc_hd__decap_3
XFILLER_96_1524 VGND VGND VPWR VPWR sky130_fd_sc_hd__fill_1
XFILLER_2_1539 VGND VGND VPWR VPWR sky130_fd_sc_hd__fill_1
XTAP_TAPCELL_ROW_1_834 VGND VPWR sky130_fd_sc_hd__tapvpwrvgnd_1
XTAP_TAPCELL_ROW_1_823 VGND VPWR sky130_fd_sc_hd__tapvpwrvgnd_1
XTAP_TAPCELL_ROW_1_812 VGND VPWR sky130_fd_sc_hd__tapvpwrvgnd_1
XFILLER_27_38 VPWR VGND VPWR VGND sky130_ef_sc_hd__decap_12
XFILLER_214_825 VPWR VGND VPWR VGND sky130_ef_sc_hd__decap_12
XFILLER_183_1505 VGND VGND VPWR VPWR sky130_fd_sc_hd__decap_6
XFILLER_213_335 VGND VGND VPWR VPWR sky130_fd_sc_hd__fill_1
XFILLER_183_1549 VPWR VGND VPWR VGND sky130_ef_sc_hd__decap_12
XFILLER_168_1073 VPWR VGND VPWR VGND sky130_ef_sc_hd__decap_12
XFILLER_214_869 VPWR VGND VPWR VGND sky130_ef_sc_hd__decap_12
XFILLER_94_1270 VPWR VGND VPWR VGND sky130_ef_sc_hd__decap_12
XFILLER_0_1285 VGND VGND VPWR VPWR sky130_fd_sc_hd__decap_3
XFILLER_43_15 VPWR VGND VPWR VGND sky130_ef_sc_hd__decap_12
XFILLER_55_1232 VPWR VGND VPWR VGND sky130_ef_sc_hd__decap_12
XFILLER_166_401 VPWR VGND VPWR VGND sky130_ef_sc_hd__decap_12
XFILLER_159_15 VPWR VGND VPWR VGND sky130_ef_sc_hd__decap_12
XFILLER_146_1382 VPWR VGND VPWR VGND sky130_ef_sc_hd__decap_12
XFILLER_107_1322 VGND VGND VPWR VPWR sky130_fd_sc_hd__decap_6
XFILLER_142_1246 VPWR VGND VPWR VGND sky130_ef_sc_hd__decap_12
XFILLER_107_1366 VPWR VGND VPWR VGND sky130_ef_sc_hd__decap_12
XFILLER_55_1298 VPWR VGND VPWR VGND sky130_ef_sc_hd__decap_12
XFILLER_182_905 VPWR VGND VPWR VGND sky130_ef_sc_hd__decap_12
XFILLER_166_445 VPWR VGND VPWR VGND sky130_ef_sc_hd__decap_12
XFILLER_33_1552 VGND VGND VPWR VPWR sky130_fd_sc_hd__fill_1
XFILLER_182_949 VPWR VGND VPWR VGND sky130_ef_sc_hd__decap_12
XFILLER_166_489 VPWR VGND VPWR VGND sky130_ef_sc_hd__decap_12
XANTENNA__324__A2 net144 VGND VGND VPWR VPWR sky130_fd_sc_hd__diode_2
XFILLER_4_127 VGND VGND VPWR VPWR sky130_fd_sc_hd__decap_8
XFILLER_218_1317 VPWR VGND VPWR VGND sky130_ef_sc_hd__decap_12
XFILLER_190_1509 VPWR VGND VPWR VGND sky130_ef_sc_hd__decap_12
XFILLER_190_993 VPWR VGND VPWR VGND sky130_ef_sc_hd__decap_12
XFILLER_175_1033 VPWR VGND VPWR VGND sky130_ef_sc_hd__decap_12
XFILLER_175_69 VPWR VGND VPWR VGND sky130_ef_sc_hd__decap_12
XFILLER_108_41 VPWR VGND VPWR VGND sky130_ef_sc_hd__decap_12
XFILLER_175_1077 VPWR VGND VPWR VGND sky130_ef_sc_hd__decap_12
XFILLER_108_85 VPWR VGND VPWR VGND sky130_ef_sc_hd__decap_12
XFILLER_66_1350 VGND VGND VPWR VPWR sky130_fd_sc_hd__decap_6
XANTENNA__331__S net140 VGND VGND VPWR VPWR sky130_fd_sc_hd__diode_2
XFILLER_153_1342 VPWR VGND VPWR VGND sky130_ef_sc_hd__decap_12
XFILLER_118_1462 VGND VGND VPWR VPWR sky130_fd_sc_hd__decap_6
XFILLER_66_1394 VPWR VGND VPWR VGND sky130_ef_sc_hd__decap_12
XFILLER_0_333 VGND VGND VPWR VPWR sky130_fd_sc_hd__decap_3
XFILLER_216_1085 VGND VGND VPWR VPWR sky130_fd_sc_hd__decap_6
XFILLER_191_57 VPWR VGND VPWR VGND sky130_ef_sc_hd__decap_12
XFILLER_153_1386 VPWR VGND VPWR VGND sky130_ef_sc_hd__decap_12
XFILLER_114_1326 VPWR VGND VPWR VGND sky130_ef_sc_hd__decap_12
XFILLER_0_388 VGND VGND VPWR VPWR sky130_fd_sc_hd__fill_2
XFILLER_27_1378 VGND VGND VPWR VPWR sky130_fd_sc_hd__decap_6
XFILLER_62_1258 VPWR VGND VPWR VGND sky130_ef_sc_hd__decap_12
XFILLER_188_1427 VGND VGND VPWR VPWR sky130_fd_sc_hd__fill_1
XFILLER_217_641 VPWR VGND VPWR VGND sky130_ef_sc_hd__decap_12
XANTENNA_input17_A func_wdata[14] VGND VGND VPWR VPWR sky130_fd_sc_hd__diode_2
XFILLER_217_685 VPWR VGND VPWR VGND sky130_ef_sc_hd__decap_12
XFILLER_84_77 VGND VGND VPWR VPWR sky130_fd_sc_hd__decap_6
XTAP_TAPCELL_ROW_65_2_3400 VGND VPWR sky130_fd_sc_hd__tapvpwrvgnd_1
XFILLER_216_195 VGND VGND VPWR VPWR sky130_fd_sc_hd__fill_1
XFILLER_186_1173 VPWR VGND VPWR VGND sky130_ef_sc_hd__decap_12
X_584_ clknet_3_3_0_clk _018_ VGND VGND VPWR VPWR b_addr\[0\] sky130_fd_sc_hd__dfxtp_2
XFILLER_204_357 VGND VGND VPWR VPWR sky130_fd_sc_hd__decap_6
XFILLER_189_559 VGND VGND VPWR VPWR sky130_fd_sc_hd__fill_1
XFILLER_182_1037 VPWR VGND VPWR VGND sky130_ef_sc_hd__decap_12
XFILLER_140_83 VGND VGND VPWR VPWR sky130_fd_sc_hd__fill_1
XFILLER_77_1490 VGND VGND VPWR VPWR sky130_fd_sc_hd__decap_6
XFILLER_73_1310 VPWR VGND VPWR VGND sky130_ef_sc_hd__decap_12
XFILLER_176_209 VPWR VGND VPWR VGND sky130_ef_sc_hd__decap_12
XFILLER_160_1302 VPWR VGND VPWR VGND sky130_ef_sc_hd__decap_12
XFILLER_125_1422 VPWR VGND VPWR VGND sky130_ef_sc_hd__decap_12
XFILLER_73_1354 VPWR VGND VPWR VGND sky130_ef_sc_hd__decap_12
XFILLER_185_721 VGND VGND VPWR VPWR sky130_fd_sc_hd__decap_6
XFILLER_169_261 VPWR VGND VPWR VGND sky130_ef_sc_hd__decap_12
XFILLER_129_125 VGND VGND VPWR VPWR sky130_fd_sc_hd__fill_2
XFILLER_125_1466 VPWR VGND VPWR VGND sky130_ef_sc_hd__decap_12
XFILLER_73_1398 VPWR VGND VPWR VGND sky130_ef_sc_hd__decap_12
XFILLER_34_1338 VPWR VGND VPWR VGND sky130_ef_sc_hd__decap_12
XFILLER_219_29 VPWR VGND VPWR VGND sky130_ef_sc_hd__decap_12
XFILLER_185_765 VPWR VGND VPWR VGND sky130_ef_sc_hd__decap_12
XFILLER_184_253 VPWR VGND VPWR VGND sky130_ef_sc_hd__decap_12
XFILLER_201_1343 VGND VGND VPWR VPWR sky130_fd_sc_hd__fill_1
XFILLER_199_1567 VGND VGND VPWR VPWR sky130_fd_sc_hd__fill_1
XFILLER_149_81 VPWR VGND VPWR VGND sky130_ef_sc_hd__decap_12
XFILLER_158_1220 VPWR VGND VPWR VGND sky130_ef_sc_hd__decap_12
XFILLER_193_1133 VPWR VGND VPWR VGND sky130_ef_sc_hd__decap_12
XFILLER_4_661 VGND VGND VPWR VPWR sky130_fd_sc_hd__fill_1
XFILLER_193_1177 VPWR VGND VPWR VGND sky130_ef_sc_hd__decap_12
XFILLER_84_1450 VPWR VGND VPWR VGND sky130_ef_sc_hd__decap_12
XFILLER_10_1382 VPWR VGND VPWR VGND sky130_ef_sc_hd__decap_12
XFILLER_136_1562 VPWR VGND VPWR VGND sky130_ef_sc_hd__decap_12
XFILLER_84_1494 VPWR VGND VPWR VGND sky130_ef_sc_hd__decap_12
XFILLER_80_1314 VPWR VGND VPWR VGND sky130_ef_sc_hd__decap_12
XFILLER_45_1434 VGND VGND VPWR VPWR sky130_fd_sc_hd__decap_6
XFILLER_132_1426 VPWR VGND VPWR VGND sky130_ef_sc_hd__decap_12
XFILLER_80_1358 VPWR VGND VPWR VGND sky130_ef_sc_hd__decap_12
XFILLER_45_1478 VPWR VGND VPWR VGND sky130_ef_sc_hd__decap_12
XFILLER_212_1483 VGND VGND VPWR VPWR sky130_fd_sc_hd__fill_1
XFILLER_78_1232 VPWR VGND VPWR VGND sky130_ef_sc_hd__decap_12
XFILLER_169_1393 VGND VGND VPWR VPWR sky130_fd_sc_hd__decap_6
XFILLER_165_1213 VPWR VGND VPWR VGND sky130_ef_sc_hd__decap_12
XFILLER_1_1561 VGND VGND VPWR VPWR sky130_fd_sc_hd__decap_6
XFILLER_165_1257 VPWR VGND VPWR VGND sky130_ef_sc_hd__decap_12
XFILLER_95_1590 VPWR VGND VPWR VGND sky130_ef_sc_hd__decap_12
XFILLER_91_1410 VPWR VGND VPWR VGND sky130_ef_sc_hd__decap_12
XFILLER_211_839 VGND VGND VPWR VPWR sky130_fd_sc_hd__fill_1
XFILLER_200_53 VPWR VGND VPWR VGND sky130_ef_sc_hd__decap_12
XFILLER_195_529 VPWR VGND VPWR VGND sky130_ef_sc_hd__decap_12
XFILLER_143_1522 VPWR VGND VPWR VGND sky130_ef_sc_hd__decap_12
XFILLER_91_1454 VPWR VGND VPWR VGND sky130_ef_sc_hd__decap_12
Xu_sram.u_mem_160 VGND VGND VPWR VPWR u_sram.u_mem_160/HI net160 sky130_fd_sc_hd__conb_1
XFILLER_56_1574 VGND VGND VPWR VPWR sky130_fd_sc_hd__decap_6
XFILLER_188_581 VGND VGND VPWR VPWR sky130_fd_sc_hd__decap_6
XFILLER_104_1506 VPWR VGND VPWR VGND sky130_ef_sc_hd__decap_12
XFILLER_91_1498 VPWR VGND VPWR VGND sky130_ef_sc_hd__decap_12
XFILLER_52_1438 VPWR VGND VPWR VGND sky130_ef_sc_hd__decap_12
XFILLER_202_1129 VPWR VGND VPWR VGND sky130_ef_sc_hd__decap_12
XFILLER_200_97 VPWR VGND VPWR VGND sky130_ef_sc_hd__decap_12
XFILLER_164_905 VPWR VGND VPWR VGND sky130_ef_sc_hd__decap_12
XFILLER_143_1566 VPWR VGND VPWR VGND sky130_ef_sc_hd__decap_12
XFILLER_164_949 VPWR VGND VPWR VGND sky130_ef_sc_hd__decap_12
XTAP_TAPCELL_ROW_123_2_3778 VGND VPWR sky130_fd_sc_hd__tapvpwrvgnd_1
XANTENNA__362__D b_addr\[0\] VGND VGND VPWR VPWR sky130_fd_sc_hd__diode_2
XFILLER_209_51 VGND VGND VPWR VPWR sky130_fd_sc_hd__decap_4
XFILLER_190_245 VGND VGND VPWR VPWR sky130_fd_sc_hd__decap_6
XTAP_TAPCELL_ROW_91_2_3567 VGND VPWR sky130_fd_sc_hd__tapvpwrvgnd_1
XFILLER_176_1353 VPWR VGND VPWR VGND sky130_ef_sc_hd__decap_12
XFILLER_150_109 VPWR VGND VPWR VGND sky130_ef_sc_hd__decap_12
XFILLER_190_289 VPWR VGND VPWR VGND sky130_ef_sc_hd__decap_12
XFILLER_176_1397 VPWR VGND VPWR VGND sky130_ef_sc_hd__decap_12
XFILLER_172_1217 VPWR VGND VPWR VGND sky130_ef_sc_hd__decap_12
XFILLER_172_993 VPWR VGND VPWR VGND sky130_ef_sc_hd__decap_12
XFILLER_145_39 VPWR VGND VPWR VGND sky130_ef_sc_hd__decap_12
XFILLER_115_1602 VGND VGND VPWR VPWR sky130_fd_sc_hd__decap_3
XFILLER_63_1534 VPWR VGND VPWR VGND sky130_ef_sc_hd__decap_12
XFILLER_213_1225 VGND VGND VPWR VPWR sky130_fd_sc_hd__decap_6
XFILLER_150_1526 VPWR VGND VPWR VGND sky130_ef_sc_hd__decap_12
XFILLER_63_1578 VPWR VGND VPWR VGND sky130_ef_sc_hd__decap_12
XTAP_TAPCELL_ROW_6_959 VGND VPWR sky130_fd_sc_hd__tapvpwrvgnd_1
XFILLER_24_1518 VGND VGND VPWR VPWR sky130_fd_sc_hd__decap_6
XFILLER_38_15 VPWR VGND VPWR VGND sky130_ef_sc_hd__decap_12
XANTENNA_input9_A func_addr[6] VGND VGND VPWR VPWR sky130_fd_sc_hd__diode_2
XFILLER_213_1269 VPWR VGND VPWR VGND sky130_ef_sc_hd__decap_12
XFILLER_161_27 VPWR VGND VPWR VGND sky130_ef_sc_hd__decap_12
XFILLER_6_1483 VGND VGND VPWR VPWR sky130_fd_sc_hd__fill_1
XANTENNA__387__A b_addr\[1\] VGND VGND VPWR VPWR sky130_fd_sc_hd__diode_2
XFILLER_22_1220 VPWR VGND VPWR VGND sky130_ef_sc_hd__decap_12
XFILLER_198_301 VGND VGND VPWR VPWR sky130_fd_sc_hd__decap_6
XFILLER_187_1493 VPWR VGND VPWR VGND sky130_ef_sc_hd__decap_12
XFILLER_183_1313 VPWR VGND VPWR VGND sky130_ef_sc_hd__decap_12
XTAP_TAPCELL_ROW_181_1896 VGND VPWR sky130_fd_sc_hd__tapvpwrvgnd_1
XTAP_TAPCELL_ROW_181_1885 VGND VPWR sky130_fd_sc_hd__tapvpwrvgnd_1
XTAP_TAPCELL_ROW_69_1_1156 VGND VPWR sky130_fd_sc_hd__tapvpwrvgnd_1
XFILLER_207_1007 VGND VGND VPWR VPWR sky130_fd_sc_hd__fill_1
XFILLER_198_345 VPWR VGND VPWR VGND sky130_ef_sc_hd__decap_12
XFILLER_183_1357 VPWR VGND VPWR VGND sky130_ef_sc_hd__decap_12
XANTENNA__608__CLK clknet_3_6_0_clk VGND VGND VPWR VPWR sky130_fd_sc_hd__diode_2
XFILLER_214_699 VGND VGND VPWR VPWR sky130_fd_sc_hd__fill_1
XFILLER_201_305 VPWR VGND VPWR VGND sky130_ef_sc_hd__decap_12
XFILLER_110_53 VPWR VGND VPWR VGND sky130_ef_sc_hd__decap_12
XFILLER_0_1093 VPWR VGND VPWR VGND sky130_ef_sc_hd__decap_12
XFILLER_201_349 VPWR VGND VPWR VGND sky130_ef_sc_hd__decap_12
XFILLER_198_389 VPWR VGND VPWR VGND sky130_ef_sc_hd__decap_12
XFILLER_167_721 VGND VGND VPWR VPWR sky130_fd_sc_hd__decap_6
XFILLER_70_1538 VPWR VGND VPWR VGND sky130_ef_sc_hd__decap_12
XANTENNA__326__S net140 VGND VGND VPWR VPWR sky130_fd_sc_hd__diode_2
XFILLER_210_861 VGND VGND VPWR VPWR sky130_fd_sc_hd__decap_6
XFILLER_167_765 VPWR VGND VPWR VGND sky130_ef_sc_hd__decap_12
XFILLER_110_97 VPWR VGND VPWR VGND sky130_ef_sc_hd__decap_12
XFILLER_214_3 VPWR VGND VPWR VGND sky130_ef_sc_hd__decap_12
XFILLER_182_713 VPWR VGND VPWR VGND sky130_ef_sc_hd__decap_12
XFILLER_166_253 VPWR VGND VPWR VGND sky130_ef_sc_hd__decap_12
XFILLER_6_937 VPWR VGND VPWR VGND sky130_ef_sc_hd__decap_12
XTAP_TAPCELL_ROW_12_2_3058 VGND VPWR sky130_fd_sc_hd__tapvpwrvgnd_1
XFILLER_182_757 VPWR VGND VPWR VGND sky130_ef_sc_hd__decap_12
XFILLER_181_223 VGND VGND VPWR VPWR sky130_fd_sc_hd__fill_1
XFILLER_119_51 VGND VGND VPWR VPWR sky130_fd_sc_hd__decap_4
XFILLER_68_1412 VGND VGND VPWR VPWR sky130_fd_sc_hd__fill_1
XFILLER_5_447 VGND VGND VPWR VPWR sky130_fd_sc_hd__fill_1
XFILLER_5_414 VGND VGND VPWR VPWR sky130_fd_sc_hd__decap_3
XFILLER_194_1453 VPWR VGND VPWR VGND sky130_ef_sc_hd__decap_12
XFILLER_218_1147 VGND VGND VPWR VPWR sky130_fd_sc_hd__fill_1
XFILLER_190_1317 VPWR VGND VPWR VGND sky130_ef_sc_hd__decap_12
XFILLER_163_993 VPWR VGND VPWR VGND sky130_ef_sc_hd__decap_12
XFILLER_79_55 VGND VGND VPWR VPWR sky130_fd_sc_hd__fill_1
XFILLER_194_1497 VPWR VGND VPWR VGND sky130_ef_sc_hd__decap_12
XFILLER_0_130 VGND VGND VPWR VPWR sky130_fd_sc_hd__fill_1
XFILLER_118_1270 VPWR VGND VPWR VGND sky130_ef_sc_hd__decap_12
XFILLER_209_405 VPWR VGND VPWR VGND sky130_ef_sc_hd__decap_12
XFILLER_209_449 VPWR VGND VPWR VGND sky130_ef_sc_hd__decap_12
XFILLER_218_961 VPWR VGND VPWR VGND sky130_ef_sc_hd__decap_12
XFILLER_79_1552 VGND VGND VPWR VPWR sky130_fd_sc_hd__fill_1
XFILLER_166_1533 VGND VGND VPWR VPWR sky130_fd_sc_hd__decap_6
XFILLER_151_93 VPWR VGND VPWR VGND sky130_ef_sc_hd__decap_12
XFILLER_204_121 VPWR VGND VPWR VGND sky130_ef_sc_hd__decap_12
X_567_ net147 net154 net157 _256_ VGND VGND VPWR VPWR _068_ sky130_fd_sc_hd__o211a_1
XFILLER_204_165 VPWR VGND VPWR VGND sky130_ef_sc_hd__decap_12
XFILLER_166_1577 VPWR VGND VPWR VGND sky130_ef_sc_hd__decap_12
XFILLER_177_529 VPWR VGND VPWR VGND sky130_ef_sc_hd__decap_12
X_498_ net176 net125 VGND VGND VPWR VPWR _223_ sky130_fd_sc_hd__or2_1
XFILLER_38_1282 VPWR VGND VPWR VGND sky130_ef_sc_hd__decap_12
XFILLER_203_1449 VGND VGND VPWR VPWR sky130_fd_sc_hd__decap_6
XFILLER_125_1274 VPWR VGND VPWR VGND sky130_ef_sc_hd__decap_12
XTAP_TAPCELL_ROW_191_2181 VGND VPWR sky130_fd_sc_hd__tapvpwrvgnd_1
XTAP_TAPCELL_ROW_191_2170 VGND VPWR sky130_fd_sc_hd__tapvpwrvgnd_1
XFILLER_185_573 VPWR VGND VPWR VGND sky130_ef_sc_hd__decap_12
XFILLER_16_1580 VGND VGND VPWR VPWR sky130_fd_sc_hd__fill_1
XTAP_TAPCELL_ROW_191_2192 VGND VPWR sky130_fd_sc_hd__tapvpwrvgnd_1
XFILLER_172_245 VGND VGND VPWR VPWR sky130_fd_sc_hd__decap_6
XTAP_TAPCELL_ROW_76_2_3469 VGND VPWR sky130_fd_sc_hd__tapvpwrvgnd_1
XFILLER_138_1602 VGND VGND VPWR VPWR sky130_fd_sc_hd__decap_3
XFILLER_132_109 VPWR VGND VPWR VGND sky130_ef_sc_hd__decap_12
XTAP_TAPCELL_ROW_212_2796 VGND VPWR sky130_fd_sc_hd__tapvpwrvgnd_1
XTAP_TAPCELL_ROW_212_2785 VGND VPWR sky130_fd_sc_hd__tapvpwrvgnd_1
XTAP_TAPCELL_ROW_212_2774 VGND VPWR sky130_fd_sc_hd__tapvpwrvgnd_1
XFILLER_172_289 VPWR VGND VPWR VGND sky130_ef_sc_hd__decap_12
XFILLER_173_1537 VPWR VGND VPWR VGND sky130_ef_sc_hd__decap_12
XFILLER_45_1220 VPWR VGND VPWR VGND sky130_ef_sc_hd__decap_12
XTAP_TAPCELL_ROW_56_2_3345 VGND VPWR sky130_fd_sc_hd__tapvpwrvgnd_1
XFILLER_136_1370 VPWR VGND VPWR VGND sky130_ef_sc_hd__decap_12
XFILLER_210_1409 VPWR VGND VPWR VGND sky130_ef_sc_hd__decap_12
XTAP_TAPCELL_ROW_36_2_3210 VGND VPWR sky130_fd_sc_hd__tapvpwrvgnd_1
XFILLER_45_1286 VPWR VGND VPWR VGND sky130_ef_sc_hd__decap_12
XFILLER_214_1589 VGND VGND VPWR VPWR sky130_fd_sc_hd__decap_6
XFILLER_54_126 VGND VGND VPWR VPWR sky130_fd_sc_hd__fill_1
XFILLER_165_1021 VPWR VGND VPWR VGND sky130_ef_sc_hd__decap_12
XTAP_TAPCELL_ROW_198_2379 VGND VPWR sky130_fd_sc_hd__tapvpwrvgnd_1
XFILLER_196_805 VGND VGND VPWR VPWR sky130_fd_sc_hd__decap_6
XFILLER_165_1065 VPWR VGND VPWR VGND sky130_ef_sc_hd__decap_12
XFILLER_196_849 VPWR VGND VPWR VGND sky130_ef_sc_hd__decap_12
XFILLER_195_337 VPWR VGND VPWR VGND sky130_ef_sc_hd__decap_12
XFILLER_143_1330 VPWR VGND VPWR VGND sky130_ef_sc_hd__decap_12
XFILLER_108_1450 VPWR VGND VPWR VGND sky130_ef_sc_hd__decap_12
XFILLER_17_1322 VGND VGND VPWR VPWR sky130_fd_sc_hd__decap_6
XFILLER_56_1382 VPWR VGND VPWR VGND sky130_ef_sc_hd__decap_12
XFILLER_206_1073 VPWR VGND VPWR VGND sky130_ef_sc_hd__decap_12
XFILLER_104_1314 VPWR VGND VPWR VGND sky130_ef_sc_hd__decap_12
XFILLER_17_1366 VPWR VGND VPWR VGND sky130_ef_sc_hd__decap_12
XFILLER_52_1246 VPWR VGND VPWR VGND sky130_ef_sc_hd__decap_12
XFILLER_164_713 VPWR VGND VPWR VGND sky130_ef_sc_hd__decap_12
XFILLER_108_1494 VPWR VGND VPWR VGND sky130_ef_sc_hd__decap_12
XFILLER_104_1358 VPWR VGND VPWR VGND sky130_ef_sc_hd__decap_12
XFILLER_40_27 VGND VGND VPWR VPWR sky130_fd_sc_hd__fill_1
XFILLER_164_757 VPWR VGND VPWR VGND sky130_ef_sc_hd__decap_12
XFILLER_156_27 VGND VGND VPWR VPWR sky130_fd_sc_hd__fill_1
XFILLER_219_1401 VPWR VGND VPWR VGND sky130_ef_sc_hd__decap_12
XTAP_TAPCELL_ROW_153_2_3973 VGND VPWR sky130_fd_sc_hd__tapvpwrvgnd_1
XFILLER_176_1161 VPWR VGND VPWR VGND sky130_ef_sc_hd__decap_12
XTAP_TAPCELL_ROW_170_1586 VGND VPWR sky130_fd_sc_hd__tapvpwrvgnd_1
XTAP_TAPCELL_ROW_170_1575 VGND VPWR sky130_fd_sc_hd__tapvpwrvgnd_1
XTAP_TAPCELL_ROW_170_1597 VGND VPWR sky130_fd_sc_hd__tapvpwrvgnd_1
XTAP_TAPCELL_ROW_122_1_1261 VGND VPWR sky130_fd_sc_hd__tapvpwrvgnd_1
XFILLER_172_15 VPWR VGND VPWR VGND sky130_ef_sc_hd__decap_12
XFILLER_115_1410 VPWR VGND VPWR VGND sky130_ef_sc_hd__decap_12
XFILLER_63_1342 VPWR VGND VPWR VGND sky130_ef_sc_hd__decap_12
XFILLER_28_1462 VGND VGND VPWR VPWR sky130_fd_sc_hd__decap_6
XFILLER_49_69 VGND VGND VPWR VPWR sky130_fd_sc_hd__fill_2
XFILLER_219_725 VGND VGND VPWR VPWR sky130_fd_sc_hd__decap_3
XFILLER_213_1033 VPWR VGND VPWR VGND sky130_ef_sc_hd__decap_12
XFILLER_154_1470 VPWR VGND VPWR VGND sky130_ef_sc_hd__decap_12
XFILLER_119_1590 VPWR VGND VPWR VGND sky130_ef_sc_hd__decap_12
XFILLER_115_1454 VPWR VGND VPWR VGND sky130_ef_sc_hd__decap_12
XFILLER_63_1386 VPWR VGND VPWR VGND sky130_ef_sc_hd__decap_12
XFILLER_4_1409 VPWR VGND VPWR VGND sky130_ef_sc_hd__decap_12
XFILLER_24_1326 VPWR VGND VPWR VGND sky130_ef_sc_hd__decap_12
XFILLER_219_769 VPWR VGND VPWR VGND sky130_ef_sc_hd__decap_12
XFILLER_213_1077 VPWR VGND VPWR VGND sky130_ef_sc_hd__decap_12
XFILLER_207_909 VPWR VGND VPWR VGND sky130_ef_sc_hd__decap_12
XFILLER_189_1511 VGND VGND VPWR VPWR sky130_fd_sc_hd__fill_1
XTAP_TAPCELL_ROW_183_1958 VGND VPWR sky130_fd_sc_hd__tapvpwrvgnd_1
XTAP_TAPCELL_ROW_183_1947 VGND VPWR sky130_fd_sc_hd__tapvpwrvgnd_1
XFILLER_150_1356 VGND VGND VPWR VPWR sky130_fd_sc_hd__fill_1
XFILLER_206_419 VGND VGND VPWR VPWR sky130_fd_sc_hd__fill_1
XTAP_TAPCELL_ROW_183_1969 VGND VPWR sky130_fd_sc_hd__tapvpwrvgnd_1
XFILLER_115_1498 VPWR VGND VPWR VGND sky130_ef_sc_hd__decap_12
XFILLER_98_1438 VPWR VGND VPWR VGND sky130_ef_sc_hd__decap_12
XFILLER_65_57 VPWR VGND VPWR VGND sky130_ef_sc_hd__decap_12
XPHY_EDGE_ROW_22_1_Left_241 VGND VGND VPWR VPWR sky130_fd_sc_hd__decap_3
XFILLER_45_104 VGND VGND VPWR VPWR sky130_fd_sc_hd__decap_8
XFILLER_215_953 VPWR VGND VPWR VGND sky130_ef_sc_hd__decap_12
XFILLER_183_1121 VPWR VGND VPWR VGND sky130_ef_sc_hd__decap_12
XFILLER_164_3 VPWR VGND VPWR VGND sky130_ef_sc_hd__decap_12
X_421_ _141_ _151_ _143_ VGND VGND VPWR VPWR _155_ sky130_fd_sc_hd__nor3b_1
XFILLER_202_625 VPWR VGND VPWR VGND sky130_ef_sc_hd__decap_12
XFILLER_199_665 VGND VGND VPWR VPWR sky130_fd_sc_hd__decap_6
XFILLER_198_153 VPWR VGND VPWR VGND sky130_ef_sc_hd__decap_12
X_352_ u_ctrl.cmp_addr\[7\] b_addr\[7\] net153 VGND VGND VPWR VPWR _097_ sky130_fd_sc_hd__mux2_1
XFILLER_201_113 VPWR VGND VPWR VGND sky130_ef_sc_hd__decap_12
XFILLER_198_197 VPWR VGND VPWR VGND sky130_ef_sc_hd__decap_12
XFILLER_74_1482 VPWR VGND VPWR VGND sky130_ef_sc_hd__decap_12
XFILLER_70_1302 VPWR VGND VPWR VGND sky130_ef_sc_hd__decap_12
XANTENNA__580__CLK clknet_3_2_0_clk VGND VGND VPWR VPWR sky130_fd_sc_hd__diode_2
XFILLER_35_1422 VPWR VGND VPWR VGND sky130_ef_sc_hd__decap_12
XFILLER_202_669 VPWR VGND VPWR VGND sky130_ef_sc_hd__decap_12
XFILLER_126_1550 VPWR VGND VPWR VGND sky130_ef_sc_hd__decap_12
XFILLER_122_1414 VPWR VGND VPWR VGND sky130_ef_sc_hd__decap_12
X_283_ _079_ _080_ VGND VGND VPWR VPWR _081_ sky130_fd_sc_hd__nor2_1
XFILLER_35_1466 VPWR VGND VPWR VGND sky130_ef_sc_hd__decap_12
XFILLER_167_573 VPWR VGND VPWR VGND sky130_ef_sc_hd__decap_12
XFILLER_161_1496 VGND VGND VPWR VPWR sky130_fd_sc_hd__fill_1
XFILLER_126_1594 VGND VGND VPWR VPWR sky130_fd_sc_hd__decap_8
XFILLER_6_701 VPWR VGND VPWR VGND sky130_ef_sc_hd__decap_12
XFILLER_14_83 VGND VGND VPWR VPWR sky130_fd_sc_hd__fill_1
XFILLER_68_1220 VPWR VGND VPWR VGND sky130_ef_sc_hd__decap_12
XFILLER_194_1261 VPWR VGND VPWR VGND sky130_ef_sc_hd__decap_12
XFILLER_182_587 VGND VGND VPWR VPWR sky130_fd_sc_hd__fill_1
XFILLER_170_749 VGND VGND VPWR VPWR sky130_fd_sc_hd__decap_6
XFILLER_114_109 VPWR VGND VPWR VGND sky130_ef_sc_hd__decap_12
XFILLER_30_82 VGND VGND VPWR VPWR sky130_fd_sc_hd__fill_2
XTAP_TAPCELL_ROW_42_2_3253 VGND VPWR sky130_fd_sc_hd__tapvpwrvgnd_1
XFILLER_190_1147 VGND VGND VPWR VPWR sky130_fd_sc_hd__fill_1
XFILLER_155_1256 VPWR VGND VPWR VGND sky130_ef_sc_hd__decap_12
XFILLER_133_1510 VPWR VGND VPWR VGND sky130_ef_sc_hd__decap_12
XFILLER_81_1442 VPWR VGND VPWR VGND sky130_ef_sc_hd__decap_12
XFILLER_1_461 VPWR VGND VPWR VGND sky130_ef_sc_hd__decap_12
XFILLER_46_1562 VPWR VGND VPWR VGND sky130_ef_sc_hd__decap_12
XFILLER_7_1033 VGND VGND VPWR VPWR sky130_fd_sc_hd__decap_3
XFILLER_42_1426 VPWR VGND VPWR VGND sky130_ef_sc_hd__decap_12
XFILLER_133_1554 VPWR VGND VPWR VGND sky130_ef_sc_hd__decap_12
XFILLER_7_1077 VPWR VGND VPWR VGND sky130_ef_sc_hd__decap_12
XANTENNA_output48_A net149 VGND VGND VPWR VPWR sky130_fd_sc_hd__diode_2
Xinput9 func_addr[6] VGND VGND VPWR VPWR net9 sky130_fd_sc_hd__clkbuf_1
XFILLER_209_279 VGND VGND VPWR VPWR sky130_fd_sc_hd__fill_1
XTAP_TAPCELL_ROW_147_1_1312 VGND VPWR sky130_fd_sc_hd__tapvpwrvgnd_1
XFILLER_205_441 VGND VGND VPWR VPWR sky130_fd_sc_hd__decap_6
XFILLER_166_1341 VPWR VGND VPWR VGND sky130_ef_sc_hd__decap_12
X_619_ clknet_3_6_0_clk _053_ VGND VGND VPWR VPWR net76 sky130_fd_sc_hd__dfxtp_1
XFILLER_51_107 VGND VGND VPWR VPWR sky130_fd_sc_hd__decap_4
XFILLER_205_485 VPWR VGND VPWR VGND sky130_ef_sc_hd__decap_12
XTAP_TAPCELL_ROW_201_2475 VGND VPWR sky130_fd_sc_hd__tapvpwrvgnd_1
XTAP_TAPCELL_ROW_201_2464 VGND VPWR sky130_fd_sc_hd__tapvpwrvgnd_1
XFILLER_178_805 VGND VGND VPWR VPWR sky130_fd_sc_hd__decap_6
XFILLER_75_1268 VGND VGND VPWR VPWR sky130_fd_sc_hd__decap_4
XTAP_TAPCELL_ROW_193_2232 VGND VPWR sky130_fd_sc_hd__tapvpwrvgnd_1
XFILLER_178_849 VPWR VGND VPWR VGND sky130_ef_sc_hd__decap_12
XFILLER_177_337 VPWR VGND VPWR VGND sky130_ef_sc_hd__decap_12
XFILLER_166_1385 VPWR VGND VPWR VGND sky130_ef_sc_hd__decap_12
XFILLER_53_1522 VPWR VGND VPWR VGND sky130_ef_sc_hd__decap_12
XFILLER_203_1213 VPWR VGND VPWR VGND sky130_ef_sc_hd__decap_12
XTAP_TAPCELL_ROW_193_2254 VGND VPWR sky130_fd_sc_hd__tapvpwrvgnd_1
XTAP_TAPCELL_ROW_193_2243 VGND VPWR sky130_fd_sc_hd__tapvpwrvgnd_1
XFILLER_92_1582 VPWR VGND VPWR VGND sky130_ef_sc_hd__decap_12
XFILLER_14_1506 VPWR VGND VPWR VGND sky130_ef_sc_hd__decap_12
XTAP_TAPCELL_ROW_218_2961 VGND VPWR sky130_fd_sc_hd__tapvpwrvgnd_1
XTAP_TAPCELL_ROW_218_2950 VGND VPWR sky130_fd_sc_hd__tapvpwrvgnd_1
XFILLER_207_1393 VGND VGND VPWR VPWR sky130_fd_sc_hd__decap_6
XFILLER_203_1257 VPWR VGND VPWR VGND sky130_ef_sc_hd__decap_12
XFILLER_192_307 VGND VGND VPWR VPWR sky130_fd_sc_hd__fill_1
XFILLER_186_893 VPWR VGND VPWR VGND sky130_ef_sc_hd__decap_12
XPHY_EDGE_ROW_98_1_Left_317 VGND VGND VPWR VPWR sky130_fd_sc_hd__decap_3
XFILLER_53_1566 VPWR VGND VPWR VGND sky130_ef_sc_hd__decap_12
XTAP_TAPCELL_ROW_214_2847 VGND VPWR sky130_fd_sc_hd__tapvpwrvgnd_1
XTAP_TAPCELL_ROW_214_2836 VGND VPWR sky130_fd_sc_hd__tapvpwrvgnd_1
XTAP_TAPCELL_ROW_214_2825 VGND VPWR sky130_fd_sc_hd__tapvpwrvgnd_1
XPHY_EDGE_ROW_150_1_Left_369 VGND VGND VPWR VPWR sky130_fd_sc_hd__decap_3
XTAP_TAPCELL_ROW_138_2_3875 VGND VPWR sky130_fd_sc_hd__tapvpwrvgnd_1
XFILLER_173_1301 VPWR VGND VPWR VGND sky130_ef_sc_hd__decap_12
XFILLER_177_1481 VPWR VGND VPWR VGND sky130_ef_sc_hd__decap_12
XFILLER_173_1345 VPWR VGND VPWR VGND sky130_ef_sc_hd__decap_12
XFILLER_206_41 VPWR VGND VPWR VGND sky130_ef_sc_hd__decap_12
XTAP_TAPCELL_ROW_187_2069 VGND VPWR sky130_fd_sc_hd__tapvpwrvgnd_1
XTAP_TAPCELL_ROW_187_2058 VGND VPWR sky130_fd_sc_hd__tapvpwrvgnd_1
XFILLER_25_1602 VGND VGND VPWR VPWR sky130_fd_sc_hd__decap_3
XFILLER_214_1353 VPWR VGND VPWR VGND sky130_ef_sc_hd__decap_12
XFILLER_206_85 VPWR VGND VPWR VGND sky130_ef_sc_hd__decap_12
XTAP_TAPCELL_ROW_131_2_3829 VGND VPWR sky130_fd_sc_hd__tapvpwrvgnd_1
XTAP_TAPCELL_ROW_86_2_3540 VGND VPWR sky130_fd_sc_hd__tapvpwrvgnd_1
XFILLER_210_1217 VPWR VGND VPWR VGND sky130_ef_sc_hd__decap_12
XFILLER_142_29 VPWR VGND VPWR VGND sky130_ef_sc_hd__decap_12
XFILLER_19_39 VPWR VGND VPWR VGND sky130_ef_sc_hd__decap_12
XFILLER_60_1526 VPWR VGND VPWR VGND sky130_ef_sc_hd__decap_12
XFILLER_214_1397 VPWR VGND VPWR VGND sky130_ef_sc_hd__decap_12
XFILLER_215_205 VPWR VGND VPWR VGND sky130_ef_sc_hd__decap_12
XFILLER_215_249 VPWR VGND VPWR VGND sky130_ef_sc_hd__decap_12
XTAP_TAPCELL_ROW_163_1390 VGND VPWR sky130_fd_sc_hd__tapvpwrvgnd_1
XFILLER_35_27 VPWR VGND VPWR VGND sky130_ef_sc_hd__decap_12
XFILLER_212_923 VGND VGND VPWR VPWR sky130_fd_sc_hd__fill_1
XFILLER_184_1441 VPWR VGND VPWR VGND sky130_ef_sc_hd__decap_12
XANTENNA_fanout157_X net157 VGND VGND VPWR VPWR sky130_fd_sc_hd__diode_2
XFILLER_196_613 VPWR VGND VPWR VGND sky130_ef_sc_hd__decap_12
XFILLER_184_1485 VPWR VGND VPWR VGND sky130_ef_sc_hd__decap_12
XFILLER_196_657 VPWR VGND VPWR VGND sky130_ef_sc_hd__decap_12
XFILLER_51_15 VPWR VGND VPWR VGND sky130_ef_sc_hd__decap_12
XFILLER_195_167 VGND VGND VPWR VPWR sky130_fd_sc_hd__fill_1
XFILLER_183_329 VGND VGND VPWR VPWR sky130_fd_sc_hd__decap_6
XTAP_TAPCELL_ROW_176_1762 VGND VPWR sky130_fd_sc_hd__tapvpwrvgnd_1
XTAP_TAPCELL_ROW_176_1751 VGND VPWR sky130_fd_sc_hd__tapvpwrvgnd_1
XFILLER_167_15 VPWR VGND VPWR VGND sky130_ef_sc_hd__decap_12
XTAP_TAPCELL_ROW_172_1637 VGND VPWR sky130_fd_sc_hd__tapvpwrvgnd_1
XANTENNA__381__B1 b_addr\[1\] VGND VGND VPWR VPWR sky130_fd_sc_hd__diode_2
XTAP_TAPCELL_ROW_172_1648 VGND VPWR sky130_fd_sc_hd__tapvpwrvgnd_1
XTAP_TAPCELL_ROW_27_2_3155 VGND VPWR sky130_fd_sc_hd__tapvpwrvgnd_1
XFILLER_191_1401 VPWR VGND VPWR VGND sky130_ef_sc_hd__decap_12
XFILLER_191_373 VPWR VGND VPWR VGND sky130_ef_sc_hd__decap_12
XFILLER_164_587 VGND VGND VPWR VPWR sky130_fd_sc_hd__fill_1
XFILLER_195_1581 VPWR VGND VPWR VGND sky130_ef_sc_hd__decap_12
XFILLER_183_69 VPWR VGND VPWR VGND sky130_ef_sc_hd__decap_12
XFILLER_116_41 VPWR VGND VPWR VGND sky130_ef_sc_hd__decap_12
XPHY_EDGE_ROW_173_Right_18 VGND VGND VPWR VPWR sky130_fd_sc_hd__decap_3
XFILLER_116_85 VPWR VGND VPWR VGND sky130_ef_sc_hd__decap_12
XFILLER_28_1270 VPWR VGND VPWR VGND sky130_ef_sc_hd__decap_12
XFILLER_219_533 VPWR VGND VPWR VGND sky130_ef_sc_hd__decap_12
XFILLER_4_1217 VPWR VGND VPWR VGND sky130_ef_sc_hd__decap_12
XTAP_TAPCELL_ROW_20_2_3109 VGND VPWR sky130_fd_sc_hd__tapvpwrvgnd_1
XFILLER_98_1246 VPWR VGND VPWR VGND sky130_ef_sc_hd__decap_12
XFILLER_215_783 VGND VGND VPWR VPWR sky130_fd_sc_hd__fill_1
XFILLER_92_77 VGND VGND VPWR VPWR sky130_fd_sc_hd__decap_6
XFILLER_203_945 VGND VGND VPWR VPWR sky130_fd_sc_hd__decap_6
XFILLER_202_433 VPWR VGND VPWR VGND sky130_ef_sc_hd__decap_12
XFILLER_199_473 VPWR VGND VPWR VGND sky130_ef_sc_hd__decap_12
XPHY_EDGE_ROW_182_Right_27 VGND VGND VPWR VPWR sky130_fd_sc_hd__decap_3
XFILLER_163_1525 VPWR VGND VPWR VGND sky130_ef_sc_hd__decap_12
X_404_ b_addr\[4\] _084_ _103_ VGND VGND VPWR VPWR _140_ sky130_fd_sc_hd__and3_1
XFILLER_203_989 VPWR VGND VPWR VGND sky130_ef_sc_hd__decap_12
XFILLER_202_477 VPWR VGND VPWR VGND sky130_ef_sc_hd__decap_12
XFILLER_163_1569 VPWR VGND VPWR VGND sky130_ef_sc_hd__decap_12
X_335_ net44 net140 _089_ net152 VGND VGND VPWR VPWR _005_ sky130_fd_sc_hd__a22oi_2
XFILLER_204_1533 VGND VGND VPWR VPWR sky130_fd_sc_hd__decap_6
XFILLER_179_1009 VPWR VGND VPWR VGND sky130_ef_sc_hd__decap_12
XFILLER_174_307 VGND VGND VPWR VPWR sky130_fd_sc_hd__fill_1
XFILLER_35_1274 VPWR VGND VPWR VGND sky130_ef_sc_hd__decap_12
XFILLER_204_1577 VPWR VGND VPWR VGND sky130_ef_sc_hd__decap_12
XFILLER_186_189 VGND VGND VPWR VPWR sky130_fd_sc_hd__decap_6
XFILLER_183_841 VPWR VGND VPWR VGND sky130_ef_sc_hd__decap_12
XFILLER_168_893 VPWR VGND VPWR VGND sky130_ef_sc_hd__decap_12
XTAP_TAPCELL_ROW_124_2_3783 VGND VPWR sky130_fd_sc_hd__tapvpwrvgnd_1
XFILLER_122_1244 VGND VGND VPWR VPWR sky130_fd_sc_hd__fill_1
XFILLER_41_81 VPWR VGND VPWR VGND sky130_ef_sc_hd__decap_12
XFILLER_170_513 VPWR VGND VPWR VGND sky130_ef_sc_hd__decap_12
XFILLER_157_81 VPWR VGND VPWR VGND sky130_ef_sc_hd__decap_12
XFILLER_6_586 VGND VGND VPWR VPWR sky130_fd_sc_hd__fill_2
XFILLER_48_1602 VGND VGND VPWR VPWR sky130_fd_sc_hd__decap_3
XFILLER_170_557 VPWR VGND VPWR VGND sky130_ef_sc_hd__decap_12
XFILLER_6_597 VPWR VGND VPWR VGND sky130_ef_sc_hd__decap_12
XFILLER_194_1091 VGND VGND VPWR VPWR sky130_fd_sc_hd__fill_1
XPHY_EDGE_ROW_191_Right_36 VGND VGND VPWR VPWR sky130_fd_sc_hd__decap_3
XFILLER_46_1370 VPWR VGND VPWR VGND sky130_ef_sc_hd__decap_12
XFILLER_81_1272 VGND VGND VPWR VPWR sky130_fd_sc_hd__fill_1
XFILLER_2_53 VPWR VGND VPWR VGND sky130_ef_sc_hd__decap_12
XFILLER_211_1537 VPWR VGND VPWR VGND sky130_ef_sc_hd__decap_12
XTAP_TAPCELL_ROW_207_2651 VGND VPWR sky130_fd_sc_hd__tapvpwrvgnd_1
XTAP_TAPCELL_ROW_207_2640 VGND VPWR sky130_fd_sc_hd__tapvpwrvgnd_1
XFILLER_133_1384 VGND VGND VPWR VPWR sky130_fd_sc_hd__fill_1
XTAP_TAPCELL_ROW_203_2526 VGND VPWR sky130_fd_sc_hd__tapvpwrvgnd_1
XTAP_TAPCELL_ROW_203_2515 VGND VPWR sky130_fd_sc_hd__tapvpwrvgnd_1
XFILLER_2_97 VPWR VGND VPWR VGND sky130_ef_sc_hd__decap_12
XFILLER_213_709 VPWR VGND VPWR VGND sky130_ef_sc_hd__decap_12
XTAP_TAPCELL_ROW_203_2537 VGND VPWR sky130_fd_sc_hd__tapvpwrvgnd_1
XANTENNA__485__A net135 VGND VGND VPWR VPWR sky130_fd_sc_hd__diode_2
XTAP_TAPCELL_ROW_195_2305 VGND VPWR sky130_fd_sc_hd__tapvpwrvgnd_1
XFILLER_209_1455 VGND VGND VPWR VPWR sky130_fd_sc_hd__fill_1
XFILLER_205_293 VPWR VGND VPWR VGND sky130_ef_sc_hd__decap_12
XFILLER_178_613 VPWR VGND VPWR VGND sky130_ef_sc_hd__decap_12
XFILLER_178_657 VPWR VGND VPWR VGND sky130_ef_sc_hd__decap_12
XFILLER_18_1450 VPWR VGND VPWR VGND sky130_ef_sc_hd__decap_12
XFILLER_53_1330 VPWR VGND VPWR VGND sky130_ef_sc_hd__decap_12
XTAP_TAPCELL_ROW_216_2909 VGND VPWR sky130_fd_sc_hd__tapvpwrvgnd_1
XFILLER_203_1021 VPWR VGND VPWR VGND sky130_ef_sc_hd__decap_12
XFILLER_177_167 VGND VGND VPWR VPWR sky130_fd_sc_hd__fill_1
XFILLER_140_1300 VGND VGND VPWR VPWR sky130_fd_sc_hd__fill_1
XTAP_TAPCELL_ROW_9_2_3039 VGND VPWR sky130_fd_sc_hd__tapvpwrvgnd_1
XFILLER_14_1314 VPWR VGND VPWR VGND sky130_ef_sc_hd__decap_12
XFILLER_203_1065 VPWR VGND VPWR VGND sky130_ef_sc_hd__decap_12
XFILLER_165_329 VGND VGND VPWR VPWR sky130_fd_sc_hd__decap_6
XFILLER_105_1442 VPWR VGND VPWR VGND sky130_ef_sc_hd__decap_12
XFILLER_14_1358 VPWR VGND VPWR VGND sky130_ef_sc_hd__decap_12
XTAP_TAPCELL_ROW_13_2_3063 VGND VPWR sky130_fd_sc_hd__tapvpwrvgnd_1
XFILLER_18_1494 VPWR VGND VPWR VGND sky130_ef_sc_hd__decap_12
XFILLER_101_1328 VGND VGND VPWR VPWR sky130_fd_sc_hd__fill_1
XFILLER_88_1426 VPWR VGND VPWR VGND sky130_ef_sc_hd__decap_12
XFILLER_173_373 VPWR VGND VPWR VGND sky130_ef_sc_hd__decap_12
Xoutput110 net110 VGND VGND VPWR VPWR func_rdata[29] sky130_fd_sc_hd__buf_2
XFILLER_217_51 VGND VGND VPWR VPWR sky130_fd_sc_hd__decap_4
XFILLER_0_718 VGND VGND VPWR VPWR sky130_fd_sc_hd__fill_1
XFILLER_173_1175 VGND VGND VPWR VPWR sky130_fd_sc_hd__fill_1
XFILLER_153_39 VPWR VGND VPWR VGND sky130_ef_sc_hd__decap_12
XFILLER_25_1410 VPWR VGND VPWR VGND sky130_ef_sc_hd__decap_12
XFILLER_214_1161 VPWR VGND VPWR VGND sky130_ef_sc_hd__decap_12
XFILLER_151_1440 VGND VGND VPWR VPWR sky130_fd_sc_hd__fill_1
XFILLER_64_1470 VPWR VGND VPWR VGND sky130_ef_sc_hd__decap_12
XFILLER_25_1454 VPWR VGND VPWR VGND sky130_ef_sc_hd__decap_12
XFILLER_29_1590 VPWR VGND VPWR VGND sky130_ef_sc_hd__decap_12
XTAP_TAPCELL_ROW_165_1452 VGND VPWR sky130_fd_sc_hd__tapvpwrvgnd_1
XTAP_TAPCELL_ROW_165_1441 VGND VPWR sky130_fd_sc_hd__tapvpwrvgnd_1
XTAP_TAPCELL_ROW_165_1430 VGND VPWR sky130_fd_sc_hd__tapvpwrvgnd_1
XFILLER_116_1582 VPWR VGND VPWR VGND sky130_ef_sc_hd__decap_12
XFILLER_99_1522 VPWR VGND VPWR VGND sky130_ef_sc_hd__decap_12
XFILLER_5_1537 VPWR VGND VPWR VGND sky130_ef_sc_hd__decap_12
XFILLER_60_1356 VGND VGND VPWR VPWR sky130_fd_sc_hd__fill_1
XFILLER_216_525 VGND VGND VPWR VPWR sky130_fd_sc_hd__decap_6
XFILLER_112_1468 VGND VGND VPWR VPWR sky130_fd_sc_hd__fill_1
XFILLER_99_1566 VPWR VGND VPWR VGND sky130_ef_sc_hd__decap_12
XFILLER_25_1498 VPWR VGND VPWR VGND sky130_ef_sc_hd__decap_12
XFILLER_216_569 VPWR VGND VPWR VGND sky130_ef_sc_hd__decap_12
XFILLER_197_933 VPWR VGND VPWR VGND sky130_ef_sc_hd__decap_12
XTAP_TAPCELL_ROW_178_1824 VGND VPWR sky130_fd_sc_hd__tapvpwrvgnd_1
XTAP_TAPCELL_ROW_178_1813 VGND VPWR sky130_fd_sc_hd__tapvpwrvgnd_1
XTAP_TAPCELL_ROW_178_1802 VGND VPWR sky130_fd_sc_hd__tapvpwrvgnd_1
XFILLER_102_65 VPWR VGND VPWR VGND sky130_ef_sc_hd__decap_12
XFILLER_197_977 VPWR VGND VPWR VGND sky130_ef_sc_hd__decap_12
XFILLER_196_421 VPWR VGND VPWR VGND sky130_ef_sc_hd__decap_12
XFILLER_145_1244 VPWR VGND VPWR VGND sky130_ef_sc_hd__decap_12
XFILLER_200_937 VPWR VGND VPWR VGND sky130_ef_sc_hd__decap_12
XFILLER_162_1580 VGND VGND VPWR VPWR sky130_fd_sc_hd__fill_1
XTAP_TAPCELL_ROW_110_2_3691 VGND VPWR sky130_fd_sc_hd__tapvpwrvgnd_1
XTAP_TAPCELL_ROW_109_2_3685 VGND VPWR sky130_fd_sc_hd__tapvpwrvgnd_1
XFILLER_32_1414 VPWR VGND VPWR VGND sky130_ef_sc_hd__decap_12
XFILLER_36_1550 VPWR VGND VPWR VGND sky130_ef_sc_hd__decap_12
XFILLER_183_137 VPWR VGND VPWR VGND sky130_ef_sc_hd__decap_12
XFILLER_168_189 VGND VGND VPWR VPWR sky130_fd_sc_hd__decap_6
XFILLER_165_841 VPWR VGND VPWR VGND sky130_ef_sc_hd__decap_12
XFILLER_127_3 VPWR VGND VPWR VGND sky130_ef_sc_hd__decap_12
XFILLER_71_1496 VGND VGND VPWR VPWR sky130_fd_sc_hd__fill_1
XFILLER_36_1594 VGND VGND VPWR VPWR sky130_fd_sc_hd__decap_8
XFILLER_192_693 VGND VGND VPWR VPWR sky130_fd_sc_hd__decap_6
XFILLER_180_811 VGND VGND VPWR VPWR sky130_fd_sc_hd__fill_1
XANTENNA__280__D b_addr\[0\] VGND VGND VPWR VPWR sky130_fd_sc_hd__diode_2
XFILLER_191_181 VPWR VGND VPWR VGND sky130_ef_sc_hd__decap_12
XFILLER_127_51 VGND VGND VPWR VPWR sky130_fd_sc_hd__decap_4
XFILLER_3_523 VGND VGND VPWR VPWR sky130_fd_sc_hd__fill_1
XTAP_TAPCELL_ROW_57_2_3350 VGND VPWR sky130_fd_sc_hd__tapvpwrvgnd_1
XFILLER_219_1061 VGND VGND VPWR VPWR sky130_fd_sc_hd__decap_3
XFILLER_191_1231 VGND VGND VPWR VPWR sky130_fd_sc_hd__fill_1
XTAP_TAPCELL_ROW_102_2_3639 VGND VPWR sky130_fd_sc_hd__tapvpwrvgnd_1
XFILLER_3_556 VGND VGND VPWR VPWR sky130_fd_sc_hd__decap_4
XFILLER_87_55 VGND VGND VPWR VPWR sky130_fd_sc_hd__fill_1
XFILLER_65_1256 VPWR VGND VPWR VGND sky130_ef_sc_hd__decap_12
XFILLER_43_1510 VPWR VGND VPWR VGND sky130_ef_sc_hd__decap_12
XFILLER_130_1524 VGND VGND VPWR VPWR sky130_fd_sc_hd__fill_1
XFILLER_43_1554 VPWR VGND VPWR VGND sky130_ef_sc_hd__decap_12
XFILLER_207_503 VGND VGND VPWR VPWR sky130_fd_sc_hd__fill_1
XTAP_TAPCELL_ROW_50_2_3304 VGND VPWR sky130_fd_sc_hd__tapvpwrvgnd_1
XFILLER_185_1057 VGND VGND VPWR VPWR sky130_fd_sc_hd__decap_6
XFILLER_203_753 VPWR VGND VPWR VGND sky130_ef_sc_hd__decap_12
XFILLER_199_281 VPWR VGND VPWR VGND sky130_ef_sc_hd__decap_12
XFILLER_203_797 VPWR VGND VPWR VGND sky130_ef_sc_hd__decap_12
XFILLER_204_1341 VPWR VGND VPWR VGND sky130_ef_sc_hd__decap_12
XFILLER_200_1205 VPWR VGND VPWR VGND sky130_ef_sc_hd__decap_12
XFILLER_198_1429 VPWR VGND VPWR VGND sky130_ef_sc_hd__decap_12
Xinput12 func_wdata[0] VGND VGND VPWR VPWR net12 sky130_fd_sc_hd__clkbuf_1
X_318_ net29 net143 net133 VGND VGND VPWR VPWR s_wdata\[25\] sky130_fd_sc_hd__a21o_1
XFILLER_204_1385 VPWR VGND VPWR VGND sky130_ef_sc_hd__decap_12
Xinput45 rst_n VGND VGND VPWR VPWR net45 sky130_fd_sc_hd__clkbuf_1
Xinput23 func_wdata[1] VGND VGND VPWR VPWR net23 sky130_fd_sc_hd__clkbuf_1
Xinput34 func_wdata[2] VGND VGND VPWR VPWR net34 sky130_fd_sc_hd__clkbuf_1
XPHY_EDGE_ROW_60_2_Right_117 VGND VGND VPWR VPWR sky130_fd_sc_hd__decap_3
XFILLER_183_671 VGND VGND VPWR VPWR sky130_fd_sc_hd__fill_1
XFILLER_171_833 VGND VGND VPWR VPWR sky130_fd_sc_hd__decap_6
XFILLER_196_1197 VGND VGND VPWR VPWR sky130_fd_sc_hd__decap_6
XFILLER_192_1017 VPWR VGND VPWR VGND sky130_ef_sc_hd__decap_12
XFILLER_170_321 VPWR VGND VPWR VGND sky130_ef_sc_hd__decap_12
XFILLER_100_1350 VGND VGND VPWR VPWR sky130_fd_sc_hd__decap_6
XFILLER_171_877 VPWR VGND VPWR VGND sky130_ef_sc_hd__decap_12
XFILLER_170_365 VPWR VGND VPWR VGND sky130_ef_sc_hd__decap_12
XFILLER_100_1394 VPWR VGND VPWR VGND sky130_ef_sc_hd__decap_12
XFILLER_42_3 VPWR VGND VPWR VGND sky130_ef_sc_hd__decap_12
XTAP_TAPCELL_ROW_209_2702 VGND VPWR sky130_fd_sc_hd__tapvpwrvgnd_1
XFILLER_170_1315 VGND VGND VPWR VPWR sky130_fd_sc_hd__fill_1
XFILLER_96_121 VGND VGND VPWR VPWR sky130_fd_sc_hd__decap_6
XFILLER_83_1378 VGND VGND VPWR VPWR sky130_fd_sc_hd__decap_6
XTAP_TAPCELL_ROW_27_1_1071 VGND VPWR sky130_fd_sc_hd__tapvpwrvgnd_1
XFILLER_215_1481 VPWR VGND VPWR VGND sky130_ef_sc_hd__decap_12
XFILLER_211_1301 VPWR VGND VPWR VGND sky130_ef_sc_hd__decap_12
XTAP_TAPCELL_ROW_146_2_3926 VGND VPWR sky130_fd_sc_hd__tapvpwrvgnd_1
XFILLER_211_1345 VPWR VGND VPWR VGND sky130_ef_sc_hd__decap_12
XFILLER_0_1401 VPWR VGND VPWR VGND sky130_ef_sc_hd__decap_12
XFILLER_213_517 VPWR VGND VPWR VGND sky130_ef_sc_hd__decap_12
XTAP_TAPCELL_ROW_115_1_1247 VGND VPWR sky130_fd_sc_hd__tapvpwrvgnd_1
XFILLER_111_1490 VGND VGND VPWR VPWR sky130_fd_sc_hd__decap_6
XFILLER_16_29 VPWR VGND VPWR VGND sky130_ef_sc_hd__decap_12
XFILLER_179_933 VPWR VGND VPWR VGND sky130_ef_sc_hd__decap_12
XTAP_TAPCELL_ROW_20_1_1058 VGND VPWR sky130_fd_sc_hd__tapvpwrvgnd_1
XFILLER_181_1455 VGND VGND VPWR VPWR sky130_fd_sc_hd__fill_1
XFILLER_178_421 VPWR VGND VPWR VGND sky130_ef_sc_hd__decap_12
XFILLER_142_1406 VGND VGND VPWR VPWR sky130_fd_sc_hd__decap_6
XFILLER_90_1338 VPWR VGND VPWR VGND sky130_ef_sc_hd__decap_12
XFILLER_194_925 VPWR VGND VPWR VGND sky130_ef_sc_hd__decap_12
XFILLER_179_977 VPWR VGND VPWR VGND sky130_ef_sc_hd__decap_12
XTAP_TAPCELL_ROW_82_1_1181 VGND VPWR sky130_fd_sc_hd__tapvpwrvgnd_1
XFILLER_165_137 VPWR VGND VPWR VGND sky130_ef_sc_hd__decap_12
XFILLER_105_1272 VGND VGND VPWR VPWR sky130_fd_sc_hd__fill_1
XFILLER_4_309 VGND VGND VPWR VPWR sky130_fd_sc_hd__decap_8
XPHY_EDGE_ROW_31_1_Left_250 VGND VGND VPWR VPWR sky130_fd_sc_hd__decap_3
XFILLER_174_693 VGND VGND VPWR VPWR sky130_fd_sc_hd__decap_6
XFILLER_173_181 VPWR VGND VPWR VGND sky130_ef_sc_hd__decap_12
XFILLER_164_27 VGND VGND VPWR VPWR sky130_fd_sc_hd__fill_1
XTAP_TAPCELL_ROW_167_1503 VGND VPWR sky130_fd_sc_hd__tapvpwrvgnd_1
XFILLER_192_1595 VGND VGND VPWR VPWR sky130_fd_sc_hd__fill_1
XFILLER_153_1546 VGND VGND VPWR VPWR sky130_fd_sc_hd__decap_6
XFILLER_180_15 VPWR VGND VPWR VGND sky130_ef_sc_hd__decap_12
XFILLER_5_1301 VPWR VGND VPWR VGND sky130_ef_sc_hd__decap_12
XFILLER_57_69 VPWR VGND VPWR VGND sky130_ef_sc_hd__decap_12
XFILLER_112_1232 VPWR VGND VPWR VGND sky130_ef_sc_hd__decap_12
XFILLER_99_1330 VPWR VGND VPWR VGND sky130_ef_sc_hd__decap_12
XFILLER_5_1345 VPWR VGND VPWR VGND sky130_ef_sc_hd__decap_12
XTAP_TAPCELL_ROW_35_2_3206 VGND VPWR sky130_fd_sc_hd__tapvpwrvgnd_1
XFILLER_216_333 VPWR VGND VPWR VGND sky130_ef_sc_hd__decap_12
XTAP_TAPCELL_ROW_4_898 VGND VPWR sky130_fd_sc_hd__tapvpwrvgnd_1
XFILLER_217_889 VGND VGND VPWR VPWR sky130_fd_sc_hd__decap_6
XFILLER_216_377 VPWR VGND VPWR VGND sky130_ef_sc_hd__decap_12
XANTENNA__329__S net140 VGND VGND VPWR VPWR sky130_fd_sc_hd__diode_2
XTAP_TAPCELL_ROW_219_3020 VGND VPWR sky130_fd_sc_hd__tapvpwrvgnd_1
XFILLER_147_1328 VGND VGND VPWR VPWR sky130_fd_sc_hd__fill_1
XFILLER_73_57 VPWR VGND VPWR VGND sky130_ef_sc_hd__decap_12
XFILLER_197_741 VPWR VGND VPWR VGND sky130_ef_sc_hd__decap_12
XFILLER_189_57 VPWR VGND VPWR VGND sky130_ef_sc_hd__decap_12
XFILLER_200_701 VPWR VGND VPWR VGND sky130_ef_sc_hd__decap_12
XFILLER_197_785 VPWR VGND VPWR VGND sky130_ef_sc_hd__decap_12
XFILLER_196_251 VGND VGND VPWR VPWR sky130_fd_sc_hd__fill_1
XFILLER_160_1506 VPWR VGND VPWR VGND sky130_ef_sc_hd__decap_12
XFILLER_11_110 VGND VGND VPWR VPWR sky130_fd_sc_hd__fill_2
XFILLER_184_413 VGND VGND VPWR VPWR sky130_fd_sc_hd__decap_6
XANTENNA__327__A0 b_addr\[2\] VGND VGND VPWR VPWR sky130_fd_sc_hd__diode_2
XFILLER_201_1525 VPWR VGND VPWR VGND sky130_ef_sc_hd__decap_12
XFILLER_184_457 VPWR VGND VPWR VGND sky130_ef_sc_hd__decap_12
XFILLER_32_1244 VGND VGND VPWR VPWR sky130_fd_sc_hd__fill_1
XFILLER_201_1569 VPWR VGND VPWR VGND sky130_ef_sc_hd__decap_12
XFILLER_165_671 VGND VGND VPWR VPWR sky130_fd_sc_hd__fill_1
XTAP_TAPCELL_ROW_139_2_3880 VGND VPWR sky130_fd_sc_hd__tapvpwrvgnd_1
XFILLER_193_1337 VGND VGND VPWR VPWR sky130_fd_sc_hd__decap_6
XFILLER_138_83 VGND VGND VPWR VPWR sky130_fd_sc_hd__fill_1
XFILLER_217_1009 VPWR VGND VPWR VGND sky130_ef_sc_hd__decap_12
XFILLER_158_1468 VGND VGND VPWR VPWR sky130_fd_sc_hd__fill_1
XTAP_TAPCELL_ROW_152_2_3969 VGND VPWR sky130_fd_sc_hd__tapvpwrvgnd_1
XFILLER_98_65 VPWR VGND VPWR VGND sky130_ef_sc_hd__decap_12
XFILLER_4_887 VGND VGND VPWR VPWR sky130_fd_sc_hd__decap_3
XFILLER_3_386 VGND VGND VPWR VPWR sky130_fd_sc_hd__decap_6
XTAP_TAPCELL_ROW_132_2_3834 VGND VPWR sky130_fd_sc_hd__tapvpwrvgnd_1
XFILLER_80_1518 VGND VGND VPWR VPWR sky130_fd_sc_hd__decap_6
XFILLER_78_121 VGND VGND VPWR VPWR sky130_fd_sc_hd__decap_6
XFILLER_93_113 VPWR VGND VPWR VGND sky130_ef_sc_hd__decap_12
XFILLER_187_1119 VGND VGND VPWR VPWR sky130_fd_sc_hd__fill_1
XFILLER_43_1384 VGND VGND VPWR VPWR sky130_fd_sc_hd__fill_1
XFILLER_219_193 VGND VGND VPWR VPWR sky130_fd_sc_hd__decap_3
XFILLER_208_867 VGND VGND VPWR VPWR sky130_fd_sc_hd__fill_1
XFILLER_78_1414 VPWR VGND VPWR VGND sky130_ef_sc_hd__decap_12
XFILLER_203_561 VPWR VGND VPWR VGND sky130_ef_sc_hd__decap_12
XFILLER_176_925 VPWR VGND VPWR VGND sky130_ef_sc_hd__decap_12
XFILLER_128_1294 VGND VGND VPWR VPWR sky130_fd_sc_hd__decap_6
XFILLER_187_273 VGND VGND VPWR VPWR sky130_fd_sc_hd__decap_6
XFILLER_8_41 VPWR VGND VPWR VGND sky130_ef_sc_hd__decap_12
XFILLER_50_1300 VGND VGND VPWR VPWR sky130_fd_sc_hd__fill_1
XFILLER_102_1412 VGND VGND VPWR VPWR sky130_fd_sc_hd__fill_1
XFILLER_89_1510 VPWR VGND VPWR VGND sky130_ef_sc_hd__decap_12
XFILLER_8_85 VGND VGND VPWR VPWR sky130_fd_sc_hd__fill_1
XFILLER_15_1442 VPWR VGND VPWR VGND sky130_ef_sc_hd__decap_12
XFILLER_200_1035 VGND VGND VPWR VPWR sky130_fd_sc_hd__fill_1
XFILLER_198_1259 VGND VGND VPWR VPWR sky130_fd_sc_hd__fill_1
XFILLER_89_1554 VPWR VGND VPWR VGND sky130_ef_sc_hd__decap_12
XFILLER_11_1328 VGND VGND VPWR VPWR sky130_fd_sc_hd__fill_1
XTAP_TAPCELL_ROW_28_2_3160 VGND VPWR sky130_fd_sc_hd__tapvpwrvgnd_1
XPHY_EDGE_ROW_61_2_Right_118 VGND VGND VPWR VPWR sky130_fd_sc_hd__decap_3
XFILLER_171_641 VPWR VGND VPWR VGND sky130_ef_sc_hd__decap_12
XFILLER_171_685 VPWR VGND VPWR VGND sky130_ef_sc_hd__decap_12
XFILLER_170_195 VGND VGND VPWR VPWR sky130_fd_sc_hd__fill_1
XFILLER_135_1232 VPWR VGND VPWR VGND sky130_ef_sc_hd__decap_12
XFILLER_214_41 VPWR VGND VPWR VGND sky130_ef_sc_hd__decap_12
XTAP_TAPCELL_ROW_21_2_3114 VGND VPWR sky130_fd_sc_hd__tapvpwrvgnd_1
XFILLER_61_1440 VGND VGND VPWR VPWR sky130_fd_sc_hd__fill_1
XFILLER_135_1298 VPWR VGND VPWR VGND sky130_ef_sc_hd__decap_12
XFILLER_113_1552 VGND VGND VPWR VPWR sky130_fd_sc_hd__fill_1
XFILLER_26_1582 VPWR VGND VPWR VGND sky130_ef_sc_hd__decap_12
XFILLER_214_85 VPWR VGND VPWR VGND sky130_ef_sc_hd__decap_12
XFILLER_211_1175 VGND VGND VPWR VPWR sky130_fd_sc_hd__fill_1
XFILLER_150_29 VPWR VGND VPWR VGND sky130_ef_sc_hd__decap_12
XTAP_TAPCELL_ROW_1_824 VGND VPWR sky130_fd_sc_hd__tapvpwrvgnd_1
XTAP_TAPCELL_ROW_1_813 VGND VPWR sky130_fd_sc_hd__tapvpwrvgnd_1
XFILLER_22_1468 VGND VGND VPWR VPWR sky130_fd_sc_hd__fill_1
XFILLER_214_837 VPWR VGND VPWR VGND sky130_ef_sc_hd__decap_12
XFILLER_168_1085 VGND VGND VPWR VPWR sky130_fd_sc_hd__decap_6
XTAP_TAPCELL_ROW_51_1_1119 VGND VPWR sky130_fd_sc_hd__tapvpwrvgnd_1
XFILLER_179_741 VPWR VGND VPWR VGND sky130_ef_sc_hd__decap_12
XFILLER_146_1350 VGND VGND VPWR VPWR sky130_fd_sc_hd__decap_6
XFILLER_94_1282 VPWR VGND VPWR VGND sky130_ef_sc_hd__decap_12
XFILLER_43_27 VPWR VGND VPWR VGND sky130_ef_sc_hd__decap_12
XFILLER_178_251 VGND VGND VPWR VPWR sky130_fd_sc_hd__fill_1
XFILLER_159_27 VPWR VGND VPWR VGND sky130_ef_sc_hd__decap_12
XFILLER_55_1244 VPWR VGND VPWR VGND sky130_ef_sc_hd__decap_12
XFILLER_179_785 VPWR VGND VPWR VGND sky130_ef_sc_hd__decap_12
XFILLER_166_413 VGND VGND VPWR VPWR sky130_fd_sc_hd__decap_6
XFILLER_146_1394 VPWR VGND VPWR VGND sky130_ef_sc_hd__decap_12
XFILLER_194_755 VGND VGND VPWR VPWR sky130_fd_sc_hd__fill_1
XFILLER_182_917 VGND VGND VPWR VPWR sky130_fd_sc_hd__decap_6
XFILLER_166_457 VPWR VGND VPWR VGND sky130_ef_sc_hd__decap_12
XFILLER_142_1258 VPWR VGND VPWR VGND sky130_ef_sc_hd__decap_12
XFILLER_107_1378 VGND VGND VPWR VPWR sky130_fd_sc_hd__decap_6
XFILLER_72_1580 VGND VGND VPWR VPWR sky130_fd_sc_hd__fill_1
XFILLER_181_405 VPWR VGND VPWR VGND sky130_ef_sc_hd__decap_12
XFILLER_175_15 VPWR VGND VPWR VGND sky130_ef_sc_hd__decap_12
XFILLER_181_449 VPWR VGND VPWR VGND sky130_ef_sc_hd__decap_12
XFILLER_175_1001 VGND VGND VPWR VPWR sky130_fd_sc_hd__decap_6
XFILLER_218_1329 VPWR VGND VPWR VGND sky130_ef_sc_hd__decap_12
XFILLER_190_961 VPWR VGND VPWR VGND sky130_ef_sc_hd__decap_12
XFILLER_175_1045 VPWR VGND VPWR VGND sky130_ef_sc_hd__decap_12
XFILLER_108_53 VPWR VGND VPWR VGND sky130_ef_sc_hd__decap_12
XFILLER_175_1089 VPWR VGND VPWR VGND sky130_ef_sc_hd__decap_12
XFILLER_153_1310 VPWR VGND VPWR VGND sky130_ef_sc_hd__decap_12
XFILLER_157_1490 VGND VGND VPWR VPWR sky130_fd_sc_hd__decap_6
XTAP_TAPCELL_ROW_117_2_3736 VGND VPWR sky130_fd_sc_hd__tapvpwrvgnd_1
XFILLER_108_97 VPWR VGND VPWR VGND sky130_ef_sc_hd__decap_12
XFILLER_1_846 VPWR VGND VPWR VGND sky130_ef_sc_hd__decap_12
XFILLER_209_609 VGND VGND VPWR VPWR sky130_fd_sc_hd__decap_6
XFILLER_194_3 VPWR VGND VPWR VGND sky130_ef_sc_hd__decap_12
XFILLER_191_69 VPWR VGND VPWR VGND sky130_ef_sc_hd__decap_12
XFILLER_153_1354 VPWR VGND VPWR VGND sky130_ef_sc_hd__decap_12
XFILLER_7_1429 VPWR VGND VPWR VGND sky130_ef_sc_hd__decap_12
XFILLER_153_1398 VPWR VGND VPWR VGND sky130_ef_sc_hd__decap_12
XFILLER_124_41 VPWR VGND VPWR VGND sky130_ef_sc_hd__decap_12
XFILLER_114_1338 VPWR VGND VPWR VGND sky130_ef_sc_hd__decap_12
XFILLER_75_113 VPWR VGND VPWR VGND sky130_ef_sc_hd__decap_12
XFILLER_40_1524 VGND VGND VPWR VPWR sky130_fd_sc_hd__fill_1
XFILLER_124_85 VPWR VGND VPWR VGND sky130_ef_sc_hd__decap_12
XFILLER_5_1175 VGND VGND VPWR VPWR sky130_fd_sc_hd__fill_1
XFILLER_217_653 VPWR VGND VPWR VGND sky130_ef_sc_hd__decap_12
XFILLER_216_141 VPWR VGND VPWR VGND sky130_ef_sc_hd__decap_12
XFILLER_186_1141 VGND VGND VPWR VPWR sky130_fd_sc_hd__decap_6
XTAP_TAPCELL_ROW_65_2_3401 VGND VPWR sky130_fd_sc_hd__tapvpwrvgnd_1
XFILLER_217_697 VPWR VGND VPWR VGND sky130_ef_sc_hd__decap_12
XFILLER_189_505 VPWR VGND VPWR VGND sky130_ef_sc_hd__decap_12
XFILLER_186_1185 VPWR VGND VPWR VGND sky130_ef_sc_hd__decap_12
XFILLER_182_1005 VPWR VGND VPWR VGND sky130_ef_sc_hd__decap_12
X_583_ clknet_3_3_0_clk _017_ VGND VGND VPWR VPWR u_ctrl.elem_idx\[2\] sky130_fd_sc_hd__dfxtp_2
XFILLER_17_61 VGND VGND VPWR VPWR sky130_fd_sc_hd__fill_1
XFILLER_182_1049 VPWR VGND VPWR VGND sky130_ef_sc_hd__decap_12
XFILLER_73_1322 VGND VGND VPWR VPWR sky130_fd_sc_hd__decap_6
XFILLER_200_531 VGND VGND VPWR VPWR sky130_fd_sc_hd__fill_1
XFILLER_199_1513 VPWR VGND VPWR VGND sky130_ef_sc_hd__decap_12
XFILLER_169_273 VGND VGND VPWR VPWR sky130_fd_sc_hd__decap_6
XFILLER_164_1483 VGND VGND VPWR VPWR sky130_fd_sc_hd__fill_1
XFILLER_160_1314 VPWR VGND VPWR VGND sky130_ef_sc_hd__decap_12
XFILLER_125_1434 VGND VGND VPWR VPWR sky130_fd_sc_hd__decap_6
XFILLER_73_1366 VPWR VGND VPWR VGND sky130_ef_sc_hd__decap_12
XFILLER_185_777 VGND VGND VPWR VPWR sky130_fd_sc_hd__decap_6
XFILLER_184_221 VPWR VGND VPWR VGND sky130_ef_sc_hd__decap_12
XFILLER_160_1358 VPWR VGND VPWR VGND sky130_ef_sc_hd__decap_12
XFILLER_125_1478 VPWR VGND VPWR VGND sky130_ef_sc_hd__decap_12
XFILLER_184_265 VPWR VGND VPWR VGND sky130_ef_sc_hd__decap_12
XFILLER_149_93 VPWR VGND VPWR VGND sky130_ef_sc_hd__decap_12
XFILLER_193_1101 VPWR VGND VPWR VGND sky130_ef_sc_hd__decap_12
XFILLER_201_1399 VGND VGND VPWR VPWR sky130_fd_sc_hd__fill_1
XFILLER_197_1281 VGND VGND VPWR VPWR sky130_fd_sc_hd__decap_6
XFILLER_193_1145 VPWR VGND VPWR VGND sky130_ef_sc_hd__decap_12
XFILLER_158_1232 VPWR VGND VPWR VGND sky130_ef_sc_hd__decap_12
XFILLER_10_1350 VGND VGND VPWR VPWR sky130_fd_sc_hd__decap_6
XFILLER_165_81 VPWR VGND VPWR VGND sky130_ef_sc_hd__decap_12
XTAP_TAPCELL_ROW_139_1_1295 VGND VPWR sky130_fd_sc_hd__tapvpwrvgnd_1
XFILLER_10_1394 VPWR VGND VPWR VGND sky130_ef_sc_hd__decap_12
XFILLER_193_1189 VPWR VGND VPWR VGND sky130_ef_sc_hd__decap_12
XFILLER_84_1462 VGND VGND VPWR VPWR sky130_fd_sc_hd__decap_6
XFILLER_80_1326 VPWR VGND VPWR VGND sky130_ef_sc_hd__decap_12
XFILLER_136_1574 VGND VGND VPWR VPWR sky130_fd_sc_hd__decap_6
XFILLER_132_1438 VPWR VGND VPWR VGND sky130_ef_sc_hd__decap_12
Xhold1 net87 VGND VGND VPWR VPWR net171 sky130_fd_sc_hd__dlygate4sd3_1
XFILLER_81_105 VGND VGND VPWR VPWR sky130_fd_sc_hd__decap_6
XFILLER_78_1244 VGND VGND VPWR VPWR sky130_fd_sc_hd__fill_1
XFILLER_208_1509 VPWR VGND VPWR VGND sky130_ef_sc_hd__decap_12
XFILLER_165_1225 VGND VGND VPWR VPWR sky130_fd_sc_hd__decap_6
XFILLER_21_1490 VGND VGND VPWR VPWR sky130_fd_sc_hd__decap_6
XFILLER_204_881 VPWR VGND VPWR VGND sky130_ef_sc_hd__decap_12
XFILLER_165_1269 VPWR VGND VPWR VGND sky130_ef_sc_hd__decap_12
XFILLER_91_1422 VPWR VGND VPWR VGND sky130_ef_sc_hd__decap_12
XANTENNA__539__B1 net139 VGND VGND VPWR VPWR sky130_fd_sc_hd__diode_2
Xu_sram.u_mem_161 VGND VGND VPWR VPWR u_sram.u_mem_161/HI net161 sky130_fd_sc_hd__conb_1
XFILLER_52_1406 VGND VGND VPWR VPWR sky130_fd_sc_hd__decap_6
XFILLER_203_391 VGND VGND VPWR VPWR sky130_fd_sc_hd__fill_1
XFILLER_200_65 VPWR VGND VPWR VGND sky130_ef_sc_hd__decap_12
XFILLER_143_1534 VPWR VGND VPWR VGND sky130_ef_sc_hd__decap_12
XFILLER_91_1466 VPWR VGND VPWR VGND sky130_ef_sc_hd__decap_12
XFILLER_176_755 VGND VGND VPWR VPWR sky130_fd_sc_hd__fill_1
XFILLER_164_917 VGND VGND VPWR VPWR sky130_fd_sc_hd__decap_6
XFILLER_143_1578 VPWR VGND VPWR VGND sky130_ef_sc_hd__decap_12
XFILLER_104_1518 VGND VGND VPWR VPWR sky130_fd_sc_hd__decap_6
XFILLER_163_405 VPWR VGND VPWR VGND sky130_ef_sc_hd__decap_12
XTAP_TAPCELL_ROW_123_2_3779 VGND VPWR sky130_fd_sc_hd__tapvpwrvgnd_1
XFILLER_102_1220 VPWR VGND VPWR VGND sky130_ef_sc_hd__decap_12
XFILLER_15_1272 VGND VGND VPWR VPWR sky130_fd_sc_hd__fill_1
XFILLER_163_449 VPWR VGND VPWR VGND sky130_ef_sc_hd__decap_12
XFILLER_172_961 VPWR VGND VPWR VGND sky130_ef_sc_hd__decap_12
XTAP_TAPCELL_ROW_91_2_3568 VGND VPWR sky130_fd_sc_hd__tapvpwrvgnd_1
XFILLER_89_1384 VGND VGND VPWR VPWR sky130_fd_sc_hd__fill_1
XPHY_EDGE_ROW_62_2_Right_119 VGND VGND VPWR VPWR sky130_fd_sc_hd__decap_3
XFILLER_176_1365 VGND VGND VPWR VPWR sky130_fd_sc_hd__decap_6
XFILLER_172_1229 VPWR VGND VPWR VGND sky130_ef_sc_hd__decap_12
XFILLER_63_1546 VGND VGND VPWR VPWR sky130_fd_sc_hd__decap_6
XTAP_TAPCELL_ROW_6_949 VGND VPWR sky130_fd_sc_hd__tapvpwrvgnd_1
XFILLER_38_27 VGND VGND VPWR VPWR sky130_fd_sc_hd__fill_1
XFILLER_150_1538 VPWR VGND VPWR VGND sky130_ef_sc_hd__decap_12
XFILLER_57_113 VPWR VGND VPWR VGND sky130_ef_sc_hd__decap_12
XFILLER_161_39 VPWR VGND VPWR VGND sky130_ef_sc_hd__decap_12
XFILLER_96_1300 VGND VGND VPWR VPWR sky130_fd_sc_hd__fill_1
XFILLER_2_1315 VGND VGND VPWR VPWR sky130_fd_sc_hd__fill_1
XFILLER_22_1232 VPWR VGND VPWR VGND sky130_ef_sc_hd__decap_12
XFILLER_214_601 VPWR VGND VPWR VGND sky130_ef_sc_hd__decap_12
XFILLER_213_111 VGND VGND VPWR VPWR sky130_fd_sc_hd__fill_1
XTAP_TAPCELL_ROW_181_1897 VGND VPWR sky130_fd_sc_hd__tapvpwrvgnd_1
XTAP_TAPCELL_ROW_181_1886 VGND VPWR sky130_fd_sc_hd__tapvpwrvgnd_1
XFILLER_148_1412 VGND VGND VPWR VPWR sky130_fd_sc_hd__fill_1
XFILLER_214_645 VPWR VGND VPWR VGND sky130_ef_sc_hd__decap_12
XFILLER_183_1325 VPWR VGND VPWR VGND sky130_ef_sc_hd__decap_12
XFILLER_0_1061 VGND VGND VPWR VPWR sky130_fd_sc_hd__decap_3
XFILLER_57_1328 VGND VGND VPWR VPWR sky130_fd_sc_hd__fill_1
XFILLER_201_317 VPWR VGND VPWR VGND sky130_ef_sc_hd__decap_12
XFILLER_198_357 VGND VGND VPWR VPWR sky130_fd_sc_hd__decap_6
XFILLER_183_1369 VPWR VGND VPWR VGND sky130_ef_sc_hd__decap_12
XFILLER_110_65 VPWR VGND VPWR VGND sky130_ef_sc_hd__decap_12
XFILLER_70_1506 VPWR VGND VPWR VGND sky130_ef_sc_hd__decap_12
XFILLER_166_221 VPWR VGND VPWR VGND sky130_ef_sc_hd__decap_12
XPHY_EDGE_ROW_137_2_Left_569 VGND VGND VPWR VPWR sky130_fd_sc_hd__decap_3
XFILLER_182_725 VPWR VGND VPWR VGND sky130_ef_sc_hd__decap_12
XFILLER_167_777 VGND VGND VPWR VPWR sky130_fd_sc_hd__decap_6
XFILLER_166_265 VPWR VGND VPWR VGND sky130_ef_sc_hd__decap_12
XFILLER_6_905 VPWR VGND VPWR VGND sky130_ef_sc_hd__decap_12
XTAP_TAPCELL_ROW_12_2_3059 VGND VPWR sky130_fd_sc_hd__tapvpwrvgnd_1
XFILLER_182_769 VPWR VGND VPWR VGND sky130_ef_sc_hd__decap_12
XFILLER_6_949 VPWR VGND VPWR VGND sky130_ef_sc_hd__decap_12
XFILLER_207_3 VPWR VGND VPWR VGND sky130_ef_sc_hd__decap_12
XFILLER_194_1421 VGND VGND VPWR VPWR sky130_fd_sc_hd__decap_6
XFILLER_181_279 VGND VGND VPWR VPWR sky130_fd_sc_hd__fill_1
XFILLER_159_1552 VGND VGND VPWR VPWR sky130_fd_sc_hd__fill_1
XPHY_EDGE_ROW_74_2_Left_506 VGND VGND VPWR VPWR sky130_fd_sc_hd__decap_3
XPHY_EDGE_ROW_2_Left_222 VGND VGND VPWR VPWR sky130_fd_sc_hd__decap_3
XFILLER_194_1465 VPWR VGND VPWR VGND sky130_ef_sc_hd__decap_12
XFILLER_68_1468 VGND VGND VPWR VPWR sky130_fd_sc_hd__fill_1
XFILLER_190_1329 VPWR VGND VPWR VGND sky130_ef_sc_hd__decap_12
XFILLER_81_1602 VGND VGND VPWR VPWR sky130_fd_sc_hd__decap_3
XFILLER_135_51 VGND VGND VPWR VPWR sky130_fd_sc_hd__decap_4
XFILLER_1_654 VPWR VGND VPWR VGND sky130_ef_sc_hd__decap_12
XFILLER_209_417 VPWR VGND VPWR VGND sky130_ef_sc_hd__decap_12
XTAP_TAPCELL_ROW_147_2_3931 VGND VPWR sky130_fd_sc_hd__tapvpwrvgnd_1
XFILLER_118_1282 VPWR VGND VPWR VGND sky130_ef_sc_hd__decap_12
XFILLER_95_55 VGND VGND VPWR VPWR sky130_fd_sc_hd__fill_1
XFILLER_0_197 VPWR VGND VPWR VGND sky130_ef_sc_hd__decap_12
XFILLER_0_186 VGND VGND VPWR VPWR sky130_fd_sc_hd__decap_8
XFILLER_188_1203 VGND VGND VPWR VPWR sky130_fd_sc_hd__fill_1
XFILLER_218_973 VGND VGND VPWR VPWR sky130_fd_sc_hd__decap_6
XFILLER_63_105 VGND VGND VPWR VPWR sky130_fd_sc_hd__decap_6
XFILLER_28_60 VGND VGND VPWR VPWR sky130_fd_sc_hd__decap_8
XFILLER_217_461 VPWR VGND VPWR VGND sky130_ef_sc_hd__decap_12
XFILLER_204_133 VGND VGND VPWR VPWR sky130_fd_sc_hd__decap_6
XFILLER_189_335 VGND VGND VPWR VPWR sky130_fd_sc_hd__fill_1
X_566_ net154 _086_ VGND VGND VPWR VPWR _256_ sky130_fd_sc_hd__nand2_1
XFILLER_204_177 VPWR VGND VPWR VGND sky130_ef_sc_hd__decap_12
XFILLER_166_1589 VGND VGND VPWR VPWR sky130_fd_sc_hd__decap_6
XFILLER_125_1220 VPWR VGND VPWR VGND sky130_ef_sc_hd__decap_12
X_497_ net151 _176_ net130 net138 _222_ VGND VGND VPWR VPWR _032_ sky130_fd_sc_hd__o311a_1
XFILLER_185_541 VPWR VGND VPWR VGND sky130_ef_sc_hd__decap_12
XFILLER_38_1294 VGND VGND VPWR VPWR sky130_fd_sc_hd__decap_6
XFILLER_201_895 VGND VGND VPWR VPWR sky130_fd_sc_hd__fill_1
XFILLER_199_1343 VGND VGND VPWR VPWR sky130_fd_sc_hd__fill_1
XTAP_TAPCELL_ROW_191_2171 VGND VPWR sky130_fd_sc_hd__tapvpwrvgnd_1
XFILLER_185_585 VPWR VGND VPWR VGND sky130_ef_sc_hd__decap_12
XFILLER_125_1286 VPWR VGND VPWR VGND sky130_ef_sc_hd__decap_12
XFILLER_12_1412 VGND VGND VPWR VPWR sky130_fd_sc_hd__fill_1
XTAP_TAPCELL_ROW_191_2193 VGND VPWR sky130_fd_sc_hd__tapvpwrvgnd_1
XTAP_TAPCELL_ROW_191_2182 VGND VPWR sky130_fd_sc_hd__tapvpwrvgnd_1
XFILLER_86_1524 VGND VGND VPWR VPWR sky130_fd_sc_hd__fill_1
XTAP_TAPCELL_ROW_212_2786 VGND VPWR sky130_fd_sc_hd__tapvpwrvgnd_1
XTAP_TAPCELL_ROW_212_2775 VGND VPWR sky130_fd_sc_hd__tapvpwrvgnd_1
XFILLER_173_1505 VGND VGND VPWR VPWR sky130_fd_sc_hd__decap_6
XFILLER_173_1549 VPWR VGND VPWR VGND sky130_ef_sc_hd__decap_12
XFILLER_140_121 VGND VGND VPWR VPWR sky130_fd_sc_hd__decap_6
XFILLER_84_1270 VPWR VGND VPWR VGND sky130_ef_sc_hd__decap_12
XTAP_TAPCELL_ROW_75_1_1167 VGND VPWR sky130_fd_sc_hd__tapvpwrvgnd_1
XFILLER_45_1232 VPWR VGND VPWR VGND sky130_ef_sc_hd__decap_12
XFILLER_136_1382 VPWR VGND VPWR VGND sky130_ef_sc_hd__decap_12
XTAP_TAPCELL_ROW_36_2_3211 VGND VPWR sky130_fd_sc_hd__tapvpwrvgnd_1
XFILLER_39_113 VPWR VGND VPWR VGND sky130_ef_sc_hd__decap_12
XFILLER_132_1246 VPWR VGND VPWR VGND sky130_ef_sc_hd__decap_12
XFILLER_45_1298 VPWR VGND VPWR VGND sky130_ef_sc_hd__decap_12
XFILLER_209_951 VGND VGND VPWR VPWR sky130_fd_sc_hd__fill_1
XFILLER_23_1552 VGND VGND VPWR VPWR sky130_fd_sc_hd__fill_1
XFILLER_208_1317 VPWR VGND VPWR VGND sky130_ef_sc_hd__decap_12
XTAP_TAPCELL_ROW_198_2369 VGND VPWR sky130_fd_sc_hd__tapvpwrvgnd_1
XFILLER_165_1033 VPWR VGND VPWR VGND sky130_ef_sc_hd__decap_12
XFILLER_211_615 VGND VGND VPWR VPWR sky130_fd_sc_hd__fill_1
XFILLER_180_1509 VPWR VGND VPWR VGND sky130_ef_sc_hd__decap_12
XFILLER_1_1381 VPWR VGND VPWR VGND sky130_ef_sc_hd__decap_12
XFILLER_24_29 VGND VGND VPWR VPWR sky130_fd_sc_hd__fill_2
XFILLER_195_305 VPWR VGND VPWR VGND sky130_ef_sc_hd__decap_12
XFILLER_165_1077 VPWR VGND VPWR VGND sky130_ef_sc_hd__decap_12
XANTENNA_fanout147_A u_ctrl.cmp_exp\[0\] VGND VGND VPWR VPWR sky130_fd_sc_hd__diode_2
XFILLER_56_1350 VGND VGND VPWR VPWR sky130_fd_sc_hd__decap_6
XFILLER_195_349 VPWR VGND VPWR VGND sky130_ef_sc_hd__decap_12
XFILLER_143_1342 VPWR VGND VPWR VGND sky130_ef_sc_hd__decap_12
XFILLER_108_1462 VGND VGND VPWR VPWR sky130_fd_sc_hd__decap_6
XFILLER_91_1274 VPWR VGND VPWR VGND sky130_ef_sc_hd__decap_12
XFILLER_56_1394 VPWR VGND VPWR VGND sky130_ef_sc_hd__decap_12
XFILLER_206_1085 VGND VGND VPWR VPWR sky130_fd_sc_hd__decap_6
XFILLER_164_725 VPWR VGND VPWR VGND sky130_ef_sc_hd__decap_12
XFILLER_143_1386 VPWR VGND VPWR VGND sky130_ef_sc_hd__decap_12
XFILLER_104_1326 VPWR VGND VPWR VGND sky130_ef_sc_hd__decap_12
XFILLER_17_1378 VGND VGND VPWR VPWR sky130_fd_sc_hd__decap_6
XFILLER_52_1258 VPWR VGND VPWR VGND sky130_ef_sc_hd__decap_12
XFILLER_178_1427 VGND VGND VPWR VPWR sky130_fd_sc_hd__fill_1
XFILLER_219_1413 VPWR VGND VPWR VGND sky130_ef_sc_hd__decap_12
XTAP_TAPCELL_ROW_174_1690 VGND VPWR sky130_fd_sc_hd__tapvpwrvgnd_1
XFILLER_164_769 VPWR VGND VPWR VGND sky130_ef_sc_hd__decap_12
XTAP_TAPCELL_ROW_153_2_3974 VGND VPWR sky130_fd_sc_hd__tapvpwrvgnd_1
XTAP_TAPCELL_ROW_170_1587 VGND VPWR sky130_fd_sc_hd__tapvpwrvgnd_1
XTAP_TAPCELL_ROW_170_1576 VGND VPWR sky130_fd_sc_hd__tapvpwrvgnd_1
XFILLER_219_1457 VPWR VGND VPWR VGND sky130_ef_sc_hd__decap_12
XFILLER_176_1173 VPWR VGND VPWR VGND sky130_ef_sc_hd__decap_12
XFILLER_172_1037 VPWR VGND VPWR VGND sky130_ef_sc_hd__decap_12
XTAP_TAPCELL_ROW_170_1598 VGND VPWR sky130_fd_sc_hd__tapvpwrvgnd_1
XTAP_TAPCELL_ROW_122_1_1262 VGND VPWR sky130_fd_sc_hd__tapvpwrvgnd_1
XFILLER_63_1310 VPWR VGND VPWR VGND sky130_ef_sc_hd__decap_12
XFILLER_213_1001 VGND VGND VPWR VPWR sky130_fd_sc_hd__decap_6
XFILLER_172_27 VGND VGND VPWR VPWR sky130_fd_sc_hd__fill_1
XFILLER_67_1490 VGND VGND VPWR VPWR sky130_fd_sc_hd__decap_6
XFILLER_8_1524 VGND VGND VPWR VPWR sky130_fd_sc_hd__fill_1
XFILLER_213_1045 VPWR VGND VPWR VGND sky130_ef_sc_hd__decap_12
XFILLER_154_1482 VPWR VGND VPWR VGND sky130_ef_sc_hd__decap_12
XFILLER_150_1302 VPWR VGND VPWR VGND sky130_ef_sc_hd__decap_12
XFILLER_115_1422 VPWR VGND VPWR VGND sky130_ef_sc_hd__decap_12
XFILLER_63_1354 VPWR VGND VPWR VGND sky130_ef_sc_hd__decap_12
XTAP_TAPCELL_ROW_183_1959 VGND VPWR sky130_fd_sc_hd__tapvpwrvgnd_1
XTAP_TAPCELL_ROW_183_1948 VGND VPWR sky130_fd_sc_hd__tapvpwrvgnd_1
XFILLER_115_1466 VPWR VGND VPWR VGND sky130_ef_sc_hd__decap_12
XFILLER_98_1406 VGND VGND VPWR VPWR sky130_fd_sc_hd__decap_6
XFILLER_63_1398 VPWR VGND VPWR VGND sky130_ef_sc_hd__decap_12
XFILLER_24_1338 VPWR VGND VPWR VGND sky130_ef_sc_hd__decap_12
XFILLER_213_1089 VPWR VGND VPWR VGND sky130_ef_sc_hd__decap_12
XFILLER_189_1567 VGND VGND VPWR VPWR sky130_fd_sc_hd__fill_1
XFILLER_215_921 VPWR VGND VPWR VGND sky130_ef_sc_hd__decap_12
XFILLER_65_69 VPWR VGND VPWR VGND sky130_ef_sc_hd__decap_12
XFILLER_215_965 VPWR VGND VPWR VGND sky130_ef_sc_hd__decap_12
XFILLER_198_121 VPWR VGND VPWR VGND sky130_ef_sc_hd__decap_12
XFILLER_148_1220 VPWR VGND VPWR VGND sky130_ef_sc_hd__decap_12
X_420_ net156 _154_ VGND VGND VPWR VPWR _023_ sky130_fd_sc_hd__and2_1
XFILLER_214_475 VGND VGND VPWR VPWR sky130_fd_sc_hd__fill_1
XFILLER_183_1133 VPWR VGND VPWR VGND sky130_ef_sc_hd__decap_12
XFILLER_157_3 VPWR VGND VPWR VGND sky130_ef_sc_hd__decap_12
X_351_ net157 _096_ VGND VGND VPWR VPWR _012_ sky130_fd_sc_hd__and2_1
XFILLER_202_637 VGND VGND VPWR VPWR sky130_fd_sc_hd__decap_6
XFILLER_201_125 VPWR VGND VPWR VGND sky130_ef_sc_hd__decap_12
XFILLER_198_165 VPWR VGND VPWR VGND sky130_ef_sc_hd__decap_12
XFILLER_187_839 VGND VGND VPWR VPWR sky130_fd_sc_hd__fill_1
XFILLER_183_1177 VPWR VGND VPWR VGND sky130_ef_sc_hd__decap_12
XFILLER_81_57 VPWR VGND VPWR VGND sky130_ef_sc_hd__decap_12
XFILLER_74_1450 VPWR VGND VPWR VGND sky130_ef_sc_hd__decap_12
XFILLER_201_169 VPWR VGND VPWR VGND sky130_ef_sc_hd__decap_12
XFILLER_197_57 VPWR VGND VPWR VGND sky130_ef_sc_hd__decap_12
XFILLER_167_541 VPWR VGND VPWR VGND sky130_ef_sc_hd__decap_12
XFILLER_161_1442 VPWR VGND VPWR VGND sky130_ef_sc_hd__decap_12
XFILLER_126_1562 VPWR VGND VPWR VGND sky130_ef_sc_hd__decap_12
XFILLER_74_1494 VPWR VGND VPWR VGND sky130_ef_sc_hd__decap_12
XFILLER_70_1314 VPWR VGND VPWR VGND sky130_ef_sc_hd__decap_12
XANTENNA__634__Q u_ctrl.cmp_exp\[0\] VGND VGND VPWR VPWR sky130_fd_sc_hd__diode_2
X_282_ _069_ u_ctrl.elem_idx\[1\] _071_ VGND VGND VPWR VPWR _080_ sky130_fd_sc_hd__or3_1
XFILLER_35_1434 VGND VGND VPWR VPWR sky130_fd_sc_hd__decap_6
XFILLER_210_681 VPWR VGND VPWR VGND sky130_ef_sc_hd__decap_12
XFILLER_122_1426 VPWR VGND VPWR VGND sky130_ef_sc_hd__decap_12
XFILLER_70_1358 VPWR VGND VPWR VGND sky130_ef_sc_hd__decap_12
XFILLER_35_1478 VPWR VGND VPWR VGND sky130_ef_sc_hd__decap_12
XTAP_TAPCELL_ROW_62_2_3378 VGND VPWR sky130_fd_sc_hd__tapvpwrvgnd_1
XFILLER_182_533 VPWR VGND VPWR VGND sky130_ef_sc_hd__decap_12
XFILLER_167_585 VPWR VGND VPWR VGND sky130_ef_sc_hd__decap_12
XFILLER_6_713 VPWR VGND VPWR VGND sky130_ef_sc_hd__decap_12
XFILLER_202_1483 VGND VGND VPWR VPWR sky130_fd_sc_hd__fill_1
XFILLER_5_223 VGND VGND VPWR VPWR sky130_fd_sc_hd__fill_1
XFILLER_6_757 VPWR VGND VPWR VGND sky130_ef_sc_hd__decap_12
XFILLER_30_50 VGND VGND VPWR VPWR sky130_fd_sc_hd__fill_2
XFILLER_68_1232 VPWR VGND VPWR VGND sky130_ef_sc_hd__decap_12
XFILLER_5_267 VPWR VGND VPWR VGND sky130_ef_sc_hd__decap_12
XTAP_TAPCELL_ROW_42_2_3254 VGND VPWR sky130_fd_sc_hd__tapvpwrvgnd_1
XFILLER_194_1273 VPWR VGND VPWR VGND sky130_ef_sc_hd__decap_12
XFILLER_146_83 VGND VGND VPWR VPWR sky130_fd_sc_hd__fill_1
XFILLER_122_121 VGND VGND VPWR VPWR sky130_fd_sc_hd__decap_6
XFILLER_155_1268 VGND VGND VPWR VPWR sky130_fd_sc_hd__decap_4
XFILLER_85_1590 VPWR VGND VPWR VGND sky130_ef_sc_hd__decap_12
XFILLER_81_1410 VPWR VGND VPWR VGND sky130_ef_sc_hd__decap_12
XFILLER_133_1522 VPWR VGND VPWR VGND sky130_ef_sc_hd__decap_12
XFILLER_81_1454 VPWR VGND VPWR VGND sky130_ef_sc_hd__decap_12
XFILLER_1_473 VGND VGND VPWR VPWR sky130_fd_sc_hd__decap_8
XFILLER_46_1574 VGND VGND VPWR VPWR sky130_fd_sc_hd__decap_6
XFILLER_209_225 VPWR VGND VPWR VGND sky130_ef_sc_hd__decap_12
XFILLER_133_1566 VPWR VGND VPWR VGND sky130_ef_sc_hd__decap_12
XFILLER_81_1498 VPWR VGND VPWR VGND sky130_ef_sc_hd__decap_12
XFILLER_39_81 VPWR VGND VPWR VGND sky130_ef_sc_hd__decap_12
XFILLER_42_1438 VPWR VGND VPWR VGND sky130_ef_sc_hd__decap_12
XFILLER_7_1089 VGND VGND VPWR VPWR sky130_fd_sc_hd__decap_3
XFILLER_218_781 VPWR VGND VPWR VGND sky130_ef_sc_hd__decap_12
XTAP_TAPCELL_ROW_205_2590 VGND VPWR sky130_fd_sc_hd__tapvpwrvgnd_1
X_618_ clknet_3_7_0_clk _052_ VGND VGND VPWR VPWR net75 sky130_fd_sc_hd__dfxtp_1
XTAP_TAPCELL_ROW_201_2465 VGND VPWR sky130_fd_sc_hd__tapvpwrvgnd_1
XFILLER_166_1353 VPWR VGND VPWR VGND sky130_ef_sc_hd__decap_12
XFILLER_205_497 VGND VGND VPWR VPWR sky130_fd_sc_hd__decap_6
XTAP_TAPCELL_ROW_201_2476 VGND VPWR sky130_fd_sc_hd__tapvpwrvgnd_1
XFILLER_177_305 VPWR VGND VPWR VGND sky130_ef_sc_hd__decap_12
XFILLER_166_1397 VPWR VGND VPWR VGND sky130_ef_sc_hd__decap_12
XFILLER_92_1550 VPWR VGND VPWR VGND sky130_ef_sc_hd__decap_12
XANTENNA__474__C _198_ VGND VGND VPWR VPWR sky130_fd_sc_hd__diode_2
X_549_ net136 _248_ VGND VGND VPWR VPWR _058_ sky130_fd_sc_hd__and2_1
XTAP_TAPCELL_ROW_218_2940 VGND VPWR sky130_fd_sc_hd__tapvpwrvgnd_1
XTAP_TAPCELL_ROW_193_2244 VGND VPWR sky130_fd_sc_hd__tapvpwrvgnd_1
XFILLER_193_809 VPWR VGND VPWR VGND sky130_ef_sc_hd__decap_12
XTAP_TAPCELL_ROW_193_2233 VGND VPWR sky130_fd_sc_hd__tapvpwrvgnd_1
XFILLER_177_349 VPWR VGND VPWR VGND sky130_ef_sc_hd__decap_12
XFILLER_105_1602 VGND VGND VPWR VPWR sky130_fd_sc_hd__decap_3
XFILLER_92_1594 VGND VGND VPWR VPWR sky130_fd_sc_hd__decap_8
XFILLER_53_1534 VPWR VGND VPWR VGND sky130_ef_sc_hd__decap_12
XTAP_TAPCELL_ROW_218_2962 VGND VPWR sky130_fd_sc_hd__tapvpwrvgnd_1
XTAP_TAPCELL_ROW_218_2951 VGND VPWR sky130_fd_sc_hd__tapvpwrvgnd_1
XFILLER_203_1225 VGND VGND VPWR VPWR sky130_fd_sc_hd__decap_6
XFILLER_186_861 VGND VGND VPWR VPWR sky130_fd_sc_hd__decap_6
XFILLER_140_1526 VPWR VGND VPWR VGND sky130_ef_sc_hd__decap_12
XFILLER_14_1518 VGND VGND VPWR VPWR sky130_fd_sc_hd__decap_6
XFILLER_53_1578 VPWR VGND VPWR VGND sky130_ef_sc_hd__decap_12
XTAP_TAPCELL_ROW_214_2837 VGND VPWR sky130_fd_sc_hd__tapvpwrvgnd_1
XTAP_TAPCELL_ROW_214_2826 VGND VPWR sky130_fd_sc_hd__tapvpwrvgnd_1
XFILLER_203_1269 VPWR VGND VPWR VGND sky130_ef_sc_hd__decap_12
XFILLER_185_393 VPWR VGND VPWR VGND sky130_ef_sc_hd__decap_12
XFILLER_72_3 VPWR VGND VPWR VGND sky130_ef_sc_hd__decap_12
XFILLER_12_1220 VPWR VGND VPWR VGND sky130_ef_sc_hd__decap_12
XTAP_TAPCELL_ROW_214_2848 VGND VPWR sky130_fd_sc_hd__tapvpwrvgnd_1
XTAP_TAPCELL_ROW_138_2_3876 VGND VPWR sky130_fd_sc_hd__tapvpwrvgnd_1
XFILLER_177_1493 VPWR VGND VPWR VGND sky130_ef_sc_hd__decap_12
XFILLER_173_1313 VPWR VGND VPWR VGND sky130_ef_sc_hd__decap_12
XTAP_TAPCELL_ROW_187_2059 VGND VPWR sky130_fd_sc_hd__tapvpwrvgnd_1
XFILLER_173_1357 VPWR VGND VPWR VGND sky130_ef_sc_hd__decap_12
XFILLER_206_53 VPWR VGND VPWR VGND sky130_ef_sc_hd__decap_12
XFILLER_214_1365 VGND VGND VPWR VPWR sky130_fd_sc_hd__decap_6
XFILLER_206_97 VPWR VGND VPWR VGND sky130_ef_sc_hd__decap_12
XFILLER_60_1538 VPWR VGND VPWR VGND sky130_ef_sc_hd__decap_12
XFILLER_210_1229 VPWR VGND VPWR VGND sky130_ef_sc_hd__decap_12
XFILLER_215_217 VGND VGND VPWR VPWR sky130_fd_sc_hd__decap_6
XTAP_TAPCELL_ROW_163_1391 VGND VPWR sky130_fd_sc_hd__tapvpwrvgnd_1
XTAP_TAPCELL_ROW_163_1380 VGND VPWR sky130_fd_sc_hd__tapvpwrvgnd_1
XFILLER_35_39 VPWR VGND VPWR VGND sky130_ef_sc_hd__decap_12
XFILLER_58_1412 VGND VGND VPWR VPWR sky130_fd_sc_hd__fill_1
XFILLER_184_1453 VPWR VGND VPWR VGND sky130_ef_sc_hd__decap_12
XFILLER_208_1147 VGND VGND VPWR VPWR sky130_fd_sc_hd__fill_1
XFILLER_196_625 VPWR VGND VPWR VGND sky130_ef_sc_hd__decap_12
XFILLER_184_1497 VPWR VGND VPWR VGND sky130_ef_sc_hd__decap_12
XFILLER_180_1317 VPWR VGND VPWR VGND sky130_ef_sc_hd__decap_12
XFILLER_169_839 VGND VGND VPWR VPWR sky130_fd_sc_hd__fill_1
XFILLER_212_979 VGND VGND VPWR VPWR sky130_fd_sc_hd__fill_1
XFILLER_196_669 VPWR VGND VPWR VGND sky130_ef_sc_hd__decap_12
XFILLER_195_113 VPWR VGND VPWR VGND sky130_ef_sc_hd__decap_12
XFILLER_51_27 VPWR VGND VPWR VGND sky130_ef_sc_hd__decap_12
XPHY_EDGE_ROW_208_Left_427 VGND VGND VPWR VPWR sky130_fd_sc_hd__decap_3
XTAP_TAPCELL_ROW_176_1763 VGND VPWR sky130_fd_sc_hd__tapvpwrvgnd_1
XTAP_TAPCELL_ROW_176_1752 VGND VPWR sky130_fd_sc_hd__tapvpwrvgnd_1
XFILLER_167_27 VPWR VGND VPWR VGND sky130_ef_sc_hd__decap_12
XFILLER_108_1270 VPWR VGND VPWR VGND sky130_ef_sc_hd__decap_12
XTAP_TAPCELL_ROW_172_1638 VGND VPWR sky130_fd_sc_hd__tapvpwrvgnd_1
XFILLER_164_533 VPWR VGND VPWR VGND sky130_ef_sc_hd__decap_12
XTAP_TAPCELL_ROW_172_1649 VGND VPWR sky130_fd_sc_hd__tapvpwrvgnd_1
XTAP_TAPCELL_ROW_27_2_3156 VGND VPWR sky130_fd_sc_hd__tapvpwrvgnd_1
XFILLER_191_385 VGND VGND VPWR VPWR sky130_fd_sc_hd__decap_6
XFILLER_183_15 VPWR VGND VPWR VGND sky130_ef_sc_hd__decap_12
XFILLER_69_1552 VGND VGND VPWR VPWR sky130_fd_sc_hd__fill_1
XFILLER_195_1593 VPWR VGND VPWR VGND sky130_ef_sc_hd__decap_12
XFILLER_191_1413 VPWR VGND VPWR VGND sky130_ef_sc_hd__decap_12
XFILLER_104_121 VGND VGND VPWR VPWR sky130_fd_sc_hd__decap_6
XFILLER_191_1457 VPWR VGND VPWR VGND sky130_ef_sc_hd__decap_12
XTAP_TAPCELL_ROW_153_1_1323 VGND VPWR sky130_fd_sc_hd__tapvpwrvgnd_1
XFILLER_219_501 VGND VGND VPWR VPWR sky130_fd_sc_hd__decap_3
XFILLER_116_53 VPWR VGND VPWR VGND sky130_ef_sc_hd__decap_12
XPHY_EDGE_ROW_217_Left_436 VGND VGND VPWR VPWR sky130_fd_sc_hd__decap_3
XFILLER_116_97 VPWR VGND VPWR VGND sky130_ef_sc_hd__decap_12
XFILLER_28_1282 VPWR VGND VPWR VGND sky130_ef_sc_hd__decap_12
XFILLER_219_545 VPWR VGND VPWR VGND sky130_ef_sc_hd__decap_12
XFILLER_115_1274 VPWR VGND VPWR VGND sky130_ef_sc_hd__decap_12
XFILLER_4_1229 VPWR VGND VPWR VGND sky130_ef_sc_hd__decap_12
XFILLER_18_105 VGND VGND VPWR VPWR sky130_fd_sc_hd__fill_2
XFILLER_219_589 VPWR VGND VPWR VGND sky130_ef_sc_hd__decap_12
XFILLER_207_729 VPWR VGND VPWR VGND sky130_ef_sc_hd__decap_12
XFILLER_132_41 VPWR VGND VPWR VGND sky130_ef_sc_hd__decap_12
XFILLER_98_1258 VPWR VGND VPWR VGND sky130_ef_sc_hd__decap_12
XFILLER_132_85 VPWR VGND VPWR VGND sky130_ef_sc_hd__decap_12
XFILLER_199_441 VGND VGND VPWR VPWR sky130_fd_sc_hd__decap_6
XFILLER_128_1602 VGND VGND VPWR VPWR sky130_fd_sc_hd__decap_3
X_403_ b_addr\[4\] _104_ VGND VGND VPWR VPWR _139_ sky130_fd_sc_hd__nor2_1
XFILLER_202_401 VPWR VGND VPWR VGND sky130_ef_sc_hd__decap_12
XFILLER_199_485 VPWR VGND VPWR VGND sky130_ef_sc_hd__decap_12
XFILLER_163_1537 VGND VGND VPWR VPWR sky130_fd_sc_hd__decap_3
XFILLER_202_445 VPWR VGND VPWR VGND sky130_ef_sc_hd__decap_12
XFILLER_175_809 VPWR VGND VPWR VGND sky130_ef_sc_hd__decap_12
X_334_ u_ctrl.elem_idx\[2\] _070_ u_ctrl.elem_idx\[0\] _088_ VGND VGND VPWR VPWR _089_
+ sky130_fd_sc_hd__a31oi_2
XFILLER_35_1220 VPWR VGND VPWR VGND sky130_ef_sc_hd__decap_12
XFILLER_202_489 VPWR VGND VPWR VGND sky130_ef_sc_hd__decap_12
XFILLER_168_861 VGND VGND VPWR VPWR sky130_fd_sc_hd__decap_6
XFILLER_161_1272 VGND VGND VPWR VPWR sky130_fd_sc_hd__fill_1
XFILLER_126_1370 VPWR VGND VPWR VGND sky130_ef_sc_hd__decap_12
XPHY_EDGE_ROW_18_2_Left_450 VGND VGND VPWR VPWR sky130_fd_sc_hd__decap_3
XFILLER_204_1589 VGND VGND VPWR VPWR sky130_fd_sc_hd__decap_6
XFILLER_200_1409 VPWR VGND VPWR VGND sky130_ef_sc_hd__decap_12
XFILLER_167_393 VPWR VGND VPWR VGND sky130_ef_sc_hd__decap_12
XTAP_TAPCELL_ROW_124_2_3784 VGND VPWR sky130_fd_sc_hd__tapvpwrvgnd_1
XFILLER_35_1286 VPWR VGND VPWR VGND sky130_ef_sc_hd__decap_12
XFILLER_183_853 VPWR VGND VPWR VGND sky130_ef_sc_hd__decap_12
XTAP_TAPCELL_ROW_92_2_3573 VGND VPWR sky130_fd_sc_hd__tapvpwrvgnd_1
XFILLER_6_521 VGND VGND VPWR VPWR sky130_fd_sc_hd__decap_8
XFILLER_41_93 VPWR VGND VPWR VGND sky130_ef_sc_hd__decap_12
XFILLER_183_897 VPWR VGND VPWR VGND sky130_ef_sc_hd__decap_12
XFILLER_182_363 VGND VGND VPWR VPWR sky130_fd_sc_hd__fill_1
XFILLER_170_525 VGND VGND VPWR VPWR sky130_fd_sc_hd__decap_6
XFILLER_157_93 VPWR VGND VPWR VGND sky130_ef_sc_hd__decap_12
XFILLER_170_569 VPWR VGND VPWR VGND sky130_ef_sc_hd__decap_12
XFILLER_211_1505 VGND VGND VPWR VPWR sky130_fd_sc_hd__decap_6
XFILLER_173_81 VPWR VGND VPWR VGND sky130_ef_sc_hd__decap_12
XFILLER_133_1330 VPWR VGND VPWR VGND sky130_ef_sc_hd__decap_12
XANTENNA__469__C _191_ VGND VGND VPWR VPWR sky130_fd_sc_hd__diode_2
XFILLER_1_281 VPWR VGND VPWR VGND sky130_ef_sc_hd__decap_12
XFILLER_46_1382 VPWR VGND VPWR VGND sky130_ef_sc_hd__decap_12
XFILLER_211_1549 VPWR VGND VPWR VGND sky130_ef_sc_hd__decap_12
XTAP_TAPCELL_ROW_207_2652 VGND VPWR sky130_fd_sc_hd__tapvpwrvgnd_1
XTAP_TAPCELL_ROW_207_2641 VGND VPWR sky130_fd_sc_hd__tapvpwrvgnd_1
XTAP_TAPCELL_ROW_207_2630 VGND VPWR sky130_fd_sc_hd__tapvpwrvgnd_1
XFILLER_2_65 VPWR VGND VPWR VGND sky130_ef_sc_hd__decap_12
XFILLER_42_1246 VPWR VGND VPWR VGND sky130_ef_sc_hd__decap_12
XTAP_TAPCELL_ROW_203_2527 VGND VPWR sky130_fd_sc_hd__tapvpwrvgnd_1
XTAP_TAPCELL_ROW_203_2516 VGND VPWR sky130_fd_sc_hd__tapvpwrvgnd_1
XFILLER_209_1401 VPWR VGND VPWR VGND sky130_ef_sc_hd__decap_12
XTAP_TAPCELL_ROW_203_2538 VGND VPWR sky130_fd_sc_hd__tapvpwrvgnd_1
XTAP_TAPCELL_ROW_199_2420 VGND VPWR sky130_fd_sc_hd__tapvpwrvgnd_1
XFILLER_212_209 VPWR VGND VPWR VGND sky130_ef_sc_hd__decap_12
XTAP_TAPCELL_ROW_195_2306 VGND VPWR sky130_fd_sc_hd__tapvpwrvgnd_1
XFILLER_205_261 VPWR VGND VPWR VGND sky130_ef_sc_hd__decap_12
XFILLER_178_625 VPWR VGND VPWR VGND sky130_ef_sc_hd__decap_12
XFILLER_166_1161 VPWR VGND VPWR VGND sky130_ef_sc_hd__decap_12
XPHY_EDGE_ROW_29_2_Right_86 VGND VGND VPWR VPWR sky130_fd_sc_hd__decap_3
XFILLER_178_669 VPWR VGND VPWR VGND sky130_ef_sc_hd__decap_12
XFILLER_177_113 VPWR VGND VPWR VGND sky130_ef_sc_hd__decap_12
XFILLER_193_617 VPWR VGND VPWR VGND sky130_ef_sc_hd__decap_12
XFILLER_144_1470 VPWR VGND VPWR VGND sky130_ef_sc_hd__decap_12
XFILLER_109_1590 VPWR VGND VPWR VGND sky130_ef_sc_hd__decap_12
XFILLER_105_1410 VPWR VGND VPWR VGND sky130_ef_sc_hd__decap_12
XFILLER_18_1462 VGND VGND VPWR VPWR sky130_fd_sc_hd__decap_6
XFILLER_53_1342 VPWR VGND VPWR VGND sky130_ef_sc_hd__decap_12
XFILLER_203_1033 VPWR VGND VPWR VGND sky130_ef_sc_hd__decap_12
XFILLER_179_1511 VGND VGND VPWR VPWR sky130_fd_sc_hd__fill_1
XFILLER_105_1454 VPWR VGND VPWR VGND sky130_ef_sc_hd__decap_12
XFILLER_14_1326 VPWR VGND VPWR VGND sky130_ef_sc_hd__decap_12
XTAP_TAPCELL_ROW_13_2_3064 VGND VPWR sky130_fd_sc_hd__tapvpwrvgnd_1
XFILLER_53_1386 VPWR VGND VPWR VGND sky130_ef_sc_hd__decap_12
XFILLER_203_1077 VPWR VGND VPWR VGND sky130_ef_sc_hd__decap_12
XFILLER_140_1356 VGND VGND VPWR VPWR sky130_fd_sc_hd__fill_1
XFILLER_105_1498 VPWR VGND VPWR VGND sky130_ef_sc_hd__decap_12
XFILLER_88_1438 VPWR VGND VPWR VGND sky130_ef_sc_hd__decap_12
XFILLER_173_385 VGND VGND VPWR VPWR sky130_fd_sc_hd__decap_6
Xoutput100 net100 VGND VGND VPWR VPWR func_rdata[1] sky130_fd_sc_hd__buf_2
Xoutput111 net111 VGND VGND VPWR VPWR func_rdata[2] sky130_fd_sc_hd__buf_2
XFILLER_216_1427 VGND VGND VPWR VPWR sky130_fd_sc_hd__fill_1
XFILLER_173_1121 VPWR VGND VPWR VGND sky130_ef_sc_hd__decap_12
XFILLER_101_113 VPWR VGND VPWR VGND sky130_ef_sc_hd__decap_12
XANTENNA__570__CLK clknet_3_1_0_clk VGND VGND VPWR VPWR sky130_fd_sc_hd__diode_2
XFILLER_116_1550 VPWR VGND VPWR VGND sky130_ef_sc_hd__decap_12
XFILLER_64_1482 VPWR VGND VPWR VGND sky130_ef_sc_hd__decap_12
XFILLER_5_1505 VGND VGND VPWR VPWR sky130_fd_sc_hd__decap_6
XFILLER_25_1422 VPWR VGND VPWR VGND sky130_ef_sc_hd__decap_12
XFILLER_60_1302 VPWR VGND VPWR VGND sky130_ef_sc_hd__decap_12
XFILLER_214_1173 VPWR VGND VPWR VGND sky130_ef_sc_hd__decap_12
XTAP_TAPCELL_ROW_165_1442 VGND VPWR sky130_fd_sc_hd__tapvpwrvgnd_1
XTAP_TAPCELL_ROW_165_1431 VGND VPWR sky130_fd_sc_hd__tapvpwrvgnd_1
XFILLER_116_1594 VGND VGND VPWR VPWR sky130_fd_sc_hd__decap_8
XFILLER_112_1414 VPWR VGND VPWR VGND sky130_ef_sc_hd__decap_12
XFILLER_99_1534 VPWR VGND VPWR VGND sky130_ef_sc_hd__decap_12
XFILLER_5_1549 VPWR VGND VPWR VGND sky130_ef_sc_hd__decap_12
XFILLER_25_1466 VPWR VGND VPWR VGND sky130_ef_sc_hd__decap_12
XFILLER_210_1037 VPWR VGND VPWR VGND sky130_ef_sc_hd__decap_12
XTAP_TAPCELL_ROW_165_1453 VGND VPWR sky130_fd_sc_hd__tapvpwrvgnd_1
XFILLER_151_1496 VGND VGND VPWR VPWR sky130_fd_sc_hd__fill_1
XPHY_EDGE_ROW_146_2_Left_578 VGND VGND VPWR VPWR sky130_fd_sc_hd__decap_3
XFILLER_99_1578 VPWR VGND VPWR VGND sky130_ef_sc_hd__decap_12
XPHY_EDGE_ROW_83_2_Left_515 VGND VGND VPWR VPWR sky130_fd_sc_hd__decap_3
XFILLER_58_1220 VPWR VGND VPWR VGND sky130_ef_sc_hd__decap_12
XFILLER_184_1261 VPWR VGND VPWR VGND sky130_ef_sc_hd__decap_12
XTAP_TAPCELL_ROW_178_1814 VGND VPWR sky130_fd_sc_hd__tapvpwrvgnd_1
XTAP_TAPCELL_ROW_178_1803 VGND VPWR sky130_fd_sc_hd__tapvpwrvgnd_1
XFILLER_102_77 VGND VGND VPWR VPWR sky130_fd_sc_hd__decap_6
XFILLER_62_15 VPWR VGND VPWR VGND sky130_ef_sc_hd__decap_12
XFILLER_200_905 VPWR VGND VPWR VGND sky130_ef_sc_hd__decap_12
XFILLER_197_945 VGND VGND VPWR VPWR sky130_fd_sc_hd__decap_6
XFILLER_196_433 VPWR VGND VPWR VGND sky130_ef_sc_hd__decap_12
XFILLER_180_1147 VGND VGND VPWR VPWR sky130_fd_sc_hd__fill_1
XTAP_TAPCELL_ROW_178_1825 VGND VPWR sky130_fd_sc_hd__tapvpwrvgnd_1
XFILLER_178_15 VPWR VGND VPWR VGND sky130_ef_sc_hd__decap_12
XFILLER_145_1256 VPWR VGND VPWR VGND sky130_ef_sc_hd__decap_12
XFILLER_200_949 VPWR VGND VPWR VGND sky130_ef_sc_hd__decap_12
XFILLER_197_989 VPWR VGND VPWR VGND sky130_ef_sc_hd__decap_12
XFILLER_196_477 VPWR VGND VPWR VGND sky130_ef_sc_hd__decap_12
XFILLER_123_1510 VPWR VGND VPWR VGND sky130_ef_sc_hd__decap_12
XTAP_TAPCELL_ROW_110_2_3692 VGND VPWR sky130_fd_sc_hd__tapvpwrvgnd_1
XTAP_TAPCELL_ROW_109_2_3686 VGND VPWR sky130_fd_sc_hd__tapvpwrvgnd_1
XFILLER_71_1442 VPWR VGND VPWR VGND sky130_ef_sc_hd__decap_12
XFILLER_36_1562 VPWR VGND VPWR VGND sky130_ef_sc_hd__decap_12
XFILLER_183_105 VGND VGND VPWR VPWR sky130_fd_sc_hd__decap_6
XFILLER_123_1554 VPWR VGND VPWR VGND sky130_ef_sc_hd__decap_12
XFILLER_32_1426 VPWR VGND VPWR VGND sky130_ef_sc_hd__decap_12
XFILLER_183_149 VPWR VGND VPWR VGND sky130_ef_sc_hd__decap_12
XFILLER_165_853 VPWR VGND VPWR VGND sky130_ef_sc_hd__decap_12
XFILLER_165_897 VPWR VGND VPWR VGND sky130_ef_sc_hd__decap_12
XFILLER_164_363 VGND VGND VPWR VPWR sky130_fd_sc_hd__fill_1
XFILLER_191_193 VPWR VGND VPWR VGND sky130_ef_sc_hd__decap_12
XFILLER_180_867 VGND VGND VPWR VPWR sky130_fd_sc_hd__fill_1
XFILLER_2_3 VPWR VGND VPWR VGND sky130_ef_sc_hd__decap_12
XTAP_TAPCELL_ROW_57_2_3351 VGND VPWR sky130_fd_sc_hd__tapvpwrvgnd_1
XFILLER_65_1268 VGND VGND VPWR VPWR sky130_fd_sc_hd__decap_4
XFILLER_191_1287 VGND VGND VPWR VPWR sky130_fd_sc_hd__fill_1
XFILLER_82_1582 VPWR VGND VPWR VGND sky130_ef_sc_hd__decap_12
XFILLER_43_1522 VPWR VGND VPWR VGND sky130_ef_sc_hd__decap_12
XFILLER_143_51 VGND VGND VPWR VPWR sky130_fd_sc_hd__decap_4
XFILLER_43_1566 VPWR VGND VPWR VGND sky130_ef_sc_hd__decap_12
XFILLER_4_1037 VPWR VGND VPWR VGND sky130_ef_sc_hd__decap_12
XTAP_TAPCELL_ROW_50_2_3305 VGND VPWR sky130_fd_sc_hd__tapvpwrvgnd_1
XFILLER_207_559 VGND VGND VPWR VPWR sky130_fd_sc_hd__fill_1
XPHY_EDGE_ROW_153_2_Right_210 VGND VGND VPWR VPWR sky130_fd_sc_hd__decap_3
XFILLER_203_721 VGND VGND VPWR VPWR sky130_fd_sc_hd__decap_6
XFILLER_188_923 VGND VGND VPWR VPWR sky130_fd_sc_hd__fill_1
XFILLER_167_1481 VPWR VGND VPWR VGND sky130_ef_sc_hd__decap_12
XFILLER_163_1301 VPWR VGND VPWR VGND sky130_ef_sc_hd__decap_12
XFILLER_203_765 VPWR VGND VPWR VGND sky130_ef_sc_hd__decap_12
XFILLER_199_293 VPWR VGND VPWR VGND sky130_ef_sc_hd__decap_12
XFILLER_163_1345 VPWR VGND VPWR VGND sky130_ef_sc_hd__decap_12
XFILLER_159_113 VPWR VGND VPWR VGND sky130_ef_sc_hd__decap_12
XFILLER_202_253 VPWR VGND VPWR VGND sky130_ef_sc_hd__decap_12
XFILLER_175_617 VPWR VGND VPWR VGND sky130_ef_sc_hd__decap_12
X_317_ net28 net143 net133 VGND VGND VPWR VPWR s_wdata\[24\] sky130_fd_sc_hd__a21o_1
XFILLER_15_1602 VGND VGND VPWR VPWR sky130_fd_sc_hd__decap_3
XFILLER_204_1353 VPWR VGND VPWR VGND sky130_ef_sc_hd__decap_12
Xinput13 func_wdata[10] VGND VGND VPWR VPWR net13 sky130_fd_sc_hd__clkbuf_1
XFILLER_50_1526 VPWR VGND VPWR VGND sky130_ef_sc_hd__decap_12
XFILLER_204_1397 VPWR VGND VPWR VGND sky130_ef_sc_hd__decap_12
XFILLER_200_1217 VPWR VGND VPWR VGND sky130_ef_sc_hd__decap_12
Xinput35 func_wdata[30] VGND VGND VPWR VPWR net35 sky130_fd_sc_hd__clkbuf_1
Xinput24 func_wdata[20] VGND VGND VPWR VPWR net24 sky130_fd_sc_hd__clkbuf_1
XFILLER_192_1029 VGND VGND VPWR VPWR sky130_fd_sc_hd__decap_6
XTAP_TAPCELL_ROW_188_2110 VGND VPWR sky130_fd_sc_hd__tapvpwrvgnd_1
XFILLER_170_333 VPWR VGND VPWR VGND sky130_ef_sc_hd__decap_12
XANTENNA__593__CLK clknet_3_3_0_clk VGND VGND VPWR VPWR sky130_fd_sc_hd__diode_2
XFILLER_174_1441 VPWR VGND VPWR VGND sky130_ef_sc_hd__decap_12
XFILLER_171_889 VGND VGND VPWR VPWR sky130_fd_sc_hd__decap_6
XFILLER_170_377 VPWR VGND VPWR VGND sky130_ef_sc_hd__decap_12
XTAP_TAPCELL_ROW_209_2703 VGND VPWR sky130_fd_sc_hd__tapvpwrvgnd_1
XFILLER_174_1485 VPWR VGND VPWR VGND sky130_ef_sc_hd__decap_12
XFILLER_35_3 VPWR VGND VPWR VGND sky130_ef_sc_hd__decap_12
XTAP_TAPCELL_ROW_27_1_1072 VGND VPWR sky130_fd_sc_hd__tapvpwrvgnd_1
XFILLER_215_1493 VPWR VGND VPWR VGND sky130_ef_sc_hd__decap_12
XFILLER_211_1313 VPWR VGND VPWR VGND sky130_ef_sc_hd__decap_12
XTAP_TAPCELL_ROW_146_2_3927 VGND VPWR sky130_fd_sc_hd__tapvpwrvgnd_1
XFILLER_211_1357 VPWR VGND VPWR VGND sky130_ef_sc_hd__decap_12
XTAP_TAPCELL_ROW_115_1_1248 VGND VPWR sky130_fd_sc_hd__tapvpwrvgnd_1
XFILLER_0_1413 VPWR VGND VPWR VGND sky130_ef_sc_hd__decap_12
XFILLER_213_529 VPWR VGND VPWR VGND sky130_ef_sc_hd__decap_12
XFILLER_209_1231 VGND VGND VPWR VPWR sky130_fd_sc_hd__fill_1
XFILLER_206_581 VGND VGND VPWR VPWR sky130_fd_sc_hd__decap_6
XFILLER_185_1581 VPWR VGND VPWR VGND sky130_ef_sc_hd__decap_12
XFILLER_181_1401 VPWR VGND VPWR VGND sky130_ef_sc_hd__decap_12
XFILLER_0_1457 VPWR VGND VPWR VGND sky130_ef_sc_hd__decap_12
XFILLER_179_945 VGND VGND VPWR VPWR sky130_fd_sc_hd__decap_6
XFILLER_178_433 VPWR VGND VPWR VGND sky130_ef_sc_hd__decap_12
XFILLER_179_989 VPWR VGND VPWR VGND sky130_ef_sc_hd__decap_12
XFILLER_178_477 VPWR VGND VPWR VGND sky130_ef_sc_hd__decap_12
XFILLER_32_29 VPWR VGND VPWR VGND sky130_ef_sc_hd__decap_12
XFILLER_194_937 VPWR VGND VPWR VGND sky130_ef_sc_hd__decap_12
XFILLER_165_105 VGND VGND VPWR VPWR sky130_fd_sc_hd__decap_6
XFILLER_148_29 VPWR VGND VPWR VGND sky130_ef_sc_hd__decap_12
XTAP_TAPCELL_ROW_82_1_1182 VGND VPWR sky130_fd_sc_hd__tapvpwrvgnd_1
XFILLER_18_1270 VPWR VGND VPWR VGND sky130_ef_sc_hd__decap_12
XFILLER_193_447 VGND VGND VPWR VPWR sky130_fd_sc_hd__fill_1
XFILLER_181_609 VGND VGND VPWR VPWR sky130_fd_sc_hd__decap_6
XFILLER_165_149 VPWR VGND VPWR VGND sky130_ef_sc_hd__decap_12
XFILLER_88_1246 VPWR VGND VPWR VGND sky130_ef_sc_hd__decap_12
XFILLER_173_193 VPWR VGND VPWR VGND sky130_ef_sc_hd__decap_12
XFILLER_192_1541 VPWR VGND VPWR VGND sky130_ef_sc_hd__decap_12
XFILLER_87_111 VGND VGND VPWR VPWR sky130_fd_sc_hd__fill_1
XTAP_TAPCELL_ROW_167_1504 VGND VPWR sky130_fd_sc_hd__tapvpwrvgnd_1
XFILLER_0_549 VGND VGND VPWR VPWR sky130_fd_sc_hd__decap_4
XFILLER_180_27 VGND VGND VPWR VPWR sky130_fd_sc_hd__fill_1
XFILLER_5_1313 VPWR VGND VPWR VGND sky130_ef_sc_hd__decap_12
XFILLER_216_301 VGND VGND VPWR VPWR sky130_fd_sc_hd__decap_6
XFILLER_169_1009 VPWR VGND VPWR VGND sky130_ef_sc_hd__decap_12
XFILLER_112_1244 VGND VGND VPWR VPWR sky130_fd_sc_hd__fill_1
XFILLER_99_1342 VPWR VGND VPWR VGND sky130_ef_sc_hd__decap_12
XFILLER_5_1357 VPWR VGND VPWR VGND sky130_ef_sc_hd__decap_12
XFILLER_25_1274 VPWR VGND VPWR VGND sky130_ef_sc_hd__decap_12
XTAP_TAPCELL_ROW_35_2_3207 VGND VPWR sky130_fd_sc_hd__tapvpwrvgnd_1
XFILLER_99_1386 VPWR VGND VPWR VGND sky130_ef_sc_hd__decap_12
XTAP_TAPCELL_ROW_4_899 VGND VPWR sky130_fd_sc_hd__tapvpwrvgnd_1
XFILLER_216_345 VPWR VGND VPWR VGND sky130_ef_sc_hd__decap_12
XFILLER_189_709 VPWR VGND VPWR VGND sky130_ef_sc_hd__decap_12
XTAP_TAPCELL_ROW_219_3010 VGND VPWR sky130_fd_sc_hd__tapvpwrvgnd_1
XFILLER_216_389 VPWR VGND VPWR VGND sky130_ef_sc_hd__decap_12
XFILLER_73_69 VPWR VGND VPWR VGND sky130_ef_sc_hd__decap_12
XFILLER_38_1602 VGND VGND VPWR VPWR sky130_fd_sc_hd__decap_3
XTAP_TAPCELL_ROW_219_3021 VGND VPWR sky130_fd_sc_hd__tapvpwrvgnd_1
XFILLER_189_69 VPWR VGND VPWR VGND sky130_ef_sc_hd__decap_12
XFILLER_184_1091 VGND VGND VPWR VPWR sky130_fd_sc_hd__fill_1
XFILLER_200_713 VPWR VGND VPWR VGND sky130_ef_sc_hd__decap_12
XFILLER_197_753 VPWR VGND VPWR VGND sky130_ef_sc_hd__decap_12
XFILLER_160_1518 VGND VGND VPWR VPWR sky130_fd_sc_hd__decap_6
XFILLER_200_757 VPWR VGND VPWR VGND sky130_ef_sc_hd__decap_12
XFILLER_197_797 VPWR VGND VPWR VGND sky130_ef_sc_hd__decap_12
XFILLER_36_1370 VPWR VGND VPWR VGND sky130_ef_sc_hd__decap_12
XFILLER_201_1537 VPWR VGND VPWR VGND sky130_ef_sc_hd__decap_12
XFILLER_184_469 VGND VGND VPWR VPWR sky130_fd_sc_hd__decap_6
XFILLER_71_1272 VGND VGND VPWR VPWR sky130_fd_sc_hd__fill_1
XFILLER_158_1414 VPWR VGND VPWR VGND sky130_ef_sc_hd__decap_12
XTAP_TAPCELL_ROW_139_2_3881 VGND VPWR sky130_fd_sc_hd__tapvpwrvgnd_1
XFILLER_123_1384 VGND VGND VPWR VPWR sky130_fd_sc_hd__fill_1
XFILLER_4_800 VGND VGND VPWR VPWR sky130_fd_sc_hd__decap_3
XFILLER_4_811 VGND VGND VPWR VPWR sky130_fd_sc_hd__fill_1
XFILLER_98_77 VGND VGND VPWR VPWR sky130_fd_sc_hd__decap_6
XANTENNA__436__B1_N net157 VGND VGND VPWR VPWR sky130_fd_sc_hd__diode_2
XFILLER_3_365 VGND VGND VPWR VPWR sky130_fd_sc_hd__fill_1
XPHY_EDGE_ROW_168_Left_387 VGND VGND VPWR VPWR sky130_fd_sc_hd__decap_3
XTAP_TAPCELL_ROW_132_2_3835 VGND VPWR sky130_fd_sc_hd__tapvpwrvgnd_1
XFILLER_154_83 VGND VGND VPWR VPWR sky130_fd_sc_hd__fill_1
XFILLER_130_1300 VGND VGND VPWR VPWR sky130_fd_sc_hd__fill_1
XFILLER_43_1330 VPWR VGND VPWR VGND sky130_ef_sc_hd__decap_12
XFILLER_208_813 VPWR VGND VPWR VGND sky130_ef_sc_hd__decap_12
XFILLER_93_125 VGND VGND VPWR VPWR sky130_fd_sc_hd__fill_2
XFILLER_78_1426 VPWR VGND VPWR VGND sky130_ef_sc_hd__decap_12
XFILLER_47_81 VPWR VGND VPWR VGND sky130_ef_sc_hd__decap_12
XPHY_EDGE_ROW_154_2_Right_211 VGND VGND VPWR VPWR sky130_fd_sc_hd__decap_3
XANTENNA_clkload5_A clknet_3_6_0_clk VGND VGND VPWR VPWR sky130_fd_sc_hd__diode_2
XTAP_TAPCELL_ROW_80_2_3500 VGND VPWR sky130_fd_sc_hd__tapvpwrvgnd_1
XPHY_EDGE_ROW_177_Left_396 VGND VGND VPWR VPWR sky130_fd_sc_hd__decap_3
XFILLER_203_573 VPWR VGND VPWR VGND sky130_ef_sc_hd__decap_12
XFILLER_198_1205 VPWR VGND VPWR VGND sky130_ef_sc_hd__decap_12
XFILLER_176_937 VPWR VGND VPWR VGND sky130_ef_sc_hd__decap_12
XFILLER_147_105 VGND VGND VPWR VPWR sky130_fd_sc_hd__decap_6
XFILLER_15_1410 VPWR VGND VPWR VGND sky130_ef_sc_hd__decap_12
XFILLER_19_1590 VPWR VGND VPWR VGND sky130_ef_sc_hd__decap_12
XFILLER_54_1470 VPWR VGND VPWR VGND sky130_ef_sc_hd__decap_12
XFILLER_204_1161 VPWR VGND VPWR VGND sky130_ef_sc_hd__decap_12
XFILLER_175_447 VGND VGND VPWR VPWR sky130_fd_sc_hd__fill_1
XFILLER_141_1440 VGND VGND VPWR VPWR sky130_fd_sc_hd__fill_1
XFILLER_106_1582 VPWR VGND VPWR VGND sky130_ef_sc_hd__decap_12
XFILLER_89_1522 VPWR VGND VPWR VGND sky130_ef_sc_hd__decap_12
XFILLER_8_53 VGND VGND VPWR VPWR sky130_fd_sc_hd__decap_6
XFILLER_15_1454 VPWR VGND VPWR VGND sky130_ef_sc_hd__decap_12
XFILLER_184_981 VPWR VGND VPWR VGND sky130_ef_sc_hd__decap_12
XFILLER_15_1498 VPWR VGND VPWR VGND sky130_ef_sc_hd__decap_12
XTAP_TAPCELL_ROW_28_2_3161 VGND VPWR sky130_fd_sc_hd__tapvpwrvgnd_1
XFILLER_50_1356 VGND VGND VPWR VPWR sky130_fd_sc_hd__fill_1
XFILLER_102_1468 VGND VGND VPWR VPWR sky130_fd_sc_hd__fill_1
XFILLER_89_1566 VPWR VGND VPWR VGND sky130_ef_sc_hd__decap_12
XFILLER_217_1511 VGND VGND VPWR VPWR sky130_fd_sc_hd__fill_1
XFILLER_171_653 VPWR VGND VPWR VGND sky130_ef_sc_hd__decap_12
XFILLER_170_141 VPWR VGND VPWR VGND sky130_ef_sc_hd__decap_12
XFILLER_171_697 VPWR VGND VPWR VGND sky130_ef_sc_hd__decap_12
XFILLER_135_1244 VPWR VGND VPWR VGND sky130_ef_sc_hd__decap_12
XFILLER_69_111 VGND VGND VPWR VPWR sky130_fd_sc_hd__fill_1
XTAP_TAPCELL_ROW_58_1_1133 VGND VPWR sky130_fd_sc_hd__tapvpwrvgnd_1
XTAP_TAPCELL_ROW_21_2_3115 VGND VPWR sky130_fd_sc_hd__tapvpwrvgnd_1
XFILLER_26_1550 VPWR VGND VPWR VGND sky130_ef_sc_hd__decap_12
XFILLER_214_53 VPWR VGND VPWR VGND sky130_ef_sc_hd__decap_12
XFILLER_211_1121 VPWR VGND VPWR VGND sky130_ef_sc_hd__decap_12
XFILLER_152_1580 VGND VGND VPWR VPWR sky130_fd_sc_hd__fill_1
XFILLER_22_1414 VPWR VGND VPWR VGND sky130_ef_sc_hd__decap_12
XFILLER_26_1594 VGND VGND VPWR VPWR sky130_fd_sc_hd__decap_8
XFILLER_214_97 VPWR VGND VPWR VGND sky130_ef_sc_hd__decap_12
XTAP_TAPCELL_ROW_1_825 VGND VPWR sky130_fd_sc_hd__tapvpwrvgnd_1
XTAP_TAPCELL_ROW_1_814 VGND VPWR sky130_fd_sc_hd__tapvpwrvgnd_1
XFILLER_61_1496 VGND VGND VPWR VPWR sky130_fd_sc_hd__fill_1
XFILLER_214_805 VGND VGND VPWR VPWR sky130_fd_sc_hd__decap_6
XTAP_TAPCELL_ROW_146_1_1309 VGND VPWR sky130_fd_sc_hd__tapvpwrvgnd_1
XFILLER_96_1526 VPWR VGND VPWR VGND sky130_ef_sc_hd__decap_12
XFILLER_214_849 VPWR VGND VPWR VGND sky130_ef_sc_hd__decap_12
XFILLER_213_337 VPWR VGND VPWR VGND sky130_ef_sc_hd__decap_12
XFILLER_194_701 VPWR VGND VPWR VGND sky130_ef_sc_hd__decap_12
XFILLER_181_1231 VGND VGND VPWR VPWR sky130_fd_sc_hd__fill_1
XFILLER_179_753 VPWR VGND VPWR VGND sky130_ef_sc_hd__decap_12
XFILLER_159_39 VPWR VGND VPWR VGND sky130_ef_sc_hd__decap_12
XFILLER_94_1294 VGND VGND VPWR VPWR sky130_fd_sc_hd__decap_6
XFILLER_43_39 VPWR VGND VPWR VGND sky130_ef_sc_hd__decap_12
XFILLER_55_1256 VPWR VGND VPWR VGND sky130_ef_sc_hd__decap_12
XFILLER_179_797 VPWR VGND VPWR VGND sky130_ef_sc_hd__decap_12
XFILLER_33_1510 VPWR VGND VPWR VGND sky130_ef_sc_hd__decap_12
XFILLER_33_1554 VPWR VGND VPWR VGND sky130_ef_sc_hd__decap_12
XFILLER_181_417 VPWR VGND VPWR VGND sky130_ef_sc_hd__decap_12
XFILLER_166_469 VGND VGND VPWR VPWR sky130_fd_sc_hd__decap_6
XFILLER_120_1524 VGND VGND VPWR VPWR sky130_fd_sc_hd__fill_1
XFILLER_175_27 VPWR VGND VPWR VGND sky130_ef_sc_hd__decap_12
XFILLER_190_973 VGND VGND VPWR VPWR sky130_fd_sc_hd__decap_6
XFILLER_175_1057 VGND VGND VPWR VPWR sky130_fd_sc_hd__decap_6
XFILLER_108_65 VPWR VGND VPWR VGND sky130_ef_sc_hd__decap_12
XFILLER_1_814 VPWR VGND VPWR VGND sky130_ef_sc_hd__decap_12
XFILLER_192_1371 VGND VGND VPWR VPWR sky130_fd_sc_hd__fill_1
XFILLER_191_15 VPWR VGND VPWR VGND sky130_ef_sc_hd__decap_12
XFILLER_153_1322 VGND VGND VPWR VPWR sky130_fd_sc_hd__decap_6
XTAP_TAPCELL_ROW_117_2_3737 VGND VPWR sky130_fd_sc_hd__tapvpwrvgnd_1
XFILLER_1_858 VPWR VGND VPWR VGND sky130_ef_sc_hd__decap_12
XFILLER_0_313 VGND VGND VPWR VPWR sky130_fd_sc_hd__fill_2
XFILLER_153_1366 VPWR VGND VPWR VGND sky130_ef_sc_hd__decap_12
XANTENNA__493__B1 net135 VGND VGND VPWR VPWR sky130_fd_sc_hd__diode_2
XFILLER_208_109 VPWR VGND VPWR VGND sky130_ef_sc_hd__decap_12
XFILLER_124_53 VPWR VGND VPWR VGND sky130_ef_sc_hd__decap_12
XFILLER_75_125 VGND VGND VPWR VPWR sky130_fd_sc_hd__fill_2
XFILLER_5_1121 VPWR VGND VPWR VGND sky130_ef_sc_hd__decap_12
XFILLER_188_1429 VPWR VGND VPWR VGND sky130_ef_sc_hd__decap_12
XFILLER_187_3 VPWR VGND VPWR VGND sky130_ef_sc_hd__decap_12
XFILLER_124_97 VPWR VGND VPWR VGND sky130_ef_sc_hd__decap_12
XFILLER_1_1007 VGND VGND VPWR VPWR sky130_fd_sc_hd__fill_1
XFILLER_217_665 VGND VGND VPWR VPWR sky130_fd_sc_hd__decap_6
XTAP_TAPCELL_ROW_65_2_3402 VGND VPWR sky130_fd_sc_hd__tapvpwrvgnd_1
X_582_ clknet_3_2_0_clk _016_ VGND VGND VPWR VPWR u_ctrl.elem_idx\[1\] sky130_fd_sc_hd__dfxtp_2
XFILLER_216_153 VPWR VGND VPWR VGND sky130_ef_sc_hd__decap_12
XFILLER_189_517 VPWR VGND VPWR VGND sky130_ef_sc_hd__decap_12
XFILLER_140_41 VPWR VGND VPWR VGND sky130_ef_sc_hd__decap_12
XFILLER_216_197 VPWR VGND VPWR VGND sky130_ef_sc_hd__decap_12
XFILLER_186_1197 VGND VGND VPWR VPWR sky130_fd_sc_hd__decap_6
XFILLER_182_1017 VPWR VGND VPWR VGND sky130_ef_sc_hd__decap_12
XFILLER_140_85 VPWR VGND VPWR VGND sky130_ef_sc_hd__decap_12
XFILLER_197_561 VPWR VGND VPWR VGND sky130_ef_sc_hd__decap_12
XFILLER_160_1326 VPWR VGND VPWR VGND sky130_ef_sc_hd__decap_12
XFILLER_129_105 VGND VGND VPWR VPWR sky130_fd_sc_hd__decap_6
XFILLER_73_1378 VGND VGND VPWR VPWR sky130_fd_sc_hd__decap_6
XFILLER_205_1481 VPWR VGND VPWR VGND sky130_ef_sc_hd__decap_12
XFILLER_201_1301 VPWR VGND VPWR VGND sky130_ef_sc_hd__decap_12
XFILLER_199_1525 VPWR VGND VPWR VGND sky130_ef_sc_hd__decap_12
XFILLER_184_233 VPWR VGND VPWR VGND sky130_ef_sc_hd__decap_12
XFILLER_201_1345 VPWR VGND VPWR VGND sky130_ef_sc_hd__decap_12
XFILLER_200_587 VGND VGND VPWR VPWR sky130_fd_sc_hd__fill_1
XFILLER_199_1569 VPWR VGND VPWR VGND sky130_ef_sc_hd__decap_12
XFILLER_184_277 VPWR VGND VPWR VGND sky130_ef_sc_hd__decap_12
XFILLER_166_981 VPWR VGND VPWR VGND sky130_ef_sc_hd__decap_12
XFILLER_193_1113 VGND VGND VPWR VPWR sky130_fd_sc_hd__decap_6
XFILLER_181_951 VGND VGND VPWR VPWR sky130_fd_sc_hd__fill_1
XFILLER_158_1244 VGND VGND VPWR VPWR sky130_fd_sc_hd__fill_1
XFILLER_193_1157 VPWR VGND VPWR VGND sky130_ef_sc_hd__decap_12
XTAP_TAPCELL_ROW_139_1_1296 VGND VPWR sky130_fd_sc_hd__tapvpwrvgnd_1
XFILLER_101_1490 VGND VGND VPWR VPWR sky130_fd_sc_hd__decap_6
XFILLER_165_93 VPWR VGND VPWR VGND sky130_ef_sc_hd__decap_12
XFILLER_171_1455 VGND VGND VPWR VPWR sky130_fd_sc_hd__fill_1
XFILLER_132_1406 VGND VGND VPWR VPWR sky130_fd_sc_hd__decap_6
XFILLER_80_1338 VPWR VGND VPWR VGND sky130_ef_sc_hd__decap_12
XANTENNA__631__CLK clknet_3_1_0_clk VGND VGND VPWR VPWR sky130_fd_sc_hd__diode_2
XPHY_EDGE_ROW_38_2_Right_95 VGND VGND VPWR VPWR sky130_fd_sc_hd__decap_3
XFILLER_212_1441 VPWR VGND VPWR VGND sky130_ef_sc_hd__decap_12
Xhold2 net59 VGND VGND VPWR VPWR net172 sky130_fd_sc_hd__dlygate4sd3_1
XFILLER_181_81 VPWR VGND VPWR VGND sky130_ef_sc_hd__decap_12
XFILLER_212_1485 VPWR VGND VPWR VGND sky130_ef_sc_hd__decap_12
XFILLER_208_643 VGND VGND VPWR VPWR sky130_fd_sc_hd__fill_1
XPHY_EDGE_ROW_185_Left_404 VGND VGND VPWR VPWR sky130_fd_sc_hd__decap_3
XPHY_EDGE_ROW_155_2_Right_212 VGND VGND VPWR VPWR sky130_fd_sc_hd__decap_3
XANTENNA__539__A1 net151 VGND VGND VPWR VPWR sky130_fd_sc_hd__diode_2
XFILLER_210_307 VGND VGND VPWR VPWR sky130_fd_sc_hd__fill_1
XFILLER_91_1434 VGND VGND VPWR VPWR sky130_fd_sc_hd__decap_6
Xu_sram.u_mem_162 VGND VGND VPWR VPWR u_sram.u_mem_162/HI net162 sky130_fd_sc_hd__conb_1
XFILLER_204_893 VPWR VGND VPWR VGND sky130_ef_sc_hd__decap_12
XFILLER_200_77 VGND VGND VPWR VPWR sky130_fd_sc_hd__decap_6
XFILLER_182_1595 VGND VGND VPWR VPWR sky130_fd_sc_hd__fill_1
XFILLER_176_701 VPWR VGND VPWR VGND sky130_ef_sc_hd__decap_12
XFILLER_143_1546 VGND VGND VPWR VPWR sky130_fd_sc_hd__decap_6
XFILLER_91_1478 VPWR VGND VPWR VGND sky130_ef_sc_hd__decap_12
XFILLER_198_1035 VGND VGND VPWR VPWR sky130_fd_sc_hd__fill_1
XFILLER_163_417 VGND VGND VPWR VPWR sky130_fd_sc_hd__decap_3
XFILLER_89_1330 VPWR VGND VPWR VGND sky130_ef_sc_hd__decap_12
XPHY_EDGE_ROW_155_2_Left_587 VGND VGND VPWR VPWR sky130_fd_sc_hd__decap_3
XFILLER_102_1232 VPWR VGND VPWR VGND sky130_ef_sc_hd__decap_12
XPHY_EDGE_ROW_194_Left_413 VGND VGND VPWR VPWR sky130_fd_sc_hd__decap_3
XFILLER_172_973 VGND VGND VPWR VPWR sky130_fd_sc_hd__decap_6
XTAP_TAPCELL_ROW_91_2_3569 VGND VPWR sky130_fd_sc_hd__tapvpwrvgnd_1
XFILLER_171_461 VPWR VGND VPWR VGND sky130_ef_sc_hd__decap_12
XFILLER_137_1328 VGND VGND VPWR VPWR sky130_fd_sc_hd__fill_1
XTAP_TAPCELL_ROW_103_2_3645 VGND VPWR sky130_fd_sc_hd__tapvpwrvgnd_1
XPHY_EDGE_ROW_92_2_Left_524 VGND VGND VPWR VPWR sky130_fd_sc_hd__decap_3
XFILLER_150_1506 VPWR VGND VPWR VGND sky130_ef_sc_hd__decap_12
XFILLER_6_1441 VPWR VGND VPWR VGND sky130_ef_sc_hd__decap_12
XPHY_EDGE_ROW_12_1_Left_231 VGND VGND VPWR VPWR sky130_fd_sc_hd__decap_3
XFILLER_57_125 VGND VGND VPWR VPWR sky130_fd_sc_hd__fill_2
XTAP_TAPCELL_ROW_51_2_3310 VGND VPWR sky130_fd_sc_hd__tapvpwrvgnd_1
XFILLER_6_1485 VPWR VGND VPWR VGND sky130_ef_sc_hd__decap_12
XFILLER_22_1244 VGND VGND VPWR VPWR sky130_fd_sc_hd__fill_1
XFILLER_214_613 VPWR VGND VPWR VGND sky130_ef_sc_hd__decap_12
XTAP_TAPCELL_ROW_181_1898 VGND VPWR sky130_fd_sc_hd__tapvpwrvgnd_1
XTAP_TAPCELL_ROW_181_1887 VGND VPWR sky130_fd_sc_hd__tapvpwrvgnd_1
XFILLER_96_1356 VGND VGND VPWR VPWR sky130_fd_sc_hd__fill_1
XFILLER_214_657 VPWR VGND VPWR VGND sky130_ef_sc_hd__decap_12
XFILLER_207_1009 VPWR VGND VPWR VGND sky130_ef_sc_hd__decap_12
XFILLER_183_1337 VGND VGND VPWR VPWR sky130_fd_sc_hd__decap_6
XFILLER_148_1468 VGND VGND VPWR VPWR sky130_fd_sc_hd__fill_1
XFILLER_213_167 VGND VGND VPWR VPWR sky130_fd_sc_hd__fill_1
XFILLER_161_1602 VGND VGND VPWR VPWR sky130_fd_sc_hd__decap_3
XFILLER_201_329 VGND VGND VPWR VPWR sky130_fd_sc_hd__decap_6
XFILLER_179_561 VPWR VGND VPWR VGND sky130_ef_sc_hd__decap_12
XFILLER_110_77 VGND VGND VPWR VPWR sky130_fd_sc_hd__decap_6
XFILLER_70_1518 VGND VGND VPWR VPWR sky130_fd_sc_hd__decap_6
XFILLER_70_15 VPWR VGND VPWR VGND sky130_ef_sc_hd__decap_12
XFILLER_194_531 VGND VGND VPWR VPWR sky130_fd_sc_hd__fill_1
XFILLER_186_15 VPWR VGND VPWR VGND sky130_ef_sc_hd__decap_12
XFILLER_166_233 VPWR VGND VPWR VGND sky130_ef_sc_hd__decap_12
XFILLER_166_277 VPWR VGND VPWR VGND sky130_ef_sc_hd__decap_12
XFILLER_6_917 VGND VGND VPWR VPWR sky130_fd_sc_hd__decap_6
XFILLER_182_737 VPWR VGND VPWR VGND sky130_ef_sc_hd__decap_12
XFILLER_181_225 VPWR VGND VPWR VGND sky130_ef_sc_hd__decap_12
XFILLER_177_1119 VGND VGND VPWR VPWR sky130_fd_sc_hd__fill_1
XFILLER_68_1414 VPWR VGND VPWR VGND sky130_ef_sc_hd__decap_12
XFILLER_33_1384 VGND VGND VPWR VPWR sky130_fd_sc_hd__fill_1
XFILLER_218_1105 VPWR VGND VPWR VGND sky130_ef_sc_hd__decap_12
XFILLER_5_449 VPWR VGND VPWR VGND sky130_ef_sc_hd__decap_12
XFILLER_194_1477 VGND VGND VPWR VPWR sky130_fd_sc_hd__decap_6
XFILLER_190_781 VPWR VGND VPWR VGND sky130_ef_sc_hd__decap_12
XFILLER_102_3 VPWR VGND VPWR VGND sky130_ef_sc_hd__decap_12
XFILLER_79_57 VPWR VGND VPWR VGND sky130_ef_sc_hd__decap_12
XFILLER_218_1149 VPWR VGND VPWR VGND sky130_ef_sc_hd__decap_12
XFILLER_1_666 VGND VGND VPWR VPWR sky130_fd_sc_hd__fill_2
XFILLER_7_1205 VPWR VGND VPWR VGND sky130_ef_sc_hd__decap_12
XTAP_TAPCELL_ROW_41_1_1100 VGND VPWR sky130_fd_sc_hd__tapvpwrvgnd_1
XTAP_TAPCELL_ROW_147_2_3932 VGND VPWR sky130_fd_sc_hd__tapvpwrvgnd_1
XFILLER_118_1294 VGND VGND VPWR VPWR sky130_fd_sc_hd__decap_6
XFILLER_209_429 VPWR VGND VPWR VGND sky130_ef_sc_hd__decap_12
XANTENNA_input22_A func_wdata[19] VGND VGND VPWR VPWR sky130_fd_sc_hd__diode_2
XFILLER_40_1300 VGND VGND VPWR VPWR sky130_fd_sc_hd__fill_1
XFILLER_188_1259 VGND VGND VPWR VPWR sky130_fd_sc_hd__fill_1
XFILLER_151_51 VGND VGND VPWR VPWR sky130_fd_sc_hd__decap_4
XFILLER_79_1510 VPWR VGND VPWR VGND sky130_ef_sc_hd__decap_12
X_634_ clknet_3_3_0_clk _068_ VGND VGND VPWR VPWR u_ctrl.cmp_exp\[0\] sky130_fd_sc_hd__dfxtp_1
XFILLER_217_473 VPWR VGND VPWR VGND sky130_ef_sc_hd__decap_12
XFILLER_79_1554 VPWR VGND VPWR VGND sky130_ef_sc_hd__decap_12
X_565_ u_ctrl.state\[1\] _089_ _075_ net157 VGND VGND VPWR VPWR _067_ sky130_fd_sc_hd__and4bb_1
X_496_ net178 net125 VGND VGND VPWR VPWR _222_ sky130_fd_sc_hd__or2_1
XFILLER_204_189 VGND VGND VPWR VPWR sky130_fd_sc_hd__decap_6
XFILLER_198_881 VPWR VGND VPWR VGND sky130_ef_sc_hd__decap_12
XFILLER_125_1232 VPWR VGND VPWR VGND sky130_ef_sc_hd__decap_12
XFILLER_201_841 VPWR VGND VPWR VGND sky130_ef_sc_hd__decap_12
XFILLER_197_391 VGND VGND VPWR VPWR sky130_fd_sc_hd__fill_1
XPHY_EDGE_ROW_88_1_Left_307 VGND VGND VPWR VPWR sky130_fd_sc_hd__decap_3
XTAP_TAPCELL_ROW_191_2172 VGND VPWR sky130_fd_sc_hd__tapvpwrvgnd_1
XFILLER_185_553 VGND VGND VPWR VPWR sky130_fd_sc_hd__decap_6
XFILLER_125_1298 VPWR VGND VPWR VGND sky130_ef_sc_hd__decap_12
XFILLER_16_1582 VPWR VGND VPWR VGND sky130_ef_sc_hd__decap_12
XFILLER_51_1440 VGND VGND VPWR VPWR sky130_fd_sc_hd__fill_1
XFILLER_199_1399 VGND VGND VPWR VPWR sky130_fd_sc_hd__fill_1
XTAP_TAPCELL_ROW_191_2194 VGND VPWR sky130_fd_sc_hd__tapvpwrvgnd_1
XTAP_TAPCELL_ROW_191_2183 VGND VPWR sky130_fd_sc_hd__tapvpwrvgnd_1
XFILLER_185_597 VPWR VGND VPWR VGND sky130_ef_sc_hd__decap_12
XPHY_EDGE_ROW_140_1_Left_359 VGND VGND VPWR VPWR sky130_fd_sc_hd__decap_3
XFILLER_103_1552 VGND VGND VPWR VPWR sky130_fd_sc_hd__fill_1
XTAP_TAPCELL_ROW_216_2890 VGND VPWR sky130_fd_sc_hd__tapvpwrvgnd_1
XFILLER_201_1175 VGND VGND VPWR VPWR sky130_fd_sc_hd__fill_1
XFILLER_5_950 VGND VGND VPWR VPWR sky130_fd_sc_hd__fill_2
XFILLER_12_1468 VGND VGND VPWR VPWR sky130_fd_sc_hd__fill_1
XTAP_TAPCELL_ROW_212_2787 VGND VPWR sky130_fd_sc_hd__tapvpwrvgnd_1
XTAP_TAPCELL_ROW_212_2776 VGND VPWR sky130_fd_sc_hd__tapvpwrvgnd_1
XFILLER_136_1350 VGND VGND VPWR VPWR sky130_fd_sc_hd__decap_6
XFILLER_84_1282 VPWR VGND VPWR VGND sky130_ef_sc_hd__decap_12
XTAP_TAPCELL_ROW_75_1_1168 VGND VPWR sky130_fd_sc_hd__tapvpwrvgnd_1
XFILLER_45_1244 VPWR VGND VPWR VGND sky130_ef_sc_hd__decap_12
XFILLER_136_1394 VPWR VGND VPWR VGND sky130_ef_sc_hd__decap_12
XFILLER_39_125 VGND VGND VPWR VPWR sky130_fd_sc_hd__fill_2
XFILLER_132_1258 VPWR VGND VPWR VGND sky130_ef_sc_hd__decap_12
XTAP_TAPCELL_ROW_36_2_3212 VGND VPWR sky130_fd_sc_hd__tapvpwrvgnd_1
XFILLER_62_1580 VGND VGND VPWR VPWR sky130_fd_sc_hd__fill_1
XFILLER_165_1001 VGND VGND VPWR VPWR sky130_fd_sc_hd__decap_6
XFILLER_208_1329 VPWR VGND VPWR VGND sky130_ef_sc_hd__decap_12
XFILLER_165_1045 VPWR VGND VPWR VGND sky130_ef_sc_hd__decap_12
XPHY_EDGE_ROW_156_2_Right_213 VGND VGND VPWR VPWR sky130_fd_sc_hd__decap_3
XFILLER_91_1220 VPWR VGND VPWR VGND sky130_ef_sc_hd__decap_12
XFILLER_1_1393 VGND VGND VPWR VPWR sky130_fd_sc_hd__decap_6
XFILLER_195_317 VPWR VGND VPWR VGND sky130_ef_sc_hd__decap_12
XFILLER_165_1089 VPWR VGND VPWR VGND sky130_ef_sc_hd__decap_12
XFILLER_147_1490 VGND VGND VPWR VPWR sky130_fd_sc_hd__decap_6
XFILLER_143_1310 VPWR VGND VPWR VGND sky130_ef_sc_hd__decap_12
XFILLER_176_531 VGND VGND VPWR VPWR sky130_fd_sc_hd__fill_1
XFILLER_143_1354 VPWR VGND VPWR VGND sky130_ef_sc_hd__decap_12
XFILLER_91_1286 VPWR VGND VPWR VGND sky130_ef_sc_hd__decap_12
XFILLER_143_1398 VPWR VGND VPWR VGND sky130_ef_sc_hd__decap_12
XFILLER_104_1338 VPWR VGND VPWR VGND sky130_ef_sc_hd__decap_12
XTAP_TAPCELL_ROW_8_1_3025 VGND VPWR sky130_fd_sc_hd__tapvpwrvgnd_1
XFILLER_164_737 VPWR VGND VPWR VGND sky130_ef_sc_hd__decap_12
XFILLER_163_225 VPWR VGND VPWR VGND sky130_ef_sc_hd__decap_12
XFILLER_30_1524 VGND VGND VPWR VPWR sky130_fd_sc_hd__fill_1
XFILLER_40_29 VPWR VGND VPWR VGND sky130_ef_sc_hd__decap_12
XTAP_TAPCELL_ROW_174_1691 VGND VPWR sky130_fd_sc_hd__tapvpwrvgnd_1
XFILLER_156_29 VPWR VGND VPWR VGND sky130_ef_sc_hd__decap_12
XFILLER_219_1425 VGND VGND VPWR VPWR sky130_fd_sc_hd__decap_3
XFILLER_176_1141 VGND VGND VPWR VPWR sky130_fd_sc_hd__decap_6
XFILLER_172_781 VPWR VGND VPWR VGND sky130_ef_sc_hd__decap_12
XTAP_TAPCELL_ROW_170_1577 VGND VPWR sky130_fd_sc_hd__tapvpwrvgnd_1
XTAP_TAPCELL_ROW_153_2_3975 VGND VPWR sky130_fd_sc_hd__tapvpwrvgnd_1
XFILLER_219_1469 VPWR VGND VPWR VGND sky130_ef_sc_hd__decap_12
XFILLER_176_1185 VPWR VGND VPWR VGND sky130_ef_sc_hd__decap_12
XFILLER_172_1005 VPWR VGND VPWR VGND sky130_ef_sc_hd__decap_12
XTAP_TAPCELL_ROW_170_1599 VGND VPWR sky130_fd_sc_hd__tapvpwrvgnd_1
XTAP_TAPCELL_ROW_170_1588 VGND VPWR sky130_fd_sc_hd__tapvpwrvgnd_1
XFILLER_131_111 VGND VGND VPWR VPWR sky130_fd_sc_hd__fill_1
XFILLER_172_1049 VPWR VGND VPWR VGND sky130_ef_sc_hd__decap_12
XFILLER_154_1450 VPWR VGND VPWR VGND sky130_ef_sc_hd__decap_12
XTAP_TAPCELL_ROW_133_2_3840 VGND VPWR sky130_fd_sc_hd__tapvpwrvgnd_1
XFILLER_63_1322 VGND VGND VPWR VPWR sky130_fd_sc_hd__decap_6
XFILLER_154_1494 VPWR VGND VPWR VGND sky130_ef_sc_hd__decap_12
XFILLER_150_1314 VPWR VGND VPWR VGND sky130_ef_sc_hd__decap_12
XFILLER_115_1434 VGND VGND VPWR VPWR sky130_fd_sc_hd__decap_6
XFILLER_63_1366 VPWR VGND VPWR VGND sky130_ef_sc_hd__decap_12
XFILLER_213_1057 VGND VGND VPWR VPWR sky130_fd_sc_hd__decap_6
XFILLER_189_1513 VPWR VGND VPWR VGND sky130_ef_sc_hd__decap_12
XTAP_TAPCELL_ROW_183_1949 VGND VPWR sky130_fd_sc_hd__tapvpwrvgnd_1
XFILLER_150_1358 VPWR VGND VPWR VGND sky130_ef_sc_hd__decap_12
XFILLER_115_1478 VPWR VGND VPWR VGND sky130_ef_sc_hd__decap_12
XFILLER_105_55 VGND VGND VPWR VPWR sky130_fd_sc_hd__fill_1
XFILLER_65_15 VPWR VGND VPWR VGND sky130_ef_sc_hd__decap_12
XFILLER_215_933 VPWR VGND VPWR VGND sky130_ef_sc_hd__decap_12
XFILLER_214_421 VPWR VGND VPWR VGND sky130_ef_sc_hd__decap_12
XFILLER_187_1281 VGND VGND VPWR VPWR sky130_fd_sc_hd__decap_6
XFILLER_183_1101 VPWR VGND VPWR VGND sky130_ef_sc_hd__decap_12
XFILLER_148_1232 VPWR VGND VPWR VGND sky130_ef_sc_hd__decap_12
XFILLER_60_109 VPWR VGND VPWR VGND sky130_ef_sc_hd__decap_12
XFILLER_215_977 VPWR VGND VPWR VGND sky130_ef_sc_hd__decap_12
XFILLER_198_133 VGND VGND VPWR VPWR sky130_fd_sc_hd__decap_6
XFILLER_183_1145 VPWR VGND VPWR VGND sky130_ef_sc_hd__decap_12
X_350_ u_ctrl.cmp_addr\[6\] b_addr\[6\] net154 VGND VGND VPWR VPWR _096_ sky130_fd_sc_hd__mux2_1
XFILLER_198_177 VPWR VGND VPWR VGND sky130_ef_sc_hd__decap_12
XFILLER_183_1189 VPWR VGND VPWR VGND sky130_ef_sc_hd__decap_12
XFILLER_161_1410 VPWR VGND VPWR VGND sky130_ef_sc_hd__decap_12
XFILLER_81_69 VPWR VGND VPWR VGND sky130_ef_sc_hd__decap_12
XFILLER_74_1462 VGND VGND VPWR VPWR sky130_fd_sc_hd__decap_6
XFILLER_201_137 VPWR VGND VPWR VGND sky130_ef_sc_hd__decap_12
XFILLER_197_69 VPWR VGND VPWR VGND sky130_ef_sc_hd__decap_12
XFILLER_179_391 VGND VGND VPWR VPWR sky130_fd_sc_hd__fill_1
XFILLER_161_1454 VPWR VGND VPWR VGND sky130_ef_sc_hd__decap_12
XFILLER_126_1574 VGND VGND VPWR VPWR sky130_fd_sc_hd__decap_6
XFILLER_70_1326 VPWR VGND VPWR VGND sky130_ef_sc_hd__decap_12
XFILLER_14_41 VGND VGND VPWR VPWR sky130_fd_sc_hd__decap_4
X_281_ _077_ _078_ VGND VGND VPWR VPWR _079_ sky130_fd_sc_hd__nand2_1
XFILLER_182_501 VPWR VGND VPWR VGND sky130_ef_sc_hd__decap_12
XFILLER_167_553 VGND VGND VPWR VPWR sky130_fd_sc_hd__decap_6
XFILLER_122_1438 VPWR VGND VPWR VGND sky130_ef_sc_hd__decap_12
XFILLER_14_85 VGND VGND VPWR VPWR sky130_fd_sc_hd__fill_2
XTAP_TAPCELL_ROW_62_2_3379 VGND VPWR sky130_fd_sc_hd__tapvpwrvgnd_1
XFILLER_210_693 VGND VGND VPWR VPWR sky130_fd_sc_hd__decap_6
XFILLER_195_895 VGND VGND VPWR VPWR sky130_fd_sc_hd__fill_1
XFILLER_167_597 VPWR VGND VPWR VGND sky130_ef_sc_hd__decap_12
XFILLER_161_1498 VPWR VGND VPWR VGND sky130_ef_sc_hd__decap_12
XFILLER_6_725 VPWR VGND VPWR VGND sky130_ef_sc_hd__decap_12
XFILLER_196_1539 VGND VGND VPWR VPWR sky130_fd_sc_hd__fill_1
XFILLER_182_545 VPWR VGND VPWR VGND sky130_ef_sc_hd__decap_12
XFILLER_6_769 VPWR VGND VPWR VGND sky130_ef_sc_hd__decap_12
XFILLER_194_1241 VPWR VGND VPWR VGND sky130_ef_sc_hd__decap_12
XFILLER_182_589 VPWR VGND VPWR VGND sky130_ef_sc_hd__decap_12
XFILLER_163_781 VGND VGND VPWR VPWR sky130_fd_sc_hd__decap_3
XFILLER_68_1244 VGND VGND VPWR VPWR sky130_fd_sc_hd__fill_1
XFILLER_5_279 VGND VGND VPWR VPWR sky130_fd_sc_hd__fill_1
XFILLER_30_62 VPWR VGND VPWR VGND sky130_ef_sc_hd__decap_12
XFILLER_194_1285 VPWR VGND VPWR VGND sky130_ef_sc_hd__decap_12
XFILLER_190_1105 VPWR VGND VPWR VGND sky130_ef_sc_hd__decap_12
XFILLER_11_1490 VGND VGND VPWR VPWR sky130_fd_sc_hd__decap_6
XFILLER_190_1149 VPWR VGND VPWR VGND sky130_ef_sc_hd__decap_12
XFILLER_81_1422 VPWR VGND VPWR VGND sky130_ef_sc_hd__decap_12
XFILLER_133_1534 VPWR VGND VPWR VGND sky130_ef_sc_hd__decap_12
XFILLER_81_1466 VPWR VGND VPWR VGND sky130_ef_sc_hd__decap_12
XTAP_TAPCELL_ROW_22_2_3120 VGND VPWR sky130_fd_sc_hd__tapvpwrvgnd_1
XFILLER_42_1406 VGND VGND VPWR VPWR sky130_fd_sc_hd__decap_6
XFILLER_39_93 VPWR VGND VPWR VGND sky130_ef_sc_hd__decap_12
XFILLER_209_237 VPWR VGND VPWR VGND sky130_ef_sc_hd__decap_12
XFILLER_162_83 VGND VGND VPWR VPWR sky130_fd_sc_hd__fill_1
XFILLER_133_1578 VPWR VGND VPWR VGND sky130_ef_sc_hd__decap_12
XFILLER_218_793 VPWR VGND VPWR VGND sky130_ef_sc_hd__decap_12
XFILLER_217_281 VPWR VGND VPWR VGND sky130_ef_sc_hd__decap_12
XTAP_TAPCELL_ROW_205_2591 VGND VPWR sky130_fd_sc_hd__tapvpwrvgnd_1
XTAP_TAPCELL_ROW_205_2580 VGND VPWR sky130_fd_sc_hd__tapvpwrvgnd_1
XFILLER_189_111 VGND VGND VPWR VPWR sky130_fd_sc_hd__fill_1
XFILLER_79_1384 VGND VGND VPWR VPWR sky130_fd_sc_hd__fill_1
X_617_ clknet_3_3_0_clk _051_ VGND VGND VPWR VPWR net74 sky130_fd_sc_hd__dfxtp_1
XFILLER_55_81 VPWR VGND VPWR VGND sky130_ef_sc_hd__decap_12
XTAP_TAPCELL_ROW_201_2466 VGND VPWR sky130_fd_sc_hd__tapvpwrvgnd_1
XTAP_TAPCELL_ROW_201_2455 VGND VPWR sky130_fd_sc_hd__tapvpwrvgnd_1
XFILLER_166_1365 VGND VGND VPWR VPWR sky130_fd_sc_hd__decap_6
X_548_ net49 u_ctrl.cmp_addr\[0\] net122 VGND VGND VPWR VPWR _248_ sky130_fd_sc_hd__mux2_1
XTAP_TAPCELL_ROW_201_2477 VGND VPWR sky130_fd_sc_hd__tapvpwrvgnd_1
XFILLER_177_317 VPWR VGND VPWR VGND sky130_ef_sc_hd__decap_12
XFILLER_92_1562 VPWR VGND VPWR VGND sky130_ef_sc_hd__decap_12
XTAP_TAPCELL_ROW_193_2245 VGND VPWR sky130_fd_sc_hd__tapvpwrvgnd_1
XTAP_TAPCELL_ROW_193_2234 VGND VPWR sky130_fd_sc_hd__tapvpwrvgnd_1
X_479_ _201_ _202_ _207_ _210_ VGND VGND VPWR VPWR _211_ sky130_fd_sc_hd__or4_1
XFILLER_53_1546 VGND VGND VPWR VPWR sky130_fd_sc_hd__decap_6
XTAP_TAPCELL_ROW_218_2963 VGND VPWR sky130_fd_sc_hd__tapvpwrvgnd_1
XTAP_TAPCELL_ROW_218_2952 VGND VPWR sky130_fd_sc_hd__tapvpwrvgnd_1
XTAP_TAPCELL_ROW_218_2941 VGND VPWR sky130_fd_sc_hd__tapvpwrvgnd_1
XFILLER_201_671 VGND VGND VPWR VPWR sky130_fd_sc_hd__fill_1
XFILLER_192_309 VPWR VGND VPWR VGND sky130_ef_sc_hd__decap_12
XFILLER_140_1538 VPWR VGND VPWR VGND sky130_ef_sc_hd__decap_12
XTAP_TAPCELL_ROW_214_2838 VGND VPWR sky130_fd_sc_hd__tapvpwrvgnd_1
XTAP_TAPCELL_ROW_214_2827 VGND VPWR sky130_fd_sc_hd__tapvpwrvgnd_1
XFILLER_185_361 VPWR VGND VPWR VGND sky130_ef_sc_hd__decap_12
XTAP_TAPCELL_ROW_214_2849 VGND VPWR sky130_fd_sc_hd__tapvpwrvgnd_1
XTAP_TAPCELL_ROW_138_2_3877 VGND VPWR sky130_fd_sc_hd__tapvpwrvgnd_1
XFILLER_86_1300 VGND VGND VPWR VPWR sky130_fd_sc_hd__fill_1
XFILLER_65_3 VPWR VGND VPWR VGND sky130_ef_sc_hd__decap_12
XFILLER_12_1232 VPWR VGND VPWR VGND sky130_ef_sc_hd__decap_12
XFILLER_138_1412 VGND VGND VPWR VPWR sky130_fd_sc_hd__fill_1
XFILLER_173_1325 VPWR VGND VPWR VGND sky130_ef_sc_hd__decap_12
XFILLER_113_111 VGND VGND VPWR VPWR sky130_fd_sc_hd__fill_1
XFILLER_47_1328 VGND VGND VPWR VPWR sky130_fd_sc_hd__fill_1
XFILLER_173_1369 VPWR VGND VPWR VGND sky130_ef_sc_hd__decap_12
XTAP_TAPCELL_ROW_118_2_3742 VGND VPWR sky130_fd_sc_hd__tapvpwrvgnd_1
XFILLER_206_65 VPWR VGND VPWR VGND sky130_ef_sc_hd__decap_12
XFILLER_60_1506 VPWR VGND VPWR VGND sky130_ef_sc_hd__decap_12
XFILLER_27_106 VGND VGND VPWR VPWR sky130_fd_sc_hd__decap_6
XFILLER_97_1440 VGND VGND VPWR VPWR sky130_fd_sc_hd__fill_1
XFILLER_3_1455 VGND VGND VPWR VPWR sky130_fd_sc_hd__fill_1
XFILLER_184_1421 VGND VGND VPWR VPWR sky130_fd_sc_hd__decap_6
XTAP_TAPCELL_ROW_163_1392 VGND VPWR sky130_fd_sc_hd__tapvpwrvgnd_1
XTAP_TAPCELL_ROW_163_1381 VGND VPWR sky130_fd_sc_hd__tapvpwrvgnd_1
XTAP_TAPCELL_ROW_163_1370 VGND VPWR sky130_fd_sc_hd__tapvpwrvgnd_1
XFILLER_42_109 VPWR VGND VPWR VGND sky130_ef_sc_hd__decap_12
XFILLER_212_925 VPWR VGND VPWR VGND sky130_ef_sc_hd__decap_12
XFILLER_184_1465 VPWR VGND VPWR VGND sky130_ef_sc_hd__decap_12
XFILLER_149_1552 VGND VGND VPWR VPWR sky130_fd_sc_hd__fill_1
XFILLER_58_1468 VGND VGND VPWR VPWR sky130_fd_sc_hd__fill_1
XFILLER_180_1329 VPWR VGND VPWR VGND sky130_ef_sc_hd__decap_12
XFILLER_71_1602 VGND VGND VPWR VPWR sky130_fd_sc_hd__decap_3
XFILLER_196_637 VGND VGND VPWR VPWR sky130_fd_sc_hd__decap_6
XFILLER_195_125 VPWR VGND VPWR VGND sky130_ef_sc_hd__decap_12
XPHY_EDGE_ROW_157_2_Right_214 VGND VGND VPWR VPWR sky130_fd_sc_hd__decap_3
XFILLER_195_169 VPWR VGND VPWR VGND sky130_ef_sc_hd__decap_12
XTAP_TAPCELL_ROW_176_1764 VGND VPWR sky130_fd_sc_hd__tapvpwrvgnd_1
XTAP_TAPCELL_ROW_176_1753 VGND VPWR sky130_fd_sc_hd__tapvpwrvgnd_1
XTAP_TAPCELL_ROW_176_1742 VGND VPWR sky130_fd_sc_hd__tapvpwrvgnd_1
XFILLER_108_1282 VPWR VGND VPWR VGND sky130_ef_sc_hd__decap_12
XFILLER_51_39 VPWR VGND VPWR VGND sky130_ef_sc_hd__decap_12
XFILLER_178_1203 VGND VGND VPWR VPWR sky130_fd_sc_hd__fill_1
XFILLER_177_895 VGND VGND VPWR VPWR sky130_fd_sc_hd__fill_1
XTAP_TAPCELL_ROW_172_1628 VGND VPWR sky130_fd_sc_hd__tapvpwrvgnd_1
XFILLER_167_39 VPWR VGND VPWR VGND sky130_ef_sc_hd__decap_12
XFILLER_164_501 VPWR VGND VPWR VGND sky130_ef_sc_hd__decap_12
XTAP_TAPCELL_ROW_172_1639 VGND VPWR sky130_fd_sc_hd__tapvpwrvgnd_1
XFILLER_164_545 VPWR VGND VPWR VGND sky130_ef_sc_hd__decap_12
XFILLER_164_589 VPWR VGND VPWR VGND sky130_ef_sc_hd__decap_12
XFILLER_219_1233 VPWR VGND VPWR VGND sky130_ef_sc_hd__decap_12
XFILLER_195_1561 VGND VGND VPWR VPWR sky130_fd_sc_hd__decap_6
XFILLER_191_1425 VPWR VGND VPWR VGND sky130_ef_sc_hd__decap_12
XFILLER_183_27 VPWR VGND VPWR VGND sky130_ef_sc_hd__decap_12
XFILLER_215_1119 VGND VGND VPWR VPWR sky130_fd_sc_hd__fill_1
XTAP_TAPCELL_ROW_153_1_1324 VGND VPWR sky130_fd_sc_hd__tapvpwrvgnd_1
XFILLER_8_1300 VGND VGND VPWR VPWR sky130_fd_sc_hd__fill_1
XFILLER_191_1469 VPWR VGND VPWR VGND sky130_ef_sc_hd__decap_12
XFILLER_116_65 VPWR VGND VPWR VGND sky130_ef_sc_hd__decap_12
XFILLER_115_1220 VPWR VGND VPWR VGND sky130_ef_sc_hd__decap_12
XFILLER_28_1294 VGND VGND VPWR VPWR sky130_fd_sc_hd__decap_6
XFILLER_219_557 VGND VGND VPWR VPWR sky130_fd_sc_hd__decap_3
XFILLER_189_1343 VGND VGND VPWR VPWR sky130_fd_sc_hd__fill_1
XFILLER_115_1286 VPWR VGND VPWR VGND sky130_ef_sc_hd__decap_12
XFILLER_132_53 VPWR VGND VPWR VGND sky130_ef_sc_hd__decap_12
XFILLER_215_741 VPWR VGND VPWR VGND sky130_ef_sc_hd__decap_12
XFILLER_76_1524 VGND VGND VPWR VPWR sky130_fd_sc_hd__fill_1
XFILLER_214_251 VGND VGND VPWR VPWR sky130_fd_sc_hd__fill_1
XTAP_TAPCELL_ROW_157_2_4000 VGND VPWR sky130_fd_sc_hd__tapvpwrvgnd_1
XFILLER_132_97 VPWR VGND VPWR VGND sky130_ef_sc_hd__decap_12
X_402_ _137_ _138_ net156 VGND VGND VPWR VPWR _021_ sky130_fd_sc_hd__o21a_1
XFILLER_215_785 VPWR VGND VPWR VGND sky130_ef_sc_hd__decap_12
XFILLER_202_413 VGND VGND VPWR VPWR sky130_fd_sc_hd__decap_6
XFILLER_187_615 VGND VGND VPWR VPWR sky130_fd_sc_hd__fill_1
XFILLER_202_457 VPWR VGND VPWR VGND sky130_ef_sc_hd__decap_12
XFILLER_199_497 VGND VGND VPWR VPWR sky130_fd_sc_hd__decap_6
XFILLER_74_1270 VPWR VGND VPWR VGND sky130_ef_sc_hd__decap_12
X_333_ u_ctrl.elem_idx\[2\] u_ctrl.elem_idx\[1\] u_ctrl.elem_idx\[0\] _072_ VGND VGND
+ VPWR VPWR _088_ sky130_fd_sc_hd__o31a_1
XFILLER_35_1232 VPWR VGND VPWR VGND sky130_ef_sc_hd__decap_12
XFILLER_174_309 VPWR VGND VPWR VGND sky130_ef_sc_hd__decap_12
XFILLER_126_1382 VPWR VGND VPWR VGND sky130_ef_sc_hd__decap_12
XFILLER_183_821 VPWR VGND VPWR VGND sky130_ef_sc_hd__decap_12
XFILLER_167_361 VPWR VGND VPWR VGND sky130_ef_sc_hd__decap_12
XTAP_TAPCELL_ROW_124_2_3785 VGND VPWR sky130_fd_sc_hd__tapvpwrvgnd_1
XFILLER_122_1246 VPWR VGND VPWR VGND sky130_ef_sc_hd__decap_12
XFILLER_6_511 VGND VGND VPWR VPWR sky130_fd_sc_hd__fill_1
XFILLER_35_1298 VPWR VGND VPWR VGND sky130_ef_sc_hd__decap_12
XFILLER_183_865 VPWR VGND VPWR VGND sky130_ef_sc_hd__decap_12
XFILLER_6_533 VPWR VGND VPWR VGND sky130_ef_sc_hd__decap_12
XFILLER_13_1552 VGND VGND VPWR VPWR sky130_fd_sc_hd__fill_1
XTAP_TAPCELL_ROW_92_2_3574 VGND VPWR sky130_fd_sc_hd__tapvpwrvgnd_1
XFILLER_194_1093 VPWR VGND VPWR VGND sky130_ef_sc_hd__decap_12
XFILLER_170_1509 VPWR VGND VPWR VGND sky130_ef_sc_hd__decap_12
XFILLER_46_1350 VGND VGND VPWR VPWR sky130_fd_sc_hd__decap_6
XFILLER_173_93 VPWR VGND VPWR VGND sky130_ef_sc_hd__decap_12
XFILLER_133_1342 VPWR VGND VPWR VGND sky130_ef_sc_hd__decap_12
XFILLER_81_1274 VPWR VGND VPWR VGND sky130_ef_sc_hd__decap_12
XFILLER_1_293 VGND VGND VPWR VPWR sky130_fd_sc_hd__decap_4
XFILLER_46_1394 VPWR VGND VPWR VGND sky130_ef_sc_hd__decap_12
XTAP_TAPCELL_ROW_207_2653 VGND VPWR sky130_fd_sc_hd__tapvpwrvgnd_1
XTAP_TAPCELL_ROW_207_2642 VGND VPWR sky130_fd_sc_hd__tapvpwrvgnd_1
XTAP_TAPCELL_ROW_207_2631 VGND VPWR sky130_fd_sc_hd__tapvpwrvgnd_1
XFILLER_133_1386 VPWR VGND VPWR VGND sky130_ef_sc_hd__decap_12
XFILLER_2_77 VGND VGND VPWR VPWR sky130_fd_sc_hd__decap_6
XFILLER_42_1258 VPWR VGND VPWR VGND sky130_ef_sc_hd__decap_12
XTAP_TAPCELL_ROW_203_2517 VGND VPWR sky130_fd_sc_hd__tapvpwrvgnd_1
XFILLER_168_1427 VGND VGND VPWR VPWR sky130_fd_sc_hd__fill_1
XTAP_TAPCELL_ROW_203_2539 VGND VPWR sky130_fd_sc_hd__tapvpwrvgnd_1
XTAP_TAPCELL_ROW_203_2528 VGND VPWR sky130_fd_sc_hd__tapvpwrvgnd_1
XTAP_TAPCELL_ROW_199_2421 VGND VPWR sky130_fd_sc_hd__tapvpwrvgnd_1
XTAP_TAPCELL_ROW_199_2410 VGND VPWR sky130_fd_sc_hd__tapvpwrvgnd_1
XFILLER_94_1602 VGND VGND VPWR VPWR sky130_fd_sc_hd__decap_3
XFILLER_209_1413 VPWR VGND VPWR VGND sky130_ef_sc_hd__decap_12
XTAP_TAPCELL_ROW_195_2307 VGND VPWR sky130_fd_sc_hd__tapvpwrvgnd_1
XFILLER_209_1457 VPWR VGND VPWR VGND sky130_ef_sc_hd__decap_12
XFILLER_205_273 VGND VGND VPWR VPWR sky130_fd_sc_hd__decap_6
XFILLER_166_1173 VPWR VGND VPWR VGND sky130_ef_sc_hd__decap_12
XFILLER_178_637 VGND VGND VPWR VPWR sky130_fd_sc_hd__decap_6
XFILLER_177_125 VPWR VGND VPWR VGND sky130_ef_sc_hd__decap_12
XFILLER_92_1370 VPWR VGND VPWR VGND sky130_ef_sc_hd__decap_12
XFILLER_53_1310 VPWR VGND VPWR VGND sky130_ef_sc_hd__decap_12
XFILLER_57_1490 VGND VGND VPWR VPWR sky130_fd_sc_hd__decap_6
XFILLER_203_1001 VGND VGND VPWR VPWR sky130_fd_sc_hd__decap_6
XFILLER_177_169 VPWR VGND VPWR VGND sky130_ef_sc_hd__decap_12
XFILLER_140_1302 VPWR VGND VPWR VGND sky130_ef_sc_hd__decap_12
XFILLER_105_1422 VPWR VGND VPWR VGND sky130_ef_sc_hd__decap_12
XFILLER_53_1354 VPWR VGND VPWR VGND sky130_ef_sc_hd__decap_12
XFILLER_203_1045 VPWR VGND VPWR VGND sky130_ef_sc_hd__decap_12
XFILLER_193_629 VPWR VGND VPWR VGND sky130_ef_sc_hd__decap_12
XFILLER_186_681 VPWR VGND VPWR VGND sky130_ef_sc_hd__decap_12
XFILLER_144_1482 VPWR VGND VPWR VGND sky130_ef_sc_hd__decap_12
XFILLER_105_1466 VPWR VGND VPWR VGND sky130_ef_sc_hd__decap_12
XFILLER_14_1338 VPWR VGND VPWR VGND sky130_ef_sc_hd__decap_12
XTAP_TAPCELL_ROW_13_2_3065 VGND VPWR sky130_fd_sc_hd__tapvpwrvgnd_1
XFILLER_53_1398 VPWR VGND VPWR VGND sky130_ef_sc_hd__decap_12
XFILLER_203_1089 VPWR VGND VPWR VGND sky130_ef_sc_hd__decap_12
XFILLER_192_139 VGND VGND VPWR VPWR sky130_fd_sc_hd__fill_1
XFILLER_88_1406 VGND VGND VPWR VPWR sky130_fd_sc_hd__decap_6
XPHY_EDGE_ROW_21_1_Left_240 VGND VGND VPWR VPWR sky130_fd_sc_hd__decap_3
XFILLER_179_1567 VGND VGND VPWR VPWR sky130_fd_sc_hd__fill_1
Xoutput101 net101 VGND VGND VPWR VPWR func_rdata[20] sky130_fd_sc_hd__buf_2
XFILLER_138_1220 VPWR VGND VPWR VGND sky130_ef_sc_hd__decap_12
Xoutput112 net112 VGND VGND VPWR VPWR func_rdata[30] sky130_fd_sc_hd__buf_2
XFILLER_173_1133 VPWR VGND VPWR VGND sky130_ef_sc_hd__decap_12
XFILLER_173_1177 VPWR VGND VPWR VGND sky130_ef_sc_hd__decap_12
XFILLER_64_1450 VPWR VGND VPWR VGND sky130_ef_sc_hd__decap_12
XFILLER_214_1141 VGND VGND VPWR VPWR sky130_fd_sc_hd__decap_6
XFILLER_151_1442 VPWR VGND VPWR VGND sky130_ef_sc_hd__decap_12
XFILLER_101_125 VGND VGND VPWR VPWR sky130_fd_sc_hd__fill_2
XFILLER_64_1494 VPWR VGND VPWR VGND sky130_ef_sc_hd__decap_12
XFILLER_25_1434 VGND VGND VPWR VPWR sky130_fd_sc_hd__decap_6
XFILLER_60_1314 VPWR VGND VPWR VGND sky130_ef_sc_hd__decap_12
XFILLER_214_1185 VPWR VGND VPWR VGND sky130_ef_sc_hd__decap_12
XFILLER_210_1005 VPWR VGND VPWR VGND sky130_ef_sc_hd__decap_12
XTAP_TAPCELL_ROW_165_1443 VGND VPWR sky130_fd_sc_hd__tapvpwrvgnd_1
XTAP_TAPCELL_ROW_165_1432 VGND VPWR sky130_fd_sc_hd__tapvpwrvgnd_1
XFILLER_116_1562 VPWR VGND VPWR VGND sky130_ef_sc_hd__decap_12
XFILLER_112_1426 VPWR VGND VPWR VGND sky130_ef_sc_hd__decap_12
XFILLER_25_1478 VPWR VGND VPWR VGND sky130_ef_sc_hd__decap_12
XFILLER_60_1358 VPWR VGND VPWR VGND sky130_ef_sc_hd__decap_12
XFILLER_210_1049 VPWR VGND VPWR VGND sky130_ef_sc_hd__decap_12
XTAP_TAPCELL_ROW_165_1454 VGND VPWR sky130_fd_sc_hd__tapvpwrvgnd_1
XFILLER_99_1546 VGND VGND VPWR VPWR sky130_fd_sc_hd__decap_6
XFILLER_58_1232 VPWR VGND VPWR VGND sky130_ef_sc_hd__decap_12
XFILLER_196_401 VPWR VGND VPWR VGND sky130_ef_sc_hd__decap_12
XFILLER_184_1273 VPWR VGND VPWR VGND sky130_ef_sc_hd__decap_12
XTAP_TAPCELL_ROW_178_1815 VGND VPWR sky130_fd_sc_hd__tapvpwrvgnd_1
XTAP_TAPCELL_ROW_178_1804 VGND VPWR sky130_fd_sc_hd__tapvpwrvgnd_1
XFILLER_169_615 VGND VGND VPWR VPWR sky130_fd_sc_hd__fill_1
XFILLER_62_27 VGND VGND VPWR VPWR sky130_fd_sc_hd__fill_1
XFILLER_212_755 VGND VGND VPWR VPWR sky130_fd_sc_hd__fill_1
XTAP_TAPCELL_ROW_178_1826 VGND VPWR sky130_fd_sc_hd__tapvpwrvgnd_1
XFILLER_178_27 VGND VGND VPWR VPWR sky130_fd_sc_hd__fill_1
XFILLER_71_1410 VPWR VGND VPWR VGND sky130_ef_sc_hd__decap_12
XFILLER_200_917 VGND VGND VPWR VPWR sky130_fd_sc_hd__decap_6
XFILLER_196_445 VPWR VGND VPWR VGND sky130_ef_sc_hd__decap_12
XPHY_EDGE_ROW_158_2_Right_215 VGND VGND VPWR VPWR sky130_fd_sc_hd__decap_3
XFILLER_145_1268 VGND VGND VPWR VPWR sky130_fd_sc_hd__decap_4
XFILLER_123_1522 VPWR VGND VPWR VGND sky130_ef_sc_hd__decap_12
XTAP_TAPCELL_ROW_110_2_3693 VGND VPWR sky130_fd_sc_hd__tapvpwrvgnd_1
XTAP_TAPCELL_ROW_109_2_3687 VGND VPWR sky130_fd_sc_hd__tapvpwrvgnd_1
XFILLER_75_1590 VPWR VGND VPWR VGND sky130_ef_sc_hd__decap_12
XFILLER_71_1454 VPWR VGND VPWR VGND sky130_ef_sc_hd__decap_12
XFILLER_36_1574 VGND VGND VPWR VPWR sky130_fd_sc_hd__decap_6
XFILLER_196_489 VPWR VGND VPWR VGND sky130_ef_sc_hd__decap_12
XFILLER_165_821 VPWR VGND VPWR VGND sky130_ef_sc_hd__decap_12
XFILLER_162_1582 VPWR VGND VPWR VGND sky130_ef_sc_hd__decap_12
XFILLER_32_1438 VPWR VGND VPWR VGND sky130_ef_sc_hd__decap_12
XFILLER_194_15 VPWR VGND VPWR VGND sky130_ef_sc_hd__decap_12
XFILLER_165_865 VPWR VGND VPWR VGND sky130_ef_sc_hd__decap_12
XFILLER_123_1566 VPWR VGND VPWR VGND sky130_ef_sc_hd__decap_12
XTAP_TAPCELL_ROW_77_2_3476 VGND VPWR sky130_fd_sc_hd__tapvpwrvgnd_1
XFILLER_71_1498 VPWR VGND VPWR VGND sky130_ef_sc_hd__decap_12
XFILLER_191_161 VGND VGND VPWR VPWR sky130_fd_sc_hd__decap_6
XFILLER_180_813 VPWR VGND VPWR VGND sky130_ef_sc_hd__decap_12
XFILLER_191_1233 VPWR VGND VPWR VGND sky130_ef_sc_hd__decap_12
XFILLER_3_569 VGND VGND VPWR VPWR sky130_fd_sc_hd__decap_3
XFILLER_87_57 VPWR VGND VPWR VGND sky130_ef_sc_hd__decap_12
XFILLER_82_1550 VPWR VGND VPWR VGND sky130_ef_sc_hd__decap_12
XFILLER_43_1534 VPWR VGND VPWR VGND sky130_ef_sc_hd__decap_12
XFILLER_219_321 VPWR VGND VPWR VGND sky130_ef_sc_hd__decap_12
XPHY_EDGE_ROW_97_1_Left_316 VGND VGND VPWR VPWR sky130_fd_sc_hd__decap_3
XFILLER_82_1594 VGND VGND VPWR VPWR sky130_fd_sc_hd__decap_8
XFILLER_4_1005 VPWR VGND VPWR VGND sky130_ef_sc_hd__decap_12
XFILLER_219_365 VPWR VGND VPWR VGND sky130_ef_sc_hd__decap_12
XFILLER_207_505 VPWR VGND VPWR VGND sky130_ef_sc_hd__decap_12
XFILLER_130_1526 VPWR VGND VPWR VGND sky130_ef_sc_hd__decap_12
XFILLER_4_1049 VPWR VGND VPWR VGND sky130_ef_sc_hd__decap_12
XFILLER_43_1578 VPWR VGND VPWR VGND sky130_ef_sc_hd__decap_12
XTAP_TAPCELL_ROW_50_2_3306 VGND VPWR sky130_fd_sc_hd__tapvpwrvgnd_1
XFILLER_199_261 VPWR VGND VPWR VGND sky130_ef_sc_hd__decap_12
XFILLER_163_1313 VGND VGND VPWR VPWR sky130_fd_sc_hd__decap_3
XFILLER_36_83 VGND VGND VPWR VPWR sky130_fd_sc_hd__fill_1
XFILLER_202_221 VPWR VGND VPWR VGND sky130_ef_sc_hd__decap_12
XFILLER_167_1493 VPWR VGND VPWR VGND sky130_ef_sc_hd__decap_12
XFILLER_163_1357 VPWR VGND VPWR VGND sky130_ef_sc_hd__decap_12
XFILLER_159_125 VGND VGND VPWR VPWR sky130_fd_sc_hd__fill_2
XFILLER_203_777 VGND VGND VPWR VPWR sky130_fd_sc_hd__decap_6
XFILLER_202_265 VPWR VGND VPWR VGND sky130_ef_sc_hd__decap_12
XFILLER_188_979 VGND VGND VPWR VPWR sky130_fd_sc_hd__fill_1
X_316_ net27 net143 net133 VGND VGND VPWR VPWR s_wdata\[23\] sky130_fd_sc_hd__a21o_1
XFILLER_198_1409 VPWR VGND VPWR VGND sky130_ef_sc_hd__decap_12
XFILLER_175_629 VPWR VGND VPWR VGND sky130_ef_sc_hd__decap_12
XFILLER_168_681 VPWR VGND VPWR VGND sky130_ef_sc_hd__decap_12
XFILLER_204_1365 VGND VGND VPWR VPWR sky130_fd_sc_hd__decap_6
XFILLER_200_1229 VPWR VGND VPWR VGND sky130_ef_sc_hd__decap_12
XFILLER_174_139 VGND VGND VPWR VPWR sky130_fd_sc_hd__fill_1
Xinput36 func_wdata[31] VGND VGND VPWR VPWR net36 sky130_fd_sc_hd__buf_1
Xinput14 func_wdata[11] VGND VGND VPWR VPWR net14 sky130_fd_sc_hd__clkbuf_1
Xinput25 func_wdata[21] VGND VGND VPWR VPWR net25 sky130_fd_sc_hd__clkbuf_1
XFILLER_50_1538 VPWR VGND VPWR VGND sky130_ef_sc_hd__decap_12
XFILLER_183_673 VPWR VGND VPWR VGND sky130_ef_sc_hd__decap_12
XFILLER_170_301 VGND VGND VPWR VPWR sky130_fd_sc_hd__decap_6
XTAP_TAPCELL_ROW_154_2_3980 VGND VPWR sky130_fd_sc_hd__tapvpwrvgnd_1
XFILLER_7_864 VGND VGND VPWR VPWR sky130_fd_sc_hd__decap_4
XTAP_TAPCELL_ROW_188_2111 VGND VPWR sky130_fd_sc_hd__tapvpwrvgnd_1
XTAP_TAPCELL_ROW_188_2100 VGND VPWR sky130_fd_sc_hd__tapvpwrvgnd_1
XFILLER_6_363 VGND VGND VPWR VPWR sky130_fd_sc_hd__fill_1
XFILLER_7_897 VPWR VGND VPWR VGND sky130_ef_sc_hd__decap_12
XFILLER_48_1412 VGND VGND VPWR VPWR sky130_fd_sc_hd__fill_1
XFILLER_170_345 VPWR VGND VPWR VGND sky130_ef_sc_hd__decap_12
XTAP_TAPCELL_ROW_209_2704 VGND VPWR sky130_fd_sc_hd__tapvpwrvgnd_1
XFILLER_174_1453 VPWR VGND VPWR VGND sky130_ef_sc_hd__decap_12
XFILLER_170_1317 VPWR VGND VPWR VGND sky130_ef_sc_hd__decap_12
XFILLER_170_389 VPWR VGND VPWR VGND sky130_ef_sc_hd__decap_12
XPHY_EDGE_ROW_120_2_Right_177 VGND VGND VPWR VPWR sky130_fd_sc_hd__decap_3
XFILLER_174_1497 VPWR VGND VPWR VGND sky130_ef_sc_hd__decap_12
XFILLER_211_1325 VPWR VGND VPWR VGND sky130_ef_sc_hd__decap_12
XFILLER_28_3 VPWR VGND VPWR VGND sky130_ef_sc_hd__decap_12
XTAP_TAPCELL_ROW_146_2_3928 VGND VPWR sky130_fd_sc_hd__tapvpwrvgnd_1
XANTENNA__496__B net125 VGND VGND VPWR VPWR sky130_fd_sc_hd__diode_2
XFILLER_211_1369 VPWR VGND VPWR VGND sky130_ef_sc_hd__decap_12
XFILLER_203_55 VGND VGND VPWR VPWR sky130_fd_sc_hd__fill_1
XFILLER_0_1425 VGND VGND VPWR VPWR sky130_fd_sc_hd__decap_3
XFILLER_181_1413 VPWR VGND VPWR VGND sky130_ef_sc_hd__decap_12
XFILLER_178_401 VPWR VGND VPWR VGND sky130_ef_sc_hd__decap_12
XFILLER_0_1469 VPWR VGND VPWR VGND sky130_ef_sc_hd__decap_12
XFILLER_59_1552 VGND VGND VPWR VPWR sky130_fd_sc_hd__fill_1
XFILLER_185_1593 VPWR VGND VPWR VGND sky130_ef_sc_hd__decap_12
XFILLER_209_1287 VGND VGND VPWR VPWR sky130_fd_sc_hd__fill_1
XFILLER_194_905 VPWR VGND VPWR VGND sky130_ef_sc_hd__decap_12
XFILLER_181_1457 VPWR VGND VPWR VGND sky130_ef_sc_hd__decap_12
XFILLER_178_445 VPWR VGND VPWR VGND sky130_ef_sc_hd__decap_12
XFILLER_194_949 VPWR VGND VPWR VGND sky130_ef_sc_hd__decap_12
XFILLER_178_489 VPWR VGND VPWR VGND sky130_ef_sc_hd__decap_12
XFILLER_18_1282 VPWR VGND VPWR VGND sky130_ef_sc_hd__decap_12
XFILLER_105_1274 VPWR VGND VPWR VGND sky130_ef_sc_hd__decap_12
XANTENNA__336__A2 net140 VGND VGND VPWR VPWR sky130_fd_sc_hd__diode_2
XFILLER_180_109 VPWR VGND VPWR VGND sky130_ef_sc_hd__decap_12
XFILLER_173_161 VGND VGND VPWR VPWR sky130_fd_sc_hd__decap_6
XFILLER_88_1258 VPWR VGND VPWR VGND sky130_ef_sc_hd__decap_12
XTAP_TAPCELL_ROW_43_2_3260 VGND VPWR sky130_fd_sc_hd__tapvpwrvgnd_1
XFILLER_216_1203 VGND VGND VPWR VPWR sky130_fd_sc_hd__fill_1
XFILLER_164_29 VPWR VGND VPWR VGND sky130_ef_sc_hd__decap_12
XFILLER_118_1602 VGND VGND VPWR VPWR sky130_fd_sc_hd__decap_3
XFILLER_192_1553 VPWR VGND VPWR VGND sky130_ef_sc_hd__decap_12
XFILLER_0_528 VGND VGND VPWR VPWR sky130_fd_sc_hd__decap_4
XFILLER_192_1597 VGND VGND VPWR VPWR sky130_fd_sc_hd__decap_8
XTAP_TAPCELL_ROW_167_1505 VGND VPWR sky130_fd_sc_hd__tapvpwrvgnd_1
XFILLER_116_1370 VPWR VGND VPWR VGND sky130_ef_sc_hd__decap_12
XFILLER_25_1220 VPWR VGND VPWR VGND sky130_ef_sc_hd__decap_12
XFILLER_151_1272 VGND VGND VPWR VPWR sky130_fd_sc_hd__fill_1
XFILLER_99_1310 VPWR VGND VPWR VGND sky130_ef_sc_hd__decap_12
XFILLER_5_1325 VPWR VGND VPWR VGND sky130_ef_sc_hd__decap_12
XFILLER_25_1286 VPWR VGND VPWR VGND sky130_ef_sc_hd__decap_12
XTAP_TAPCELL_ROW_35_2_3208 VGND VPWR sky130_fd_sc_hd__tapvpwrvgnd_1
XFILLER_113_55 VGND VGND VPWR VPWR sky130_fd_sc_hd__fill_1
XFILLER_99_1354 VPWR VGND VPWR VGND sky130_ef_sc_hd__decap_12
XFILLER_5_1369 VPWR VGND VPWR VGND sky130_ef_sc_hd__decap_12
XFILLER_216_357 VGND VGND VPWR VPWR sky130_fd_sc_hd__decap_6
XFILLER_99_1398 VPWR VGND VPWR VGND sky130_ef_sc_hd__decap_12
XFILLER_73_15 VPWR VGND VPWR VGND sky130_ef_sc_hd__decap_12
XTAP_TAPCELL_ROW_219_3011 VGND VPWR sky130_fd_sc_hd__tapvpwrvgnd_1
XTAP_TAPCELL_ROW_219_3000 VGND VPWR sky130_fd_sc_hd__tapvpwrvgnd_1
XFILLER_188_209 VPWR VGND VPWR VGND sky130_ef_sc_hd__decap_12
XFILLER_189_15 VPWR VGND VPWR VGND sky130_ef_sc_hd__decap_12
XTAP_TAPCELL_ROW_219_3022 VGND VPWR sky130_fd_sc_hd__tapvpwrvgnd_1
XFILLER_197_721 VGND VGND VPWR VPWR sky130_fd_sc_hd__decap_6
XFILLER_197_765 VPWR VGND VPWR VGND sky130_ef_sc_hd__decap_12
XFILLER_196_253 VPWR VGND VPWR VGND sky130_ef_sc_hd__decap_12
XFILLER_200_725 VPWR VGND VPWR VGND sky130_ef_sc_hd__decap_12
XFILLER_132_3 VPWR VGND VPWR VGND sky130_ef_sc_hd__decap_12
XFILLER_123_1330 VPWR VGND VPWR VGND sky130_ef_sc_hd__decap_12
XFILLER_36_1382 VPWR VGND VPWR VGND sky130_ef_sc_hd__decap_12
XFILLER_201_1505 VGND VGND VPWR VPWR sky130_fd_sc_hd__decap_6
XFILLER_200_769 VPWR VGND VPWR VGND sky130_ef_sc_hd__decap_12
XPHY_EDGE_ROW_159_2_Right_216 VGND VGND VPWR VPWR sky130_fd_sc_hd__decap_3
XFILLER_32_1246 VPWR VGND VPWR VGND sky130_ef_sc_hd__decap_12
XTAP_TAPCELL_ROW_33_1_1083 VGND VPWR sky130_fd_sc_hd__tapvpwrvgnd_1
XFILLER_201_1549 VPWR VGND VPWR VGND sky130_ef_sc_hd__decap_12
XFILLER_165_673 VPWR VGND VPWR VGND sky130_ef_sc_hd__decap_12
XTAP_TAPCELL_ROW_139_2_3882 VGND VPWR sky130_fd_sc_hd__tapvpwrvgnd_1
XFILLER_138_41 VPWR VGND VPWR VGND sky130_ef_sc_hd__decap_12
XFILLER_22_85 VPWR VGND VPWR VGND sky130_ef_sc_hd__decap_12
XFILLER_158_1426 VPWR VGND VPWR VGND sky130_ef_sc_hd__decap_12
XFILLER_138_85 VPWR VGND VPWR VGND sky130_ef_sc_hd__decap_12
XFILLER_180_643 VGND VGND VPWR VPWR sky130_fd_sc_hd__fill_1
XFILLER_3_333 VGND VGND VPWR VPWR sky130_fd_sc_hd__decap_3
XFILLER_191_1063 VGND VGND VPWR VPWR sky130_fd_sc_hd__fill_1
XTAP_TAPCELL_ROW_121_1_1259 VGND VPWR sky130_fd_sc_hd__tapvpwrvgnd_1
XTAP_TAPCELL_ROW_132_2_3836 VGND VPWR sky130_fd_sc_hd__tapvpwrvgnd_1
XPHY_EDGE_ROW_40_1_Right_626 VGND VGND VPWR VPWR sky130_fd_sc_hd__decap_3
XFILLER_43_1342 VPWR VGND VPWR VGND sky130_ef_sc_hd__decap_12
XFILLER_134_1470 VPWR VGND VPWR VGND sky130_ef_sc_hd__decap_12
XTAP_TAPCELL_ROW_99_2_3619 VGND VPWR sky130_fd_sc_hd__tapvpwrvgnd_1
XFILLER_208_825 VPWR VGND VPWR VGND sky130_ef_sc_hd__decap_12
XPHY_EDGE_ROW_179_Right_24 VGND VGND VPWR VPWR sky130_fd_sc_hd__decap_3
XFILLER_169_1511 VGND VGND VPWR VPWR sky130_fd_sc_hd__fill_1
XFILLER_130_1356 VGND VGND VPWR VPWR sky130_fd_sc_hd__fill_1
XFILLER_43_1386 VPWR VGND VPWR VGND sky130_ef_sc_hd__decap_12
XFILLER_208_869 VPWR VGND VPWR VGND sky130_ef_sc_hd__decap_12
XFILLER_207_335 VGND VGND VPWR VPWR sky130_fd_sc_hd__fill_1
XFILLER_170_83 VGND VGND VPWR VPWR sky130_fd_sc_hd__fill_1
XFILLER_78_1438 VPWR VGND VPWR VGND sky130_ef_sc_hd__decap_12
XFILLER_47_93 VPWR VGND VPWR VGND sky130_ef_sc_hd__decap_12
XTAP_TAPCELL_ROW_80_2_3501 VGND VPWR sky130_fd_sc_hd__tapvpwrvgnd_1
XFILLER_203_541 VPWR VGND VPWR VGND sky130_ef_sc_hd__decap_12
XFILLER_163_1121 VGND VGND VPWR VPWR sky130_fd_sc_hd__decap_8
XFILLER_206_1427 VGND VGND VPWR VPWR sky130_fd_sc_hd__fill_1
XFILLER_176_905 VPWR VGND VPWR VGND sky130_ef_sc_hd__decap_12
XFILLER_63_81 VPWR VGND VPWR VGND sky130_ef_sc_hd__decap_12
XFILLER_203_585 VPWR VGND VPWR VGND sky130_ef_sc_hd__decap_12
XFILLER_179_81 VPWR VGND VPWR VGND sky130_ef_sc_hd__decap_12
XFILLER_176_949 VPWR VGND VPWR VGND sky130_ef_sc_hd__decap_12
XFILLER_15_1422 VPWR VGND VPWR VGND sky130_ef_sc_hd__decap_12
XFILLER_50_1302 VPWR VGND VPWR VGND sky130_ef_sc_hd__decap_12
XFILLER_204_1173 VPWR VGND VPWR VGND sky130_ef_sc_hd__decap_12
XFILLER_198_1217 VPWR VGND VPWR VGND sky130_ef_sc_hd__decap_12
XFILLER_106_1550 VPWR VGND VPWR VGND sky130_ef_sc_hd__decap_12
XFILLER_54_1482 VPWR VGND VPWR VGND sky130_ef_sc_hd__decap_12
XFILLER_200_1037 VPWR VGND VPWR VGND sky130_ef_sc_hd__decap_12
XPHY_EDGE_ROW_188_Right_33 VGND VGND VPWR VPWR sky130_fd_sc_hd__decap_3
XFILLER_162_109 VPWR VGND VPWR VGND sky130_ef_sc_hd__decap_12
XFILLER_141_1496 VGND VGND VPWR VPWR sky130_fd_sc_hd__fill_1
XFILLER_106_1594 VGND VGND VPWR VPWR sky130_fd_sc_hd__decap_8
XFILLER_102_1414 VPWR VGND VPWR VGND sky130_ef_sc_hd__decap_12
XFILLER_89_1534 VPWR VGND VPWR VGND sky130_ef_sc_hd__decap_12
XFILLER_15_1466 VPWR VGND VPWR VGND sky130_ef_sc_hd__decap_12
XTAP_TAPCELL_ROW_28_2_3162 VGND VPWR sky130_fd_sc_hd__tapvpwrvgnd_1
XFILLER_184_993 VPWR VGND VPWR VGND sky130_ef_sc_hd__decap_12
XFILLER_89_1578 VPWR VGND VPWR VGND sky130_ef_sc_hd__decap_12
XFILLER_171_665 VGND VGND VPWR VPWR sky130_fd_sc_hd__decap_6
XFILLER_48_1220 VPWR VGND VPWR VGND sky130_ef_sc_hd__decap_12
XFILLER_174_1261 VPWR VGND VPWR VGND sky130_ef_sc_hd__decap_12
XFILLER_170_153 VPWR VGND VPWR VGND sky130_ef_sc_hd__decap_12
XFILLER_217_1567 VGND VGND VPWR VPWR sky130_fd_sc_hd__fill_1
XFILLER_170_197 VPWR VGND VPWR VGND sky130_ef_sc_hd__decap_12
XPHY_EDGE_ROW_121_2_Right_178 VGND VGND VPWR VPWR sky130_fd_sc_hd__decap_3
XTAP_TAPCELL_ROW_58_1_1134 VGND VPWR sky130_fd_sc_hd__tapvpwrvgnd_1
XFILLER_170_1147 VGND VGND VPWR VPWR sky130_fd_sc_hd__fill_1
XFILLER_135_1256 VPWR VGND VPWR VGND sky130_ef_sc_hd__decap_12
XTAP_TAPCELL_ROW_21_2_3116 VGND VPWR sky130_fd_sc_hd__tapvpwrvgnd_1
XFILLER_214_65 VPWR VGND VPWR VGND sky130_ef_sc_hd__decap_12
XFILLER_211_1133 VPWR VGND VPWR VGND sky130_ef_sc_hd__decap_12
XPHY_EDGE_ROW_197_Right_42 VGND VGND VPWR VPWR sky130_fd_sc_hd__decap_3
XFILLER_113_1510 VPWR VGND VPWR VGND sky130_ef_sc_hd__decap_12
XFILLER_22_1426 VPWR VGND VPWR VGND sky130_ef_sc_hd__decap_12
XFILLER_26_1562 VPWR VGND VPWR VGND sky130_ef_sc_hd__decap_12
XFILLER_61_1442 VPWR VGND VPWR VGND sky130_ef_sc_hd__decap_12
XFILLER_113_1554 VPWR VGND VPWR VGND sky130_ef_sc_hd__decap_12
XFILLER_2_1509 VPWR VGND VPWR VGND sky130_ef_sc_hd__decap_12
XTAP_TAPCELL_ROW_1_826 VGND VPWR sky130_fd_sc_hd__tapvpwrvgnd_1
XTAP_TAPCELL_ROW_1_815 VGND VPWR sky130_fd_sc_hd__tapvpwrvgnd_1
XFILLER_211_1177 VPWR VGND VPWR VGND sky130_ef_sc_hd__decap_12
XFILLER_96_1538 VPWR VGND VPWR VGND sky130_ef_sc_hd__decap_12
XFILLER_213_305 VPWR VGND VPWR VGND sky130_ef_sc_hd__decap_12
XFILLER_0_1233 VPWR VGND VPWR VGND sky130_ef_sc_hd__decap_12
XFILLER_213_349 VPWR VGND VPWR VGND sky130_ef_sc_hd__decap_12
XFILLER_179_721 VGND VGND VPWR VPWR sky130_fd_sc_hd__decap_6
XFILLER_179_765 VPWR VGND VPWR VGND sky130_ef_sc_hd__decap_12
XFILLER_194_713 VPWR VGND VPWR VGND sky130_ef_sc_hd__decap_12
XFILLER_181_1287 VGND VGND VPWR VPWR sky130_fd_sc_hd__fill_1
XFILLER_178_253 VPWR VGND VPWR VGND sky130_ef_sc_hd__decap_12
XPHY_EDGE_ROW_127_2_Left_559 VGND VGND VPWR VPWR sky130_fd_sc_hd__decap_3
XFILLER_55_1268 VGND VGND VPWR VPWR sky130_fd_sc_hd__decap_4
XFILLER_194_757 VPWR VGND VPWR VGND sky130_ef_sc_hd__decap_12
XFILLER_193_223 VGND VGND VPWR VPWR sky130_fd_sc_hd__fill_1
XTAP_TAPCELL_ROW_125_2_3790 VGND VPWR sky130_fd_sc_hd__tapvpwrvgnd_1
XFILLER_72_1582 VPWR VGND VPWR VGND sky130_ef_sc_hd__decap_12
XFILLER_33_1522 VPWR VGND VPWR VGND sky130_ef_sc_hd__decap_12
XANTENNA_fanout125_X net125 VGND VGND VPWR VPWR sky130_fd_sc_hd__diode_2
XFILLER_33_1566 VPWR VGND VPWR VGND sky130_ef_sc_hd__decap_12
XFILLER_181_429 VPWR VGND VPWR VGND sky130_ef_sc_hd__decap_12
XFILLER_175_39 VPWR VGND VPWR VGND sky130_ef_sc_hd__decap_12
XPHY_EDGE_ROW_83_2_Right_140 VGND VGND VPWR VPWR sky130_fd_sc_hd__decap_3
XFILLER_218_1309 VGND VGND VPWR VPWR sky130_fd_sc_hd__decap_6
XFILLER_108_77 VGND VGND VPWR VPWR sky130_fd_sc_hd__decap_6
XFILLER_68_15 VPWR VGND VPWR VGND sky130_ef_sc_hd__decap_12
XFILLER_1_826 VGND VGND VPWR VPWR sky130_fd_sc_hd__fill_1
XFILLER_1_804 VGND VGND VPWR VPWR sky130_fd_sc_hd__decap_8
XFILLER_191_27 VPWR VGND VPWR VGND sky130_ef_sc_hd__decap_12
XTAP_TAPCELL_ROW_117_2_3738 VGND VPWR sky130_fd_sc_hd__tapvpwrvgnd_1
XANTENNA__493__A1 net149 VGND VGND VPWR VPWR sky130_fd_sc_hd__diode_2
XFILLER_0_347 VGND VGND VPWR VPWR sky130_fd_sc_hd__decap_3
XFILLER_153_1378 VGND VGND VPWR VPWR sky130_fd_sc_hd__decap_6
XFILLER_124_65 VPWR VGND VPWR VGND sky130_ef_sc_hd__decap_12
XFILLER_5_1133 VPWR VGND VPWR VGND sky130_ef_sc_hd__decap_12
XFILLER_40_1526 VPWR VGND VPWR VGND sky130_ef_sc_hd__decap_12
XFILLER_216_121 VPWR VGND VPWR VGND sky130_ef_sc_hd__decap_12
XTAP_TAPCELL_ROW_65_2_3403 VGND VPWR sky130_fd_sc_hd__tapvpwrvgnd_1
XFILLER_5_1177 VPWR VGND VPWR VGND sky130_ef_sc_hd__decap_12
X_581_ clknet_3_3_0_clk _015_ VGND VGND VPWR VPWR u_ctrl.elem_idx\[0\] sky130_fd_sc_hd__dfxtp_4
XFILLER_216_165 VPWR VGND VPWR VGND sky130_ef_sc_hd__decap_12
XFILLER_205_839 VGND VGND VPWR VPWR sky130_fd_sc_hd__fill_1
XPHY_EDGE_ROW_201_Right_46 VGND VGND VPWR VPWR sky130_fd_sc_hd__decap_3
XFILLER_189_529 VPWR VGND VPWR VGND sky130_ef_sc_hd__decap_12
XFILLER_182_1029 VGND VGND VPWR VPWR sky130_fd_sc_hd__decap_6
XFILLER_140_53 VPWR VGND VPWR VGND sky130_ef_sc_hd__decap_12
XANTENNA__583__CLK clknet_3_3_0_clk VGND VGND VPWR VPWR sky130_fd_sc_hd__diode_2
XFILLER_164_1441 VPWR VGND VPWR VGND sky130_ef_sc_hd__decap_12
XFILLER_140_97 VPWR VGND VPWR VGND sky130_ef_sc_hd__decap_12
XFILLER_200_533 VPWR VGND VPWR VGND sky130_ef_sc_hd__decap_12
XFILLER_197_573 VPWR VGND VPWR VGND sky130_ef_sc_hd__decap_12
XFILLER_164_1485 VPWR VGND VPWR VGND sky130_ef_sc_hd__decap_12
XFILLER_160_1338 VPWR VGND VPWR VGND sky130_ef_sc_hd__decap_12
XFILLER_33_51 VGND VGND VPWR VPWR sky130_fd_sc_hd__decap_4
XFILLER_199_1537 VPWR VGND VPWR VGND sky130_ef_sc_hd__decap_12
XFILLER_149_51 VGND VGND VPWR VPWR sky130_fd_sc_hd__decap_4
XTAP_TAPCELL_ROW_14_2_3070 VGND VPWR sky130_fd_sc_hd__tapvpwrvgnd_1
XFILLER_205_1493 VPWR VGND VPWR VGND sky130_ef_sc_hd__decap_12
XFILLER_201_1313 VPWR VGND VPWR VGND sky130_ef_sc_hd__decap_12
XFILLER_184_245 VGND VGND VPWR VPWR sky130_fd_sc_hd__decap_6
XFILLER_144_109 VPWR VGND VPWR VGND sky130_ef_sc_hd__decap_12
XFILLER_201_1357 VPWR VGND VPWR VGND sky130_ef_sc_hd__decap_12
XFILLER_184_289 VPWR VGND VPWR VGND sky130_ef_sc_hd__decap_12
XFILLER_166_993 VPWR VGND VPWR VGND sky130_ef_sc_hd__decap_12
XPHY_EDGE_ROW_210_Right_55 VGND VGND VPWR VPWR sky130_fd_sc_hd__decap_3
XFILLER_4_653 VGND VGND VPWR VPWR sky130_fd_sc_hd__decap_8
XFILLER_193_1169 VGND VGND VPWR VPWR sky130_fd_sc_hd__decap_6
XFILLER_175_1581 VPWR VGND VPWR VGND sky130_ef_sc_hd__decap_12
XFILLER_171_1401 VPWR VGND VPWR VGND sky130_ef_sc_hd__decap_12
XFILLER_4_697 VGND VGND VPWR VPWR sky130_fd_sc_hd__fill_1
XFILLER_3_185 VPWR VGND VPWR VGND sky130_ef_sc_hd__decap_12
XANTENNA__484__A1 _169_ VGND VGND VPWR VPWR sky130_fd_sc_hd__diode_2
Xhold3 u_ctrl.state\[1\] VGND VGND VPWR VPWR net173 sky130_fd_sc_hd__dlygate4sd3_1
XPHY_EDGE_ROW_41_1_Right_627 VGND VGND VPWR VPWR sky130_fd_sc_hd__decap_3
XFILLER_212_1453 VPWR VGND VPWR VGND sky130_ef_sc_hd__decap_12
XFILLER_181_93 VPWR VGND VPWR VGND sky130_ef_sc_hd__decap_12
XFILLER_212_1497 VPWR VGND VPWR VGND sky130_ef_sc_hd__decap_12
XFILLER_208_699 VGND VGND VPWR VPWR sky130_fd_sc_hd__fill_1
XFILLER_78_1246 VPWR VGND VPWR VGND sky130_ef_sc_hd__decap_12
XFILLER_211_809 VPWR VGND VPWR VGND sky130_ef_sc_hd__decap_12
XFILLER_204_861 VGND VGND VPWR VPWR sky130_fd_sc_hd__decap_6
XFILLER_182_1541 VPWR VGND VPWR VGND sky130_ef_sc_hd__decap_12
XFILLER_95_3 VPWR VGND VPWR VGND sky130_ef_sc_hd__decap_12
XFILLER_176_713 VPWR VGND VPWR VGND sky130_ef_sc_hd__decap_12
Xu_sram.u_mem_163 VGND VGND VPWR VPWR u_sram.u_mem_163/HI net163 sky130_fd_sc_hd__conb_1
XFILLER_203_393 VPWR VGND VPWR VGND sky130_ef_sc_hd__decap_12
XFILLER_176_757 VPWR VGND VPWR VGND sky130_ef_sc_hd__decap_12
XFILLER_175_223 VGND VGND VPWR VPWR sky130_fd_sc_hd__fill_1
XFILLER_191_727 VGND VGND VPWR VPWR sky130_fd_sc_hd__fill_1
XFILLER_15_1274 VPWR VGND VPWR VGND sky130_ef_sc_hd__decap_12
XFILLER_102_1244 VGND VGND VPWR VPWR sky130_fd_sc_hd__fill_1
XFILLER_89_1342 VPWR VGND VPWR VGND sky130_ef_sc_hd__decap_12
XFILLER_89_1386 VPWR VGND VPWR VGND sky130_ef_sc_hd__decap_12
XFILLER_171_473 VPWR VGND VPWR VGND sky130_ef_sc_hd__decap_12
XTAP_TAPCELL_ROW_103_2_3646 VGND VPWR sky130_fd_sc_hd__tapvpwrvgnd_1
XFILLER_28_1602 VGND VGND VPWR VPWR sky130_fd_sc_hd__decap_3
XFILLER_219_909 VPWR VGND VPWR VGND sky130_ef_sc_hd__decap_12
XFILLER_174_1091 VGND VGND VPWR VPWR sky130_fd_sc_hd__fill_1
XFILLER_218_419 VGND VGND VPWR VPWR sky130_fd_sc_hd__fill_1
XFILLER_150_1518 VGND VGND VPWR VPWR sky130_fd_sc_hd__decap_6
XPHY_EDGE_ROW_122_2_Right_179 VGND VGND VPWR VPWR sky130_fd_sc_hd__decap_3
XFILLER_38_29 VPWR VGND VPWR VGND sky130_ef_sc_hd__decap_12
XFILLER_6_1453 VPWR VGND VPWR VGND sky130_ef_sc_hd__decap_12
XFILLER_26_1370 VPWR VGND VPWR VGND sky130_ef_sc_hd__decap_12
XTAP_TAPCELL_ROW_51_2_3311 VGND VPWR sky130_fd_sc_hd__tapvpwrvgnd_1
XFILLER_61_1272 VGND VGND VPWR VPWR sky130_fd_sc_hd__fill_1
XFILLER_113_1384 VGND VGND VPWR VPWR sky130_fd_sc_hd__fill_1
XFILLER_96_1302 VPWR VGND VPWR VGND sky130_ef_sc_hd__decap_12
XFILLER_2_1317 VPWR VGND VPWR VGND sky130_ef_sc_hd__decap_12
XFILLER_6_1497 VPWR VGND VPWR VGND sky130_ef_sc_hd__decap_12
XFILLER_214_625 VPWR VGND VPWR VGND sky130_ef_sc_hd__decap_12
XTAP_TAPCELL_ROW_181_1888 VGND VPWR sky130_fd_sc_hd__tapvpwrvgnd_1
XFILLER_148_1414 VPWR VGND VPWR VGND sky130_ef_sc_hd__decap_12
XFILLER_213_113 VPWR VGND VPWR VGND sky130_ef_sc_hd__decap_12
XTAP_TAPCELL_ROW_181_1899 VGND VPWR sky130_fd_sc_hd__tapvpwrvgnd_1
XFILLER_214_669 VPWR VGND VPWR VGND sky130_ef_sc_hd__decap_12
XFILLER_179_573 VPWR VGND VPWR VGND sky130_ef_sc_hd__decap_12
XFILLER_70_27 VGND VGND VPWR VPWR sky130_fd_sc_hd__fill_1
XFILLER_33_1330 VPWR VGND VPWR VGND sky130_ef_sc_hd__decap_12
XFILLER_186_27 VGND VGND VPWR VPWR sky130_fd_sc_hd__fill_1
XFILLER_166_245 VGND VGND VPWR VPWR sky130_fd_sc_hd__decap_6
XFILLER_120_1300 VGND VGND VPWR VPWR sky130_fd_sc_hd__fill_1
XFILLER_194_587 VGND VGND VPWR VPWR sky130_fd_sc_hd__fill_1
XFILLER_182_749 VGND VGND VPWR VPWR sky130_fd_sc_hd__decap_6
XFILLER_166_289 VPWR VGND VPWR VGND sky130_ef_sc_hd__decap_12
XFILLER_159_1510 VPWR VGND VPWR VGND sky130_ef_sc_hd__decap_12
XFILLER_126_109 VPWR VGND VPWR VGND sky130_ef_sc_hd__decap_12
XFILLER_181_237 VPWR VGND VPWR VGND sky130_ef_sc_hd__decap_12
XFILLER_159_1554 VPWR VGND VPWR VGND sky130_ef_sc_hd__decap_12
XFILLER_68_1426 VPWR VGND VPWR VGND sky130_ef_sc_hd__decap_12
XFILLER_218_1117 VPWR VGND VPWR VGND sky130_ef_sc_hd__decap_12
XFILLER_190_1309 VGND VGND VPWR VPWR sky130_fd_sc_hd__decap_6
XPHY_EDGE_ROW_84_2_Right_141 VGND VGND VPWR VPWR sky130_fd_sc_hd__decap_3
XFILLER_79_69 VPWR VGND VPWR VGND sky130_ef_sc_hd__decap_12
XFILLER_190_793 VPWR VGND VPWR VGND sky130_ef_sc_hd__decap_12
XFILLER_0_144 VGND VGND VPWR VPWR sky130_fd_sc_hd__fill_1
XFILLER_1_645 VGND VGND VPWR VPWR sky130_fd_sc_hd__fill_2
XFILLER_7_1217 VPWR VGND VPWR VGND sky130_ef_sc_hd__decap_12
XTAP_TAPCELL_ROW_162_2_4028 VGND VPWR sky130_fd_sc_hd__tapvpwrvgnd_1
XTAP_TAPCELL_ROW_147_2_3933 VGND VPWR sky130_fd_sc_hd__tapvpwrvgnd_1
XFILLER_95_57 VPWR VGND VPWR VGND sky130_ef_sc_hd__decap_12
XFILLER_0_166 VGND VGND VPWR VPWR sky130_fd_sc_hd__fill_2
XTAP_TAPCELL_ROW_5_940 VGND VPWR sky130_fd_sc_hd__tapvpwrvgnd_1
XFILLER_188_1205 VPWR VGND VPWR VGND sky130_ef_sc_hd__decap_12
XFILLER_131_1440 VGND VGND VPWR VPWR sky130_fd_sc_hd__fill_1
XFILLER_44_1470 VPWR VGND VPWR VGND sky130_ef_sc_hd__decap_12
XFILLER_217_441 VGND VGND VPWR VPWR sky130_fd_sc_hd__decap_6
XFILLER_79_1522 VPWR VGND VPWR VGND sky130_ef_sc_hd__decap_12
X_633_ clknet_3_3_0_clk _067_ VGND VGND VPWR VPWR u_ctrl.cmp_valid sky130_fd_sc_hd__dfxtp_1
XANTENNA_input15_A func_wdata[12] VGND VGND VPWR VPWR sky130_fd_sc_hd__diode_2
XFILLER_40_1356 VGND VGND VPWR VPWR sky130_fd_sc_hd__fill_1
XFILLER_79_1566 VPWR VGND VPWR VGND sky130_ef_sc_hd__decap_12
XFILLER_217_485 VPWR VGND VPWR VGND sky130_ef_sc_hd__decap_12
X_564_ net48 _213_ net138 VGND VGND VPWR VPWR _066_ sky130_fd_sc_hd__o21a_1
XFILLER_207_1511 VGND VGND VPWR VPWR sky130_fd_sc_hd__fill_1
XFILLER_189_337 VPWR VGND VPWR VGND sky130_ef_sc_hd__decap_12
X_495_ net149 _179_ net127 net135 _221_ VGND VGND VPWR VPWR _031_ sky130_fd_sc_hd__o311a_1
XFILLER_44_83 VGND VGND VPWR VPWR sky130_fd_sc_hd__fill_1
XFILLER_201_853 VPWR VGND VPWR VGND sky130_ef_sc_hd__decap_12
XFILLER_199_1301 VPWR VGND VPWR VGND sky130_ef_sc_hd__decap_12
XFILLER_198_893 VPWR VGND VPWR VGND sky130_ef_sc_hd__decap_12
XFILLER_125_1244 VPWR VGND VPWR VGND sky130_ef_sc_hd__decap_12
XFILLER_201_1121 VPWR VGND VPWR VGND sky130_ef_sc_hd__decap_12
XFILLER_201_897 VPWR VGND VPWR VGND sky130_ef_sc_hd__decap_12
XFILLER_200_363 VGND VGND VPWR VPWR sky130_fd_sc_hd__fill_1
XFILLER_199_1345 VPWR VGND VPWR VGND sky130_ef_sc_hd__decap_12
XFILLER_16_1550 VPWR VGND VPWR VGND sky130_ef_sc_hd__decap_12
XTAP_TAPCELL_ROW_191_2195 VGND VPWR sky130_fd_sc_hd__tapvpwrvgnd_1
XTAP_TAPCELL_ROW_191_2184 VGND VPWR sky130_fd_sc_hd__tapvpwrvgnd_1
XTAP_TAPCELL_ROW_191_2173 VGND VPWR sky130_fd_sc_hd__tapvpwrvgnd_1
XFILLER_173_727 VGND VGND VPWR VPWR sky130_fd_sc_hd__fill_1
XFILLER_142_1580 VGND VGND VPWR VPWR sky130_fd_sc_hd__fill_1
XFILLER_12_1414 VPWR VGND VPWR VGND sky130_ef_sc_hd__decap_12
XFILLER_16_1594 VGND VGND VPWR VPWR sky130_fd_sc_hd__decap_8
XFILLER_51_1496 VGND VGND VPWR VPWR sky130_fd_sc_hd__fill_1
XTAP_TAPCELL_ROW_216_2891 VGND VPWR sky130_fd_sc_hd__tapvpwrvgnd_1
XFILLER_86_1526 VPWR VGND VPWR VGND sky130_ef_sc_hd__decap_12
XTAP_TAPCELL_ROW_212_2777 VGND VPWR sky130_fd_sc_hd__tapvpwrvgnd_1
XFILLER_5_55 VGND VGND VPWR VPWR sky130_fd_sc_hd__fill_1
XTAP_TAPCELL_ROW_212_2788 VGND VPWR sky130_fd_sc_hd__tapvpwrvgnd_1
XFILLER_171_1231 VGND VGND VPWR VPWR sky130_fd_sc_hd__fill_1
XFILLER_84_1294 VGND VGND VPWR VPWR sky130_fd_sc_hd__decap_6
XFILLER_45_1256 VPWR VGND VPWR VGND sky130_ef_sc_hd__decap_12
XFILLER_10_3 VPWR VGND VPWR VGND sky130_ef_sc_hd__decap_12
XFILLER_23_1510 VPWR VGND VPWR VGND sky130_ef_sc_hd__decap_12
XTAP_TAPCELL_ROW_36_2_3213 VGND VPWR sky130_fd_sc_hd__tapvpwrvgnd_1
XFILLER_212_1261 VPWR VGND VPWR VGND sky130_ef_sc_hd__decap_12
XFILLER_209_953 VPWR VGND VPWR VGND sky130_ef_sc_hd__decap_12
XFILLER_110_1524 VGND VGND VPWR VPWR sky130_fd_sc_hd__fill_1
XFILLER_23_1554 VPWR VGND VPWR VGND sky130_ef_sc_hd__decap_12
XPHY_EDGE_ROW_42_1_Right_628 VGND VGND VPWR VPWR sky130_fd_sc_hd__decap_3
XFILLER_211_617 VPWR VGND VPWR VGND sky130_ef_sc_hd__decap_12
XFILLER_211_55 VGND VGND VPWR VPWR sky130_fd_sc_hd__fill_1
XFILLER_165_1057 VGND VGND VPWR VPWR sky130_fd_sc_hd__decap_6
XFILLER_195_329 VGND VGND VPWR VPWR sky130_fd_sc_hd__decap_6
XFILLER_182_1371 VGND VGND VPWR VPWR sky130_fd_sc_hd__fill_1
XFILLER_143_1322 VGND VGND VPWR VPWR sky130_fd_sc_hd__decap_6
XFILLER_91_1232 VPWR VGND VPWR VGND sky130_ef_sc_hd__decap_12
XFILLER_143_1366 VPWR VGND VPWR VGND sky130_ef_sc_hd__decap_12
XFILLER_91_1298 VPWR VGND VPWR VGND sky130_ef_sc_hd__decap_12
XTAP_TAPCELL_ROW_8_1_3026 VGND VPWR sky130_fd_sc_hd__tapvpwrvgnd_1
XFILLER_178_1429 VPWR VGND VPWR VGND sky130_ef_sc_hd__decap_12
XFILLER_176_587 VGND VGND VPWR VPWR sky130_fd_sc_hd__fill_1
XFILLER_164_749 VGND VGND VPWR VPWR sky130_fd_sc_hd__decap_6
XFILLER_108_109 VPWR VGND VPWR VGND sky130_ef_sc_hd__decap_12
XTAP_TAPCELL_ROW_174_1692 VGND VPWR sky130_fd_sc_hd__tapvpwrvgnd_1
XFILLER_163_237 VPWR VGND VPWR VGND sky130_ef_sc_hd__decap_12
XTAP_TAPCELL_ROW_170_1578 VGND VPWR sky130_fd_sc_hd__tapvpwrvgnd_1
XFILLER_172_1017 VPWR VGND VPWR VGND sky130_ef_sc_hd__decap_12
XFILLER_172_793 VPWR VGND VPWR VGND sky130_ef_sc_hd__decap_12
XFILLER_171_281 VPWR VGND VPWR VGND sky130_ef_sc_hd__decap_12
XTAP_TAPCELL_ROW_170_1589 VGND VPWR sky130_fd_sc_hd__tapvpwrvgnd_1
XFILLER_176_1197 VGND VGND VPWR VPWR sky130_fd_sc_hd__decap_6
XFILLER_172_29 VPWR VGND VPWR VGND sky130_ef_sc_hd__decap_12
XTAP_TAPCELL_ROW_133_2_3841 VGND VPWR sky130_fd_sc_hd__tapvpwrvgnd_1
XFILLER_8_1526 VPWR VGND VPWR VGND sky130_ef_sc_hd__decap_12
XFILLER_154_1462 VGND VGND VPWR VPWR sky130_fd_sc_hd__decap_6
XTAP_TAPCELL_ROW_26_1_1069 VGND VPWR sky130_fd_sc_hd__tapvpwrvgnd_1
XANTENNA_input7_A func_addr[4] VGND VGND VPWR VPWR sky130_fd_sc_hd__diode_2
XFILLER_189_1525 VPWR VGND VPWR VGND sky130_ef_sc_hd__decap_12
XFILLER_150_1326 VPWR VGND VPWR VGND sky130_ef_sc_hd__decap_12
XFILLER_63_1378 VGND VGND VPWR VPWR sky130_fd_sc_hd__decap_6
XFILLER_65_27 VPWR VGND VPWR VGND sky130_ef_sc_hd__decap_12
XFILLER_6_1261 VPWR VGND VPWR VGND sky130_ef_sc_hd__decap_12
XFILLER_189_1569 VPWR VGND VPWR VGND sky130_ef_sc_hd__decap_12
XFILLER_2_1147 VGND VGND VPWR VPWR sky130_fd_sc_hd__fill_1
XFILLER_215_945 VGND VGND VPWR VPWR sky130_fd_sc_hd__decap_6
XFILLER_214_433 VPWR VGND VPWR VGND sky130_ef_sc_hd__decap_12
XFILLER_183_1113 VGND VGND VPWR VPWR sky130_fd_sc_hd__decap_6
XANTENNA_clkbuf_3_4_0_clk_A clknet_0_clk VGND VGND VPWR VPWR sky130_fd_sc_hd__diode_2
XFILLER_215_989 VPWR VGND VPWR VGND sky130_ef_sc_hd__decap_12
XFILLER_183_1157 VPWR VGND VPWR VGND sky130_ef_sc_hd__decap_12
XFILLER_148_1244 VGND VGND VPWR VPWR sky130_fd_sc_hd__fill_1
XFILLER_121_55 VGND VGND VPWR VPWR sky130_fd_sc_hd__fill_1
XFILLER_81_15 VPWR VGND VPWR VGND sky130_ef_sc_hd__decap_12
XFILLER_214_477 VPWR VGND VPWR VGND sky130_ef_sc_hd__decap_12
XFILLER_201_105 VGND VGND VPWR VPWR sky130_fd_sc_hd__decap_6
XFILLER_197_15 VPWR VGND VPWR VGND sky130_ef_sc_hd__decap_12
XFILLER_186_307 VGND VGND VPWR VPWR sky130_fd_sc_hd__fill_1
X_280_ b_addr\[3\] b_addr\[2\] b_addr\[1\] b_addr\[0\] VGND VGND VPWR VPWR _078_ sky130_fd_sc_hd__and4_1
XFILLER_201_149 VPWR VGND VPWR VGND sky130_ef_sc_hd__decap_12
XFILLER_198_189 VGND VGND VPWR VPWR sky130_fd_sc_hd__decap_6
XFILLER_195_841 VPWR VGND VPWR VGND sky130_ef_sc_hd__decap_12
XFILLER_161_1422 VPWR VGND VPWR VGND sky130_ef_sc_hd__decap_12
XFILLER_70_1338 VPWR VGND VPWR VGND sky130_ef_sc_hd__decap_12
XFILLER_161_1466 VPWR VGND VPWR VGND sky130_ef_sc_hd__decap_12
XFILLER_122_1406 VGND VGND VPWR VPWR sky130_fd_sc_hd__decap_6
XANTENNA__621__CLK clknet_3_6_0_clk VGND VGND VPWR VPWR sky130_fd_sc_hd__diode_2
XFILLER_212_3 VPWR VGND VPWR VGND sky130_ef_sc_hd__decap_12
XFILLER_202_1441 VPWR VGND VPWR VGND sky130_ef_sc_hd__decap_12
XFILLER_182_513 VPWR VGND VPWR VGND sky130_ef_sc_hd__decap_12
XTAP_TAPCELL_ROW_81_1_1179 VGND VPWR sky130_fd_sc_hd__tapvpwrvgnd_1
XFILLER_202_1485 VPWR VGND VPWR VGND sky130_ef_sc_hd__decap_12
XFILLER_182_557 VPWR VGND VPWR VGND sky130_ef_sc_hd__decap_12
XFILLER_5_225 VPWR VGND VPWR VGND sky130_ef_sc_hd__decap_12
XFILLER_6_737 VPWR VGND VPWR VGND sky130_ef_sc_hd__decap_12
XFILLER_146_41 VPWR VGND VPWR VGND sky130_ef_sc_hd__decap_12
XFILLER_30_74 VGND VGND VPWR VPWR sky130_fd_sc_hd__decap_8
XFILLER_194_1253 VGND VGND VPWR VPWR sky130_fd_sc_hd__decap_6
XFILLER_190_1117 VPWR VGND VPWR VGND sky130_ef_sc_hd__decap_12
XFILLER_159_1384 VGND VGND VPWR VPWR sky130_fd_sc_hd__fill_1
XPHY_EDGE_ROW_85_2_Right_142 VGND VGND VPWR VPWR sky130_fd_sc_hd__decap_3
XFILLER_30_85 VGND VGND VPWR VPWR sky130_fd_sc_hd__fill_2
XFILLER_194_1297 VPWR VGND VPWR VGND sky130_ef_sc_hd__decap_12
XFILLER_146_85 VPWR VGND VPWR VGND sky130_ef_sc_hd__decap_12
XFILLER_1_420 VGND VGND VPWR VPWR sky130_fd_sc_hd__fill_1
XFILLER_81_1434 VGND VGND VPWR VPWR sky130_fd_sc_hd__decap_6
XTAP_TAPCELL_ROW_22_2_3121 VGND VPWR sky130_fd_sc_hd__tapvpwrvgnd_1
XFILLER_209_205 VPWR VGND VPWR VGND sky130_ef_sc_hd__decap_12
XFILLER_172_1595 VGND VGND VPWR VPWR sky130_fd_sc_hd__fill_1
XFILLER_133_1546 VGND VGND VPWR VPWR sky130_fd_sc_hd__decap_6
XFILLER_81_1478 VPWR VGND VPWR VGND sky130_ef_sc_hd__decap_12
XFILLER_213_1581 VPWR VGND VPWR VGND sky130_ef_sc_hd__decap_12
XFILLER_209_249 VPWR VGND VPWR VGND sky130_ef_sc_hd__decap_12
XFILLER_188_1035 VGND VGND VPWR VPWR sky130_fd_sc_hd__fill_1
XFILLER_206_923 VGND VGND VPWR VPWR sky130_fd_sc_hd__fill_1
XFILLER_79_1330 VPWR VGND VPWR VGND sky130_ef_sc_hd__decap_12
XFILLER_217_293 VPWR VGND VPWR VGND sky130_ef_sc_hd__decap_12
XTAP_TAPCELL_ROW_205_2592 VGND VPWR sky130_fd_sc_hd__tapvpwrvgnd_1
XTAP_TAPCELL_ROW_205_2581 VGND VPWR sky130_fd_sc_hd__tapvpwrvgnd_1
XTAP_TAPCELL_ROW_205_2570 VGND VPWR sky130_fd_sc_hd__tapvpwrvgnd_1
X_616_ clknet_3_6_0_clk _050_ VGND VGND VPWR VPWR net73 sky130_fd_sc_hd__dfxtp_1
XTAP_TAPCELL_ROW_201_2456 VGND VPWR sky130_fd_sc_hd__tapvpwrvgnd_1
X_547_ net151 _170_ net128 net138 _247_ VGND VGND VPWR VPWR _057_ sky130_fd_sc_hd__o311a_1
XPHY_EDGE_ROW_19_2_Right_76 VGND VGND VPWR VPWR sky130_fd_sc_hd__decap_3
XFILLER_55_93 VPWR VGND VPWR VGND sky130_ef_sc_hd__decap_12
XTAP_TAPCELL_ROW_201_2478 VGND VPWR sky130_fd_sc_hd__tapvpwrvgnd_1
XTAP_TAPCELL_ROW_201_2467 VGND VPWR sky130_fd_sc_hd__tapvpwrvgnd_1
XTAP_TAPCELL_ROW_197_2360 VGND VPWR sky130_fd_sc_hd__tapvpwrvgnd_1
XFILLER_189_167 VGND VGND VPWR VPWR sky130_fd_sc_hd__fill_1
XFILLER_127_1328 VGND VGND VPWR VPWR sky130_fd_sc_hd__fill_1
XTAP_TAPCELL_ROW_193_2246 VGND VPWR sky130_fd_sc_hd__tapvpwrvgnd_1
XTAP_TAPCELL_ROW_193_2235 VGND VPWR sky130_fd_sc_hd__tapvpwrvgnd_1
XFILLER_177_329 VGND VGND VPWR VPWR sky130_fd_sc_hd__decap_6
XFILLER_92_1574 VGND VGND VPWR VPWR sky130_fd_sc_hd__decap_6
X_478_ _203_ _204_ _208_ _209_ VGND VGND VPWR VPWR _210_ sky130_fd_sc_hd__or4_1
XTAP_TAPCELL_ROW_218_2964 VGND VPWR sky130_fd_sc_hd__tapvpwrvgnd_1
XTAP_TAPCELL_ROW_218_2953 VGND VPWR sky130_fd_sc_hd__tapvpwrvgnd_1
XTAP_TAPCELL_ROW_218_2942 VGND VPWR sky130_fd_sc_hd__tapvpwrvgnd_1
XFILLER_140_1506 VPWR VGND VPWR VGND sky130_ef_sc_hd__decap_12
XFILLER_71_81 VPWR VGND VPWR VGND sky130_ef_sc_hd__decap_12
XTAP_TAPCELL_ROW_214_2828 VGND VPWR sky130_fd_sc_hd__tapvpwrvgnd_1
XFILLER_187_81 VPWR VGND VPWR VGND sky130_ef_sc_hd__decap_12
XFILLER_185_373 VPWR VGND VPWR VGND sky130_ef_sc_hd__decap_12
XTAP_TAPCELL_ROW_214_2839 VGND VPWR sky130_fd_sc_hd__tapvpwrvgnd_1
XFILLER_199_1175 VGND VGND VPWR VPWR sky130_fd_sc_hd__fill_1
XTAP_TAPCELL_ROW_138_2_3878 VGND VPWR sky130_fd_sc_hd__tapvpwrvgnd_1
XFILLER_12_1244 VGND VGND VPWR VPWR sky130_fd_sc_hd__fill_1
XFILLER_58_3 VPWR VGND VPWR VGND sky130_ef_sc_hd__decap_12
XFILLER_86_1356 VGND VGND VPWR VPWR sky130_fd_sc_hd__fill_1
XFILLER_173_1337 VGND VGND VPWR VPWR sky130_fd_sc_hd__decap_6
XFILLER_138_1468 VGND VGND VPWR VPWR sky130_fd_sc_hd__fill_1
XTAP_TAPCELL_ROW_118_2_3743 VGND VPWR sky130_fd_sc_hd__tapvpwrvgnd_1
XFILLER_151_1602 VGND VGND VPWR VPWR sky130_fd_sc_hd__decap_3
XFILLER_206_77 VGND VGND VPWR VPWR sky130_fd_sc_hd__decap_6
XPHY_EDGE_ROW_136_2_Left_568 VGND VGND VPWR VPWR sky130_fd_sc_hd__decap_3
XFILLER_60_1518 VGND VGND VPWR VPWR sky130_fd_sc_hd__decap_6
XFILLER_3_1401 VPWR VGND VPWR VGND sky130_ef_sc_hd__decap_12
XFILLER_7_1581 VPWR VGND VPWR VGND sky130_ef_sc_hd__decap_12
XFILLER_212_1091 VGND VGND VPWR VPWR sky130_fd_sc_hd__fill_1
XFILLER_167_1119 VGND VGND VPWR VPWR sky130_fd_sc_hd__fill_1
XFILLER_23_1384 VGND VGND VPWR VPWR sky130_fd_sc_hd__fill_1
XPHY_EDGE_ROW_43_1_Right_629 VGND VGND VPWR VPWR sky130_fd_sc_hd__decap_3
XFILLER_209_783 VGND VGND VPWR VPWR sky130_fd_sc_hd__fill_1
XTAP_TAPCELL_ROW_163_1382 VGND VPWR sky130_fd_sc_hd__tapvpwrvgnd_1
XTAP_TAPCELL_ROW_163_1371 VGND VPWR sky130_fd_sc_hd__tapvpwrvgnd_1
XTAP_TAPCELL_ROW_163_1360 VGND VPWR sky130_fd_sc_hd__tapvpwrvgnd_1
XPHY_EDGE_ROW_73_2_Left_505 VGND VGND VPWR VPWR sky130_fd_sc_hd__decap_3
XFILLER_58_1414 VPWR VGND VPWR VGND sky130_ef_sc_hd__decap_12
XFILLER_208_1105 VPWR VGND VPWR VGND sky130_ef_sc_hd__decap_12
XTAP_TAPCELL_ROW_163_1393 VGND VPWR sky130_fd_sc_hd__tapvpwrvgnd_1
XFILLER_97_1496 VGND VGND VPWR VPWR sky130_fd_sc_hd__fill_1
XFILLER_212_937 VPWR VGND VPWR VGND sky130_ef_sc_hd__decap_12
XFILLER_208_1149 VPWR VGND VPWR VGND sky130_ef_sc_hd__decap_12
XFILLER_184_1477 VGND VGND VPWR VPWR sky130_fd_sc_hd__decap_6
XFILLER_168_307 VGND VGND VPWR VPWR sky130_fd_sc_hd__fill_1
XANTENNA_fanout152_A net153 VGND VGND VPWR VPWR sky130_fd_sc_hd__diode_2
XFILLER_50_121 VGND VGND VPWR VPWR sky130_fd_sc_hd__decap_6
XFILLER_211_447 VGND VGND VPWR VPWR sky130_fd_sc_hd__fill_1
XFILLER_195_137 VPWR VGND VPWR VGND sky130_ef_sc_hd__decap_12
XFILLER_177_841 VPWR VGND VPWR VGND sky130_ef_sc_hd__decap_12
XTAP_TAPCELL_ROW_176_1754 VGND VPWR sky130_fd_sc_hd__tapvpwrvgnd_1
XTAP_TAPCELL_ROW_176_1743 VGND VPWR sky130_fd_sc_hd__tapvpwrvgnd_1
XFILLER_192_811 VGND VGND VPWR VPWR sky130_fd_sc_hd__fill_1
XTAP_TAPCELL_ROW_176_1765 VGND VPWR sky130_fd_sc_hd__tapvpwrvgnd_1
XTAP_TAPCELL_ROW_172_1629 VGND VPWR sky130_fd_sc_hd__tapvpwrvgnd_1
XFILLER_164_513 VPWR VGND VPWR VGND sky130_ef_sc_hd__decap_12
XFILLER_108_1294 VGND VGND VPWR VPWR sky130_fd_sc_hd__decap_6
XFILLER_30_1300 VGND VGND VPWR VPWR sky130_fd_sc_hd__fill_1
XFILLER_164_557 VPWR VGND VPWR VGND sky130_ef_sc_hd__decap_12
XFILLER_69_1510 VPWR VGND VPWR VGND sky130_ef_sc_hd__decap_12
XFILLER_219_1201 VGND VGND VPWR VPWR sky130_fd_sc_hd__decap_3
XFILLER_178_1259 VGND VGND VPWR VPWR sky130_fd_sc_hd__fill_1
XFILLER_69_1554 VPWR VGND VPWR VGND sky130_ef_sc_hd__decap_12
XFILLER_219_1245 VPWR VGND VPWR VGND sky130_ef_sc_hd__decap_12
XFILLER_183_39 VPWR VGND VPWR VGND sky130_ef_sc_hd__decap_12
XFILLER_156_1524 VGND VGND VPWR VPWR sky130_fd_sc_hd__fill_1
XFILLER_219_1289 VPWR VGND VPWR VGND sky130_ef_sc_hd__decap_12
XFILLER_191_1437 VPWR VGND VPWR VGND sky130_ef_sc_hd__decap_12
XFILLER_76_15 VPWR VGND VPWR VGND sky130_ef_sc_hd__decap_12
XFILLER_154_1270 VPWR VGND VPWR VGND sky130_ef_sc_hd__decap_12
XFILLER_116_77 VGND VGND VPWR VPWR sky130_fd_sc_hd__decap_6
XFILLER_115_1232 VPWR VGND VPWR VGND sky130_ef_sc_hd__decap_12
XFILLER_8_1356 VGND VGND VPWR VPWR sky130_fd_sc_hd__fill_1
XFILLER_207_709 VPWR VGND VPWR VGND sky130_ef_sc_hd__decap_12
XFILLER_41_1440 VGND VGND VPWR VPWR sky130_fd_sc_hd__fill_1
XFILLER_115_1298 VPWR VGND VPWR VGND sky130_ef_sc_hd__decap_12
XFILLER_6_1091 VGND VGND VPWR VPWR sky130_fd_sc_hd__fill_1
XFILLER_189_1399 VGND VGND VPWR VPWR sky130_fd_sc_hd__fill_1
XFILLER_132_65 VPWR VGND VPWR VGND sky130_ef_sc_hd__decap_12
XFILLER_215_753 VPWR VGND VPWR VGND sky130_ef_sc_hd__decap_12
XFILLER_162_3 VPWR VGND VPWR VGND sky130_ef_sc_hd__decap_12
XTAP_TAPCELL_ROW_157_2_4001 VGND VPWR sky130_fd_sc_hd__tapvpwrvgnd_1
X_401_ b_addr\[3\] _102_ VGND VGND VPWR VPWR _138_ sky130_fd_sc_hd__and2_1
XFILLER_215_797 VPWR VGND VPWR VGND sky130_ef_sc_hd__decap_12
X_332_ b_addr\[7\] net10 net140 VGND VGND VPWR VPWR s_addr\[7\] sky130_fd_sc_hd__mux2_1
XFILLER_202_469 VGND VGND VPWR VPWR sky130_fd_sc_hd__decap_6
XFILLER_126_1350 VGND VGND VPWR VPWR sky130_fd_sc_hd__decap_6
XFILLER_74_1282 VPWR VGND VPWR VGND sky130_ef_sc_hd__decap_12
XFILLER_35_1244 VPWR VGND VPWR VGND sky130_ef_sc_hd__decap_12
XFILLER_195_671 VGND VGND VPWR VPWR sky130_fd_sc_hd__fill_1
XFILLER_183_833 VGND VGND VPWR VPWR sky130_fd_sc_hd__decap_6
XFILLER_167_373 VPWR VGND VPWR VGND sky130_ef_sc_hd__decap_12
XFILLER_161_1274 VPWR VGND VPWR VGND sky130_ef_sc_hd__decap_12
XFILLER_126_1394 VPWR VGND VPWR VGND sky130_ef_sc_hd__decap_12
XTAP_TAPCELL_ROW_124_2_3786 VGND VPWR sky130_fd_sc_hd__tapvpwrvgnd_1
XFILLER_196_1315 VGND VGND VPWR VPWR sky130_fd_sc_hd__fill_1
XFILLER_182_321 VPWR VGND VPWR VGND sky130_ef_sc_hd__decap_12
XFILLER_157_51 VGND VGND VPWR VPWR sky130_fd_sc_hd__decap_4
XFILLER_122_1258 VPWR VGND VPWR VGND sky130_ef_sc_hd__decap_12
XFILLER_6_545 VPWR VGND VPWR VGND sky130_ef_sc_hd__decap_12
XFILLER_41_51 VGND VGND VPWR VPWR sky130_fd_sc_hd__decap_4
XFILLER_52_1580 VGND VGND VPWR VPWR sky130_fd_sc_hd__fill_1
XFILLER_183_877 VPWR VGND VPWR VGND sky130_ef_sc_hd__decap_12
XFILLER_182_365 VPWR VGND VPWR VGND sky130_ef_sc_hd__decap_12
XTAP_TAPCELL_ROW_92_2_3575 VGND VPWR sky130_fd_sc_hd__tapvpwrvgnd_1
XFILLER_194_1061 VPWR VGND VPWR VGND sky130_ef_sc_hd__decap_12
XTAP_TAPCELL_ROW_104_2_3651 VGND VPWR sky130_fd_sc_hd__tapvpwrvgnd_1
XFILLER_6_589 VGND VGND VPWR VPWR sky130_fd_sc_hd__decap_6
XTAP_TAPCELL_ROW_186_2050 VGND VPWR sky130_fd_sc_hd__tapvpwrvgnd_1
XTAP_TAPCELL_ROW_104_1_1225 VGND VPWR sky130_fd_sc_hd__tapvpwrvgnd_1
XPHY_EDGE_ROW_86_2_Right_143 VGND VGND VPWR VPWR sky130_fd_sc_hd__decap_3
XFILLER_81_1220 VPWR VGND VPWR VGND sky130_ef_sc_hd__decap_12
XFILLER_1_250 VGND VGND VPWR VPWR sky130_fd_sc_hd__decap_8
XFILLER_137_1490 VGND VGND VPWR VPWR sky130_fd_sc_hd__decap_6
XFILLER_133_1310 VPWR VGND VPWR VGND sky130_ef_sc_hd__decap_12
XFILLER_2_795 VGND VGND VPWR VPWR sky130_fd_sc_hd__fill_1
XTAP_TAPCELL_ROW_207_2643 VGND VPWR sky130_fd_sc_hd__tapvpwrvgnd_1
XTAP_TAPCELL_ROW_207_2632 VGND VPWR sky130_fd_sc_hd__tapvpwrvgnd_1
XFILLER_133_1354 VPWR VGND VPWR VGND sky130_ef_sc_hd__decap_12
XFILLER_81_1286 VPWR VGND VPWR VGND sky130_ef_sc_hd__decap_12
XTAP_TAPCELL_ROW_203_2518 VGND VPWR sky130_fd_sc_hd__tapvpwrvgnd_1
XTAP_TAPCELL_ROW_199_2400 VGND VPWR sky130_fd_sc_hd__tapvpwrvgnd_1
XFILLER_133_1398 VPWR VGND VPWR VGND sky130_ef_sc_hd__decap_12
XFILLER_20_1524 VGND VGND VPWR VPWR sky130_fd_sc_hd__fill_1
XTAP_TAPCELL_ROW_203_2529 VGND VPWR sky130_fd_sc_hd__tapvpwrvgnd_1
XTAP_TAPCELL_ROW_199_2422 VGND VPWR sky130_fd_sc_hd__tapvpwrvgnd_1
XTAP_TAPCELL_ROW_199_2411 VGND VPWR sky130_fd_sc_hd__tapvpwrvgnd_1
XFILLER_209_1425 VPWR VGND VPWR VGND sky130_ef_sc_hd__decap_12
XTAP_TAPCELL_ROW_195_2308 VGND VPWR sky130_fd_sc_hd__tapvpwrvgnd_1
XFILLER_166_1141 VGND VGND VPWR VPWR sky130_fd_sc_hd__decap_6
XFILLER_209_1469 VPWR VGND VPWR VGND sky130_ef_sc_hd__decap_12
XFILLER_166_1185 VPWR VGND VPWR VGND sky130_ef_sc_hd__decap_12
XFILLER_53_1322 VGND VGND VPWR VPWR sky130_fd_sc_hd__decap_6
XFILLER_202_981 VPWR VGND VPWR VGND sky130_ef_sc_hd__decap_12
XFILLER_177_137 VPWR VGND VPWR VGND sky130_ef_sc_hd__decap_12
XFILLER_144_1450 VPWR VGND VPWR VGND sky130_ef_sc_hd__decap_12
XFILLER_92_1382 VPWR VGND VPWR VGND sky130_ef_sc_hd__decap_12
XFILLER_203_1057 VGND VGND VPWR VPWR sky130_fd_sc_hd__decap_6
XFILLER_179_1513 VPWR VGND VPWR VGND sky130_ef_sc_hd__decap_12
XFILLER_174_811 VGND VGND VPWR VPWR sky130_fd_sc_hd__fill_1
XFILLER_144_1494 VPWR VGND VPWR VGND sky130_ef_sc_hd__decap_12
XFILLER_140_1314 VPWR VGND VPWR VGND sky130_ef_sc_hd__decap_12
XFILLER_105_1434 VGND VGND VPWR VPWR sky130_fd_sc_hd__decap_6
XFILLER_53_1366 VPWR VGND VPWR VGND sky130_ef_sc_hd__decap_12
XFILLER_186_693 VGND VGND VPWR VPWR sky130_fd_sc_hd__decap_6
XFILLER_185_181 VPWR VGND VPWR VGND sky130_ef_sc_hd__decap_12
XFILLER_140_1358 VPWR VGND VPWR VGND sky130_ef_sc_hd__decap_12
XFILLER_105_1478 VPWR VGND VPWR VGND sky130_ef_sc_hd__decap_12
XFILLER_173_1101 VPWR VGND VPWR VGND sky130_ef_sc_hd__decap_12
Xoutput113 net113 VGND VGND VPWR VPWR func_rdata[31] sky130_fd_sc_hd__buf_2
Xoutput102 net102 VGND VGND VPWR VPWR func_rdata[21] sky130_fd_sc_hd__buf_2
XFILLER_216_1429 VPWR VGND VPWR VGND sky130_ef_sc_hd__decap_12
XFILLER_177_1281 VGND VGND VPWR VPWR sky130_fd_sc_hd__decap_6
XFILLER_138_1232 VPWR VGND VPWR VGND sky130_ef_sc_hd__decap_12
XFILLER_173_1145 VPWR VGND VPWR VGND sky130_ef_sc_hd__decap_12
XFILLER_173_1189 VPWR VGND VPWR VGND sky130_ef_sc_hd__decap_12
XFILLER_155_1590 VPWR VGND VPWR VGND sky130_ef_sc_hd__decap_12
XFILLER_151_1410 VPWR VGND VPWR VGND sky130_ef_sc_hd__decap_12
XFILLER_64_1462 VGND VGND VPWR VPWR sky130_fd_sc_hd__decap_6
XFILLER_210_1017 VPWR VGND VPWR VGND sky130_ef_sc_hd__decap_12
XTAP_TAPCELL_ROW_165_1433 VGND VPWR sky130_fd_sc_hd__tapvpwrvgnd_1
XFILLER_151_1454 VPWR VGND VPWR VGND sky130_ef_sc_hd__decap_12
XFILLER_116_1574 VGND VGND VPWR VPWR sky130_fd_sc_hd__decap_6
XFILLER_60_1326 VPWR VGND VPWR VGND sky130_ef_sc_hd__decap_12
XFILLER_214_1197 VGND VGND VPWR VPWR sky130_fd_sc_hd__decap_6
XTAP_TAPCELL_ROW_165_1455 VGND VPWR sky130_fd_sc_hd__tapvpwrvgnd_1
XTAP_TAPCELL_ROW_165_1444 VGND VPWR sky130_fd_sc_hd__tapvpwrvgnd_1
XFILLER_151_1498 VPWR VGND VPWR VGND sky130_ef_sc_hd__decap_12
XFILLER_112_1438 VPWR VGND VPWR VGND sky130_ef_sc_hd__decap_12
XFILLER_46_29 VPWR VGND VPWR VGND sky130_ef_sc_hd__decap_12
XFILLER_186_1539 VGND VGND VPWR VPWR sky130_fd_sc_hd__fill_1
XFILLER_3_1231 VGND VGND VPWR VPWR sky130_fd_sc_hd__fill_1
XFILLER_212_701 VPWR VGND VPWR VGND sky130_ef_sc_hd__decap_12
XFILLER_184_1241 VPWR VGND VPWR VGND sky130_ef_sc_hd__decap_12
XFILLER_180_1105 VPWR VGND VPWR VGND sky130_ef_sc_hd__decap_12
XTAP_TAPCELL_ROW_178_1805 VGND VPWR sky130_fd_sc_hd__tapvpwrvgnd_1
XFILLER_58_1244 VGND VGND VPWR VPWR sky130_fd_sc_hd__fill_1
XFILLER_196_413 VGND VGND VPWR VPWR sky130_fd_sc_hd__decap_6
XFILLER_184_1285 VPWR VGND VPWR VGND sky130_ef_sc_hd__decap_12
XTAP_TAPCELL_ROW_178_1827 VGND VPWR sky130_fd_sc_hd__tapvpwrvgnd_1
XTAP_TAPCELL_ROW_178_1816 VGND VPWR sky130_fd_sc_hd__tapvpwrvgnd_1
XFILLER_196_457 VPWR VGND VPWR VGND sky130_ef_sc_hd__decap_12
XFILLER_180_1149 VPWR VGND VPWR VGND sky130_ef_sc_hd__decap_12
XFILLER_162_1550 VPWR VGND VPWR VGND sky130_ef_sc_hd__decap_12
XTAP_TAPCELL_ROW_110_2_3694 VGND VPWR sky130_fd_sc_hd__tapvpwrvgnd_1
XFILLER_71_1422 VPWR VGND VPWR VGND sky130_ef_sc_hd__decap_12
XFILLER_177_671 VGND VGND VPWR VPWR sky130_fd_sc_hd__fill_1
XFILLER_162_1594 VGND VGND VPWR VPWR sky130_fd_sc_hd__decap_8
XFILLER_123_1534 VPWR VGND VPWR VGND sky130_ef_sc_hd__decap_12
XTAP_TAPCELL_ROW_109_2_3688 VGND VPWR sky130_fd_sc_hd__tapvpwrvgnd_1
XTAP_TAPCELL_ROW_96_1_1210 VGND VPWR sky130_fd_sc_hd__tapvpwrvgnd_1
XFILLER_71_1466 VPWR VGND VPWR VGND sky130_ef_sc_hd__decap_12
XFILLER_7_309 VPWR VGND VPWR VGND sky130_ef_sc_hd__decap_12
XFILLER_32_1406 VGND VGND VPWR VPWR sky130_fd_sc_hd__decap_6
XFILLER_165_833 VGND VGND VPWR VPWR sky130_fd_sc_hd__decap_6
XFILLER_164_321 VPWR VGND VPWR VGND sky130_ef_sc_hd__decap_12
XFILLER_123_1578 VPWR VGND VPWR VGND sky130_ef_sc_hd__decap_12
XTAP_TAPCELL_ROW_77_2_3477 VGND VPWR sky130_fd_sc_hd__tapvpwrvgnd_1
XFILLER_194_27 VGND VGND VPWR VPWR sky130_fd_sc_hd__fill_1
XFILLER_180_825 VPWR VGND VPWR VGND sky130_ef_sc_hd__decap_12
XFILLER_165_877 VPWR VGND VPWR VGND sky130_ef_sc_hd__decap_12
XFILLER_164_365 VPWR VGND VPWR VGND sky130_ef_sc_hd__decap_12
XFILLER_3_526 VGND VGND VPWR VPWR sky130_fd_sc_hd__decap_6
XFILLER_195_1381 VPWR VGND VPWR VGND sky130_ef_sc_hd__decap_12
XFILLER_191_1201 VPWR VGND VPWR VGND sky130_ef_sc_hd__decap_12
XFILLER_180_869 VPWR VGND VPWR VGND sky130_ef_sc_hd__decap_12
XFILLER_69_1384 VGND VGND VPWR VPWR sky130_fd_sc_hd__fill_1
XANTENNA__511__B1 net139 VGND VGND VPWR VPWR sky130_fd_sc_hd__diode_2
XFILLER_191_1245 VPWR VGND VPWR VGND sky130_ef_sc_hd__decap_12
XFILLER_191_1289 VPWR VGND VPWR VGND sky130_ef_sc_hd__decap_12
XFILLER_87_69 VPWR VGND VPWR VGND sky130_ef_sc_hd__decap_12
XFILLER_82_1562 VPWR VGND VPWR VGND sky130_ef_sc_hd__decap_12
XFILLER_219_333 VGND VGND VPWR VPWR sky130_fd_sc_hd__decap_3
XFILLER_43_1546 VGND VGND VPWR VPWR sky130_fd_sc_hd__decap_6
XFILLER_219_377 VPWR VGND VPWR VGND sky130_ef_sc_hd__decap_12
XFILLER_207_517 VPWR VGND VPWR VGND sky130_ef_sc_hd__decap_12
XFILLER_130_1538 VPWR VGND VPWR VGND sky130_ef_sc_hd__decap_12
XFILLER_4_1017 VPWR VGND VPWR VGND sky130_ef_sc_hd__decap_12
XFILLER_210_1595 VGND VGND VPWR VPWR sky130_fd_sc_hd__fill_1
XFILLER_76_1300 VGND VGND VPWR VPWR sky130_fd_sc_hd__fill_1
XFILLER_215_561 VPWR VGND VPWR VGND sky130_ef_sc_hd__decap_12
XFILLER_188_925 VPWR VGND VPWR VGND sky130_ef_sc_hd__decap_12
XFILLER_128_1412 VGND VGND VPWR VPWR sky130_fd_sc_hd__fill_1
XFILLER_202_233 VPWR VGND VPWR VGND sky130_ef_sc_hd__decap_12
XFILLER_199_273 VGND VGND VPWR VPWR sky130_fd_sc_hd__decap_6
XFILLER_37_1328 VGND VGND VPWR VPWR sky130_fd_sc_hd__fill_1
XFILLER_163_1369 VGND VGND VPWR VPWR sky130_fd_sc_hd__decap_3
X_315_ net26 net143 net133 VGND VGND VPWR VPWR s_wdata\[22\] sky130_fd_sc_hd__a21o_1
XFILLER_202_277 VPWR VGND VPWR VGND sky130_ef_sc_hd__decap_12
XFILLER_50_1506 VPWR VGND VPWR VGND sky130_ef_sc_hd__decap_12
XFILLER_52_83 VGND VGND VPWR VPWR sky130_fd_sc_hd__fill_1
XFILLER_183_641 VPWR VGND VPWR VGND sky130_ef_sc_hd__decap_12
XFILLER_168_693 VGND VGND VPWR VPWR sky130_fd_sc_hd__decap_6
XFILLER_168_83 VGND VGND VPWR VPWR sky130_fd_sc_hd__fill_1
XFILLER_167_181 VPWR VGND VPWR VGND sky130_ef_sc_hd__decap_12
Xinput37 func_wdata[3] VGND VGND VPWR VPWR net37 sky130_fd_sc_hd__clkbuf_1
Xinput15 func_wdata[12] VGND VGND VPWR VPWR net15 sky130_fd_sc_hd__clkbuf_1
Xinput26 func_wdata[22] VGND VGND VPWR VPWR net26 sky130_fd_sc_hd__clkbuf_1
XTAP_TAPCELL_ROW_188_2112 VGND VPWR sky130_fd_sc_hd__tapvpwrvgnd_1
XTAP_TAPCELL_ROW_188_2101 VGND VPWR sky130_fd_sc_hd__tapvpwrvgnd_1
XFILLER_183_685 VPWR VGND VPWR VGND sky130_ef_sc_hd__decap_12
XTAP_TAPCELL_ROW_154_2_3981 VGND VPWR sky130_fd_sc_hd__tapvpwrvgnd_1
XFILLER_87_1440 VGND VGND VPWR VPWR sky130_fd_sc_hd__fill_1
XFILLER_182_195 VGND VGND VPWR VPWR sky130_fd_sc_hd__fill_1
XFILLER_174_1421 VGND VGND VPWR VPWR sky130_fd_sc_hd__decap_6
XFILLER_170_357 VGND VGND VPWR VPWR sky130_fd_sc_hd__decap_6
XFILLER_139_1552 VGND VGND VPWR VPWR sky130_fd_sc_hd__fill_1
XFILLER_174_1465 VPWR VGND VPWR VGND sky130_ef_sc_hd__decap_12
XFILLER_48_1468 VGND VGND VPWR VPWR sky130_fd_sc_hd__fill_1
XTAP_TAPCELL_ROW_209_2705 VGND VPWR sky130_fd_sc_hd__tapvpwrvgnd_1
XFILLER_170_1329 VPWR VGND VPWR VGND sky130_ef_sc_hd__decap_12
XPHY_EDGE_ROW_87_2_Right_144 VGND VGND VPWR VPWR sky130_fd_sc_hd__decap_3
XFILLER_61_1602 VGND VGND VPWR VPWR sky130_fd_sc_hd__decap_3
XFILLER_211_1337 VGND VGND VPWR VPWR sky130_fd_sc_hd__decap_6
XTAP_TAPCELL_ROW_146_2_3929 VGND VPWR sky130_fd_sc_hd__tapvpwrvgnd_1
XFILLER_168_1203 VGND VGND VPWR VPWR sky130_fd_sc_hd__fill_1
XFILLER_98_1580 VGND VGND VPWR VPWR sky130_fd_sc_hd__fill_1
XFILLER_4_1595 VGND VGND VPWR VPWR sky130_fd_sc_hd__fill_1
XFILLER_209_1233 VPWR VGND VPWR VGND sky130_ef_sc_hd__decap_12
XFILLER_185_1561 VGND VGND VPWR VPWR sky130_fd_sc_hd__decap_6
XFILLER_181_1425 VPWR VGND VPWR VGND sky130_ef_sc_hd__decap_12
XFILLER_178_413 VGND VGND VPWR VPWR sky130_fd_sc_hd__decap_6
XFILLER_205_1119 VGND VGND VPWR VPWR sky130_fd_sc_hd__fill_1
XFILLER_194_917 VGND VGND VPWR VPWR sky130_fd_sc_hd__decap_6
XFILLER_181_1469 VPWR VGND VPWR VGND sky130_ef_sc_hd__decap_12
XFILLER_178_457 VPWR VGND VPWR VGND sky130_ef_sc_hd__decap_12
XFILLER_193_405 VPWR VGND VPWR VGND sky130_ef_sc_hd__decap_12
XFILLER_105_1220 VPWR VGND VPWR VGND sky130_ef_sc_hd__decap_12
XTAP_TAPCELL_ROW_63_2_3385 VGND VPWR sky130_fd_sc_hd__tapvpwrvgnd_1
XFILLER_193_449 VPWR VGND VPWR VGND sky130_ef_sc_hd__decap_12
XFILLER_18_1294 VGND VGND VPWR VPWR sky130_fd_sc_hd__decap_6
XFILLER_179_1343 VGND VGND VPWR VPWR sky130_fd_sc_hd__fill_1
XFILLER_105_1286 VPWR VGND VPWR VGND sky130_ef_sc_hd__decap_12
XFILLER_192_1521 VPWR VGND VPWR VGND sky130_ef_sc_hd__decap_12
XFILLER_66_1524 VGND VGND VPWR VPWR sky130_fd_sc_hd__fill_1
XFILLER_192_1565 VPWR VGND VPWR VGND sky130_ef_sc_hd__decap_12
XFILLER_216_1259 VGND VGND VPWR VPWR sky130_fd_sc_hd__fill_1
XTAP_TAPCELL_ROW_167_1506 VGND VPWR sky130_fd_sc_hd__tapvpwrvgnd_1
XFILLER_87_113 VPWR VGND VPWR VGND sky130_ef_sc_hd__decap_12
XFILLER_9_1440 VGND VGND VPWR VPWR sky130_fd_sc_hd__fill_1
XFILLER_64_1270 VPWR VGND VPWR VGND sky130_ef_sc_hd__decap_12
XFILLER_25_1232 VPWR VGND VPWR VGND sky130_ef_sc_hd__decap_12
XFILLER_180_29 VPWR VGND VPWR VGND sky130_ef_sc_hd__decap_12
XFILLER_116_1382 VPWR VGND VPWR VGND sky130_ef_sc_hd__decap_12
XFILLER_99_1322 VGND VGND VPWR VPWR sky130_fd_sc_hd__decap_6
XFILLER_5_1337 VGND VGND VPWR VPWR sky130_fd_sc_hd__decap_6
XFILLER_112_1246 VPWR VGND VPWR VGND sky130_ef_sc_hd__decap_12
XFILLER_99_1366 VPWR VGND VPWR VGND sky130_ef_sc_hd__decap_12
XFILLER_25_1298 VPWR VGND VPWR VGND sky130_ef_sc_hd__decap_12
XFILLER_73_27 VPWR VGND VPWR VGND sky130_ef_sc_hd__decap_12
XTAP_TAPCELL_ROW_219_3001 VGND VPWR sky130_fd_sc_hd__tapvpwrvgnd_1
XFILLER_189_27 VPWR VGND VPWR VGND sky130_ef_sc_hd__decap_12
XTAP_TAPCELL_ROW_219_3023 VGND VPWR sky130_fd_sc_hd__tapvpwrvgnd_1
XTAP_TAPCELL_ROW_219_3012 VGND VPWR sky130_fd_sc_hd__tapvpwrvgnd_1
XFILLER_212_531 VGND VGND VPWR VPWR sky130_fd_sc_hd__fill_1
XFILLER_196_221 VPWR VGND VPWR VGND sky130_ef_sc_hd__decap_12
XFILLER_184_1093 VPWR VGND VPWR VGND sky130_ef_sc_hd__decap_12
XFILLER_11_102 VGND VGND VPWR VPWR sky130_fd_sc_hd__decap_8
XFILLER_11_113 VGND VGND VPWR VPWR sky130_fd_sc_hd__decap_3
XFILLER_200_737 VPWR VGND VPWR VGND sky130_ef_sc_hd__decap_12
XFILLER_197_777 VGND VGND VPWR VPWR sky130_fd_sc_hd__decap_6
XFILLER_196_265 VPWR VGND VPWR VGND sky130_ef_sc_hd__decap_12
XTAP_TAPCELL_ROW_128_1_1273 VGND VPWR sky130_fd_sc_hd__tapvpwrvgnd_1
XFILLER_36_1350 VGND VGND VPWR VPWR sky130_fd_sc_hd__decap_6
XFILLER_123_1342 VPWR VGND VPWR VGND sky130_ef_sc_hd__decap_12
XFILLER_71_1274 VPWR VGND VPWR VGND sky130_ef_sc_hd__decap_12
XFILLER_7_139 VGND VGND VPWR VPWR sky130_fd_sc_hd__fill_1
XTAP_TAPCELL_ROW_33_1_1084 VGND VPWR sky130_fd_sc_hd__tapvpwrvgnd_1
XFILLER_36_1394 VPWR VGND VPWR VGND sky130_ef_sc_hd__decap_12
XFILLER_165_641 VPWR VGND VPWR VGND sky130_ef_sc_hd__decap_12
XTAP_TAPCELL_ROW_139_2_3883 VGND VPWR sky130_fd_sc_hd__tapvpwrvgnd_1
XFILLER_125_3 VPWR VGND VPWR VGND sky130_ef_sc_hd__decap_12
XFILLER_123_1386 VPWR VGND VPWR VGND sky130_ef_sc_hd__decap_12
XFILLER_32_1258 VPWR VGND VPWR VGND sky130_ef_sc_hd__decap_12
XFILLER_165_685 VPWR VGND VPWR VGND sky130_ef_sc_hd__decap_12
XFILLER_158_1438 VPWR VGND VPWR VGND sky130_ef_sc_hd__decap_12
XFILLER_138_53 VPWR VGND VPWR VGND sky130_ef_sc_hd__decap_12
XFILLER_4_813 VPWR VGND VPWR VGND sky130_ef_sc_hd__decap_12
XFILLER_22_97 VPWR VGND VPWR VGND sky130_ef_sc_hd__decap_12
XFILLER_164_195 VGND VGND VPWR VPWR sky130_fd_sc_hd__fill_1
XFILLER_138_97 VPWR VGND VPWR VGND sky130_ef_sc_hd__decap_12
XFILLER_84_1602 VGND VGND VPWR VPWR sky130_fd_sc_hd__decap_3
XFILLER_180_699 VGND VGND VPWR VPWR sky130_fd_sc_hd__fill_1
XPHY_EDGE_ROW_28_2_Right_85 VGND VGND VPWR VPWR sky130_fd_sc_hd__decap_3
XFILLER_154_41 VPWR VGND VPWR VGND sky130_ef_sc_hd__decap_12
XANTENNA_input45_A rst_n VGND VGND VPWR VPWR sky130_fd_sc_hd__diode_2
XFILLER_154_85 VPWR VGND VPWR VGND sky130_ef_sc_hd__decap_12
XTAP_TAPCELL_ROW_132_2_3837 VGND VPWR sky130_fd_sc_hd__tapvpwrvgnd_1
XFILLER_82_1370 VPWR VGND VPWR VGND sky130_ef_sc_hd__decap_12
XFILLER_43_1310 VPWR VGND VPWR VGND sky130_ef_sc_hd__decap_12
XFILLER_47_1490 VGND VGND VPWR VPWR sky130_fd_sc_hd__decap_6
XFILLER_219_141 VPWR VGND VPWR VGND sky130_ef_sc_hd__decap_12
XFILLER_134_1482 VPWR VGND VPWR VGND sky130_ef_sc_hd__decap_12
XFILLER_130_1302 VPWR VGND VPWR VGND sky130_ef_sc_hd__decap_12
XFILLER_93_105 VGND VGND VPWR VPWR sky130_fd_sc_hd__decap_6
XFILLER_43_1354 VPWR VGND VPWR VGND sky130_ef_sc_hd__decap_12
XFILLER_208_837 VPWR VGND VPWR VGND sky130_ef_sc_hd__decap_12
XFILLER_78_1406 VGND VGND VPWR VPWR sky130_fd_sc_hd__decap_6
XFILLER_43_1398 VPWR VGND VPWR VGND sky130_ef_sc_hd__decap_12
XFILLER_169_1567 VGND VGND VPWR VPWR sky130_fd_sc_hd__fill_1
XTAP_TAPCELL_ROW_3_890 VGND VPWR sky130_fd_sc_hd__tapvpwrvgnd_1
XFILLER_216_881 VPWR VGND VPWR VGND sky130_ef_sc_hd__decap_12
XFILLER_215_391 VGND VGND VPWR VPWR sky130_fd_sc_hd__fill_1
XFILLER_128_1220 VPWR VGND VPWR VGND sky130_ef_sc_hd__decap_12
XFILLER_203_553 VGND VGND VPWR VPWR sky130_fd_sc_hd__decap_6
XFILLER_188_755 VGND VGND VPWR VPWR sky130_fd_sc_hd__fill_1
XFILLER_163_1133 VPWR VGND VPWR VGND sky130_ef_sc_hd__decap_12
XFILLER_63_93 VPWR VGND VPWR VGND sky130_ef_sc_hd__decap_12
XTAP_TAPCELL_ROW_48_2_3287 VGND VPWR sky130_fd_sc_hd__tapvpwrvgnd_1
XFILLER_203_597 VPWR VGND VPWR VGND sky130_ef_sc_hd__decap_12
XFILLER_179_93 VPWR VGND VPWR VGND sky130_ef_sc_hd__decap_12
XFILLER_176_917 VGND VGND VPWR VPWR sky130_fd_sc_hd__decap_6
XFILLER_175_405 VPWR VGND VPWR VGND sky130_ef_sc_hd__decap_12
XFILLER_163_1177 VPWR VGND VPWR VGND sky130_ef_sc_hd__decap_12
XFILLER_54_1450 VPWR VGND VPWR VGND sky130_ef_sc_hd__decap_12
XFILLER_204_1141 VGND VGND VPWR VPWR sky130_fd_sc_hd__decap_6
XFILLER_198_1229 VPWR VGND VPWR VGND sky130_ef_sc_hd__decap_12
XFILLER_191_909 VPWR VGND VPWR VGND sky130_ef_sc_hd__decap_12
XFILLER_175_449 VPWR VGND VPWR VGND sky130_ef_sc_hd__decap_12
XFILLER_141_1442 VPWR VGND VPWR VGND sky130_ef_sc_hd__decap_12
XFILLER_106_1562 VPWR VGND VPWR VGND sky130_ef_sc_hd__decap_12
XFILLER_15_1434 VGND VGND VPWR VPWR sky130_fd_sc_hd__decap_6
XFILLER_50_1314 VPWR VGND VPWR VGND sky130_ef_sc_hd__decap_12
XFILLER_54_1494 VPWR VGND VPWR VGND sky130_ef_sc_hd__decap_12
XFILLER_204_1185 VPWR VGND VPWR VGND sky130_ef_sc_hd__decap_12
XFILLER_200_1005 VPWR VGND VPWR VGND sky130_ef_sc_hd__decap_12
XFILLER_190_419 VGND VGND VPWR VPWR sky130_fd_sc_hd__fill_1
XFILLER_184_961 VPWR VGND VPWR VGND sky130_ef_sc_hd__decap_12
XPHY_EDGE_ROW_145_2_Left_577 VGND VGND VPWR VPWR sky130_fd_sc_hd__decap_3
XFILLER_102_1426 VPWR VGND VPWR VGND sky130_ef_sc_hd__decap_12
XFILLER_89_1546 VGND VGND VPWR VPWR sky130_fd_sc_hd__decap_6
XANTENNA__552__S net122 VGND VGND VPWR VPWR sky130_fd_sc_hd__diode_2
XFILLER_7_640 VGND VGND VPWR VPWR sky130_fd_sc_hd__decap_4
XFILLER_15_1478 VPWR VGND VPWR VGND sky130_ef_sc_hd__decap_12
XTAP_TAPCELL_ROW_28_2_3163 VGND VPWR sky130_fd_sc_hd__tapvpwrvgnd_1
XFILLER_50_1358 VPWR VGND VPWR VGND sky130_ef_sc_hd__decap_12
XFILLER_200_1049 VPWR VGND VPWR VGND sky130_ef_sc_hd__decap_12
XFILLER_195_81 VPWR VGND VPWR VGND sky130_ef_sc_hd__decap_12
XFILLER_7_673 VPWR VGND VPWR VGND sky130_ef_sc_hd__decap_12
XFILLER_170_121 VPWR VGND VPWR VGND sky130_ef_sc_hd__decap_12
XPHY_EDGE_ROW_82_2_Left_514 VGND VGND VPWR VPWR sky130_fd_sc_hd__decap_3
XFILLER_217_1513 VPWR VGND VPWR VGND sky130_ef_sc_hd__decap_12
XFILLER_170_165 VPWR VGND VPWR VGND sky130_ef_sc_hd__decap_12
XFILLER_40_3 VPWR VGND VPWR VGND sky130_ef_sc_hd__decap_12
XFILLER_48_1232 VPWR VGND VPWR VGND sky130_ef_sc_hd__decap_12
XFILLER_174_1273 VPWR VGND VPWR VGND sky130_ef_sc_hd__decap_12
XFILLER_69_113 VPWR VGND VPWR VGND sky130_ef_sc_hd__decap_12
XFILLER_135_1268 VGND VGND VPWR VPWR sky130_fd_sc_hd__decap_4
XFILLER_65_1590 VPWR VGND VPWR VGND sky130_ef_sc_hd__decap_12
XTAP_TAPCELL_ROW_21_2_3117 VGND VPWR sky130_fd_sc_hd__tapvpwrvgnd_1
XFILLER_61_1410 VPWR VGND VPWR VGND sky130_ef_sc_hd__decap_12
XFILLER_215_1281 VGND VGND VPWR VPWR sky130_fd_sc_hd__decap_6
XFILLER_211_1101 VPWR VGND VPWR VGND sky130_ef_sc_hd__decap_12
XFILLER_152_1582 VPWR VGND VPWR VGND sky130_ef_sc_hd__decap_12
XFILLER_113_1522 VPWR VGND VPWR VGND sky130_ef_sc_hd__decap_12
XPHY_EDGE_ROW_88_2_Right_145 VGND VGND VPWR VPWR sky130_fd_sc_hd__decap_3
XFILLER_26_1574 VGND VGND VPWR VPWR sky130_fd_sc_hd__decap_6
XFILLER_61_1454 VPWR VGND VPWR VGND sky130_ef_sc_hd__decap_12
XFILLER_214_77 VGND VGND VPWR VPWR sky130_fd_sc_hd__decap_6
XFILLER_211_1145 VPWR VGND VPWR VGND sky130_ef_sc_hd__decap_12
XFILLER_113_1566 VPWR VGND VPWR VGND sky130_ef_sc_hd__decap_12
XFILLER_96_1506 VPWR VGND VPWR VGND sky130_ef_sc_hd__decap_12
XTAP_TAPCELL_ROW_1_827 VGND VPWR sky130_fd_sc_hd__tapvpwrvgnd_1
XTAP_TAPCELL_ROW_1_816 VGND VPWR sky130_fd_sc_hd__tapvpwrvgnd_1
XFILLER_22_1438 VPWR VGND VPWR VGND sky130_ef_sc_hd__decap_12
XFILLER_61_1498 VPWR VGND VPWR VGND sky130_ef_sc_hd__decap_12
XFILLER_211_1189 VPWR VGND VPWR VGND sky130_ef_sc_hd__decap_12
XFILLER_0_1201 VGND VGND VPWR VPWR sky130_fd_sc_hd__decap_3
XFILLER_213_317 VPWR VGND VPWR VGND sky130_ef_sc_hd__decap_12
XFILLER_0_1245 VPWR VGND VPWR VGND sky130_ef_sc_hd__decap_12
XFILLER_209_1063 VGND VGND VPWR VPWR sky130_fd_sc_hd__fill_1
XFILLER_181_1233 VPWR VGND VPWR VGND sky130_ef_sc_hd__decap_12
XFILLER_178_221 VPWR VGND VPWR VGND sky130_ef_sc_hd__decap_12
XFILLER_0_1289 VPWR VGND VPWR VGND sky130_ef_sc_hd__decap_12
XFILLER_194_725 VPWR VGND VPWR VGND sky130_ef_sc_hd__decap_12
XFILLER_179_777 VGND VGND VPWR VPWR sky130_fd_sc_hd__decap_6
XFILLER_178_265 VPWR VGND VPWR VGND sky130_ef_sc_hd__decap_12
XFILLER_72_1550 VPWR VGND VPWR VGND sky130_ef_sc_hd__decap_12
XTAP_TAPCELL_ROW_125_2_3791 VGND VPWR sky130_fd_sc_hd__tapvpwrvgnd_1
XFILLER_72_1594 VGND VGND VPWR VPWR sky130_fd_sc_hd__decap_8
XFILLER_33_1534 VPWR VGND VPWR VGND sky130_ef_sc_hd__decap_12
XFILLER_194_769 VPWR VGND VPWR VGND sky130_ef_sc_hd__decap_12
XFILLER_120_1526 VPWR VGND VPWR VGND sky130_ef_sc_hd__decap_12
XTAP_TAPCELL_ROW_93_2_3580 VGND VPWR sky130_fd_sc_hd__tapvpwrvgnd_1
XFILLER_33_1578 VPWR VGND VPWR VGND sky130_ef_sc_hd__decap_12
XFILLER_193_279 VGND VGND VPWR VPWR sky130_fd_sc_hd__fill_1
XFILLER_192_1373 VPWR VGND VPWR VGND sky130_ef_sc_hd__decap_12
XTAP_TAPCELL_ROW_117_2_3739 VGND VPWR sky130_fd_sc_hd__tapvpwrvgnd_1
XFILLER_68_27 VGND VGND VPWR VPWR sky130_fd_sc_hd__fill_1
XFILLER_0_326 VGND VGND VPWR VPWR sky130_fd_sc_hd__decap_3
XFILLER_191_39 VPWR VGND VPWR VGND sky130_ef_sc_hd__decap_12
XFILLER_188_1409 VPWR VGND VPWR VGND sky130_ef_sc_hd__decap_12
XTAP_TAPCELL_ROW_85_2_3528 VGND VPWR sky130_fd_sc_hd__tapvpwrvgnd_1
XFILLER_75_105 VGND VGND VPWR VPWR sky130_fd_sc_hd__decap_6
XFILLER_5_1101 VPWR VGND VPWR VGND sky130_ef_sc_hd__decap_12
XFILLER_124_77 VGND VGND VPWR VPWR sky130_fd_sc_hd__decap_6
XFILLER_84_15 VPWR VGND VPWR VGND sky130_ef_sc_hd__decap_12
XFILLER_5_1145 VPWR VGND VPWR VGND sky130_ef_sc_hd__decap_12
XFILLER_40_1538 VPWR VGND VPWR VGND sky130_ef_sc_hd__decap_12
XFILLER_216_133 VGND VGND VPWR VPWR sky130_fd_sc_hd__decap_6
XFILLER_1_1009 VPWR VGND VPWR VGND sky130_ef_sc_hd__decap_12
XFILLER_5_1189 VPWR VGND VPWR VGND sky130_ef_sc_hd__decap_12
X_580_ clknet_3_2_0_clk _014_ VGND VGND VPWR VPWR u_ctrl.op_idx sky130_fd_sc_hd__dfxtp_1
XFILLER_216_177 VPWR VGND VPWR VGND sky130_ef_sc_hd__decap_12
XFILLER_140_65 VPWR VGND VPWR VGND sky130_ef_sc_hd__decap_12
XFILLER_38_1412 VGND VGND VPWR VPWR sky130_fd_sc_hd__fill_1
XFILLER_197_541 VPWR VGND VPWR VGND sky130_ef_sc_hd__decap_12
XFILLER_164_1453 VPWR VGND VPWR VGND sky130_ef_sc_hd__decap_12
XFILLER_213_895 VGND VGND VPWR VPWR sky130_fd_sc_hd__fill_1
XFILLER_200_501 VPWR VGND VPWR VGND sky130_ef_sc_hd__decap_12
XFILLER_199_1505 VGND VGND VPWR VPWR sky130_fd_sc_hd__decap_6
XFILLER_197_585 VPWR VGND VPWR VGND sky130_ef_sc_hd__decap_12
XFILLER_164_1497 VPWR VGND VPWR VGND sky130_ef_sc_hd__decap_12
XFILLER_200_545 VPWR VGND VPWR VGND sky130_ef_sc_hd__decap_12
XPHY_EDGE_ROW_130_1_Left_349 VGND VGND VPWR VPWR sky130_fd_sc_hd__decap_3
XTAP_TAPCELL_ROW_14_2_3071 VGND VPWR sky130_fd_sc_hd__tapvpwrvgnd_1
XFILLER_201_1325 VPWR VGND VPWR VGND sky130_ef_sc_hd__decap_12
XFILLER_200_589 VPWR VGND VPWR VGND sky130_ef_sc_hd__decap_12
XFILLER_199_1549 VPWR VGND VPWR VGND sky130_ef_sc_hd__decap_12
XFILLER_173_909 VPWR VGND VPWR VGND sky130_ef_sc_hd__decap_12
XFILLER_166_961 VPWR VGND VPWR VGND sky130_ef_sc_hd__decap_12
XTAP_TAPCELL_ROW_64_1_1145 VGND VPWR sky130_fd_sc_hd__tapvpwrvgnd_1
XFILLER_201_1369 VPWR VGND VPWR VGND sky130_ef_sc_hd__decap_12
XFILLER_172_419 VGND VGND VPWR VPWR sky130_fd_sc_hd__fill_1
XPHY_EDGE_ROW_134_1_Right_720 VGND VGND VPWR VPWR sky130_fd_sc_hd__decap_3
XFILLER_181_953 VPWR VGND VPWR VGND sky130_ef_sc_hd__decap_12
XFILLER_158_1246 VPWR VGND VPWR VGND sky130_ef_sc_hd__decap_12
XFILLER_152_121 VGND VGND VPWR VPWR sky130_fd_sc_hd__decap_6
XFILLER_4_632 VPWR VGND VPWR VGND sky130_ef_sc_hd__decap_12
XFILLER_165_51 VGND VGND VPWR VPWR sky130_fd_sc_hd__decap_4
XFILLER_49_1552 VGND VGND VPWR VPWR sky130_fd_sc_hd__fill_1
XFILLER_175_1593 VPWR VGND VPWR VGND sky130_ef_sc_hd__decap_12
XFILLER_171_1413 VPWR VGND VPWR VGND sky130_ef_sc_hd__decap_12
XFILLER_171_1457 VPWR VGND VPWR VGND sky130_ef_sc_hd__decap_12
XFILLER_3_197 VPWR VGND VPWR VGND sky130_ef_sc_hd__decap_12
XANTENNA__401__A b_addr\[3\] VGND VGND VPWR VPWR sky130_fd_sc_hd__diode_2
XFILLER_212_1421 VGND VGND VPWR VPWR sky130_fd_sc_hd__decap_6
XFILLER_0_893 VGND VGND VPWR VPWR sky130_fd_sc_hd__decap_3
Xhold4 u_ctrl.state\[0\] VGND VGND VPWR VPWR net174 sky130_fd_sc_hd__dlygate4sd3_1
XFILLER_212_1465 VPWR VGND VPWR VGND sky130_ef_sc_hd__decap_12
XFILLER_208_601 VPWR VGND VPWR VGND sky130_ef_sc_hd__decap_12
XFILLER_12_7 VPWR VGND VPWR VGND sky130_ef_sc_hd__decap_12
XFILLER_208_645 VPWR VGND VPWR VGND sky130_ef_sc_hd__decap_12
XFILLER_207_111 VGND VGND VPWR VPWR sky130_fd_sc_hd__fill_1
XFILLER_78_1258 VPWR VGND VPWR VGND sky130_ef_sc_hd__decap_12
XFILLER_210_309 VPWR VGND VPWR VGND sky130_ef_sc_hd__decap_12
XFILLER_206_1203 VGND VGND VPWR VPWR sky130_fd_sc_hd__fill_1
XFILLER_182_1553 VPWR VGND VPWR VGND sky130_ef_sc_hd__decap_12
XFILLER_108_1602 VGND VGND VPWR VPWR sky130_fd_sc_hd__decap_3
XANTENNA__539__A3 net129 VGND VGND VPWR VPWR sky130_fd_sc_hd__diode_2
XFILLER_203_361 VPWR VGND VPWR VGND sky130_ef_sc_hd__decap_12
XFILLER_176_725 VPWR VGND VPWR VGND sky130_ef_sc_hd__decap_12
Xu_sram.u_mem_164 VGND VGND VPWR VPWR u_sram.u_mem_164/HI net164 sky130_fd_sc_hd__conb_1
XFILLER_182_1597 VGND VGND VPWR VPWR sky130_fd_sc_hd__decap_8
XTAP_TAPCELL_ROW_111_1_1240 VGND VPWR sky130_fd_sc_hd__tapvpwrvgnd_1
XFILLER_88_3 VPWR VGND VPWR VGND sky130_ef_sc_hd__decap_12
XFILLER_15_1220 VPWR VGND VPWR VGND sky130_ef_sc_hd__decap_12
XFILLER_198_1037 VPWR VGND VPWR VGND sky130_ef_sc_hd__decap_12
XFILLER_176_769 VPWR VGND VPWR VGND sky130_ef_sc_hd__decap_12
XFILLER_106_1370 VPWR VGND VPWR VGND sky130_ef_sc_hd__decap_12
XFILLER_89_1310 VPWR VGND VPWR VGND sky130_ef_sc_hd__decap_12
XTAP_TAPCELL_ROW_78_2_3482 VGND VPWR sky130_fd_sc_hd__tapvpwrvgnd_1
XFILLER_175_279 VGND VGND VPWR VPWR sky130_fd_sc_hd__fill_1
XFILLER_141_1272 VGND VGND VPWR VPWR sky130_fd_sc_hd__fill_1
XFILLER_89_1354 VPWR VGND VPWR VGND sky130_ef_sc_hd__decap_12
XFILLER_15_1286 VPWR VGND VPWR VGND sky130_ef_sc_hd__decap_12
XFILLER_209_55 VGND VGND VPWR VPWR sky130_fd_sc_hd__fill_1
XFILLER_171_441 VGND VGND VPWR VPWR sky130_fd_sc_hd__decap_6
XTAP_TAPCELL_ROW_103_2_3647 VGND VPWR sky130_fd_sc_hd__tapvpwrvgnd_1
XFILLER_89_1398 VPWR VGND VPWR VGND sky130_ef_sc_hd__decap_12
XFILLER_217_1343 VGND VGND VPWR VPWR sky130_fd_sc_hd__fill_1
XFILLER_171_485 VPWR VGND VPWR VGND sky130_ef_sc_hd__decap_12
XFILLER_6_1421 VGND VGND VPWR VPWR sky130_fd_sc_hd__decap_6
XFILLER_57_105 VGND VGND VPWR VPWR sky130_fd_sc_hd__decap_6
XFILLER_113_1330 VPWR VGND VPWR VGND sky130_ef_sc_hd__decap_12
XPHY_EDGE_ROW_89_2_Right_146 VGND VGND VPWR VPWR sky130_fd_sc_hd__decap_3
XFILLER_6_1465 VPWR VGND VPWR VGND sky130_ef_sc_hd__decap_12
XFILLER_26_1382 VPWR VGND VPWR VGND sky130_ef_sc_hd__decap_12
XFILLER_96_1314 VPWR VGND VPWR VGND sky130_ef_sc_hd__decap_12
XFILLER_2_1329 VPWR VGND VPWR VGND sky130_ef_sc_hd__decap_12
XFILLER_22_1246 VPWR VGND VPWR VGND sky130_ef_sc_hd__decap_12
XTAP_TAPCELL_ROW_51_2_3312 VGND VPWR sky130_fd_sc_hd__tapvpwrvgnd_1
XTAP_TAPCELL_ROW_181_1889 VGND VPWR sky130_fd_sc_hd__tapvpwrvgnd_1
XFILLER_148_1426 VPWR VGND VPWR VGND sky130_ef_sc_hd__decap_12
XFILLER_96_1358 VPWR VGND VPWR VGND sky130_ef_sc_hd__decap_12
XFILLER_54_29 VPWR VGND VPWR VGND sky130_ef_sc_hd__decap_12
XFILLER_214_637 VGND VGND VPWR VPWR sky130_fd_sc_hd__decap_6
XFILLER_213_125 VPWR VGND VPWR VGND sky130_ef_sc_hd__decap_12
XFILLER_199_839 VGND VGND VPWR VPWR sky130_fd_sc_hd__fill_1
XFILLER_213_169 VPWR VGND VPWR VGND sky130_ef_sc_hd__decap_12
XFILLER_179_541 VPWR VGND VPWR VGND sky130_ef_sc_hd__decap_12
XFILLER_181_1063 VGND VGND VPWR VPWR sky130_fd_sc_hd__fill_1
XFILLER_194_533 VPWR VGND VPWR VGND sky130_ef_sc_hd__decap_12
XFILLER_179_585 VPWR VGND VPWR VGND sky130_ef_sc_hd__decap_12
XFILLER_124_1470 VPWR VGND VPWR VGND sky130_ef_sc_hd__decap_12
XFILLER_33_1342 VPWR VGND VPWR VGND sky130_ef_sc_hd__decap_12
XFILLER_181_205 VPWR VGND VPWR VGND sky130_ef_sc_hd__decap_12
XFILLER_5_429 VGND VGND VPWR VPWR sky130_fd_sc_hd__decap_3
XFILLER_33_1386 VPWR VGND VPWR VGND sky130_ef_sc_hd__decap_12
XFILLER_181_249 VPWR VGND VPWR VGND sky130_ef_sc_hd__decap_12
XFILLER_163_953 VPWR VGND VPWR VGND sky130_ef_sc_hd__decap_12
XFILLER_159_1522 VPWR VGND VPWR VGND sky130_ef_sc_hd__decap_12
XFILLER_134_121 VGND VGND VPWR VPWR sky130_fd_sc_hd__decap_6
XFILLER_120_1356 VGND VGND VPWR VPWR sky130_fd_sc_hd__fill_1
XFILLER_119_55 VGND VGND VPWR VPWR sky130_fd_sc_hd__fill_1
XFILLER_79_15 VPWR VGND VPWR VGND sky130_ef_sc_hd__decap_12
XFILLER_68_1438 VPWR VGND VPWR VGND sky130_ef_sc_hd__decap_12
XANTENNA_clkbuf_3_0_0_clk_A clknet_0_clk VGND VGND VPWR VPWR sky130_fd_sc_hd__diode_2
XFILLER_218_1129 VPWR VGND VPWR VGND sky130_ef_sc_hd__decap_12
XFILLER_159_1566 VPWR VGND VPWR VGND sky130_ef_sc_hd__decap_12
XFILLER_192_3 VPWR VGND VPWR VGND sky130_ef_sc_hd__decap_12
XTAP_TAPCELL_ROW_162_2_4029 VGND VPWR sky130_fd_sc_hd__tapvpwrvgnd_1
XTAP_TAPCELL_ROW_5_930 VGND VPWR sky130_fd_sc_hd__tapvpwrvgnd_1
XTAP_TAPCELL_ROW_5_941 VGND VPWR sky130_fd_sc_hd__tapvpwrvgnd_1
XFILLER_7_1229 VGND VGND VPWR VPWR sky130_fd_sc_hd__decap_3
XFILLER_188_1217 VPWR VGND VPWR VGND sky130_ef_sc_hd__decap_12
XTAP_TAPCELL_ROW_147_2_3934 VGND VPWR sky130_fd_sc_hd__tapvpwrvgnd_1
XFILLER_95_69 VPWR VGND VPWR VGND sky130_ef_sc_hd__decap_12
XFILLER_28_41 VGND VGND VPWR VPWR sky130_fd_sc_hd__fill_2
XFILLER_40_1302 VPWR VGND VPWR VGND sky130_ef_sc_hd__decap_12
XFILLER_44_1482 VPWR VGND VPWR VGND sky130_ef_sc_hd__decap_12
XFILLER_79_1534 VPWR VGND VPWR VGND sky130_ef_sc_hd__decap_12
X_632_ clknet_3_4_0_clk _066_ VGND VGND VPWR VPWR net48 sky130_fd_sc_hd__dfxtp_1
XFILLER_205_615 VGND VGND VPWR VPWR sky130_fd_sc_hd__fill_1
XFILLER_131_1496 VGND VGND VPWR VPWR sky130_fd_sc_hd__fill_1
XFILLER_217_497 VGND VGND VPWR VPWR sky130_fd_sc_hd__decap_6
XFILLER_189_305 VPWR VGND VPWR VGND sky130_ef_sc_hd__decap_12
XFILLER_79_1578 VPWR VGND VPWR VGND sky130_ef_sc_hd__decap_12
X_563_ net136 _255_ VGND VGND VPWR VPWR _065_ sky130_fd_sc_hd__and2_1
XFILLER_189_349 VPWR VGND VPWR VGND sky130_ef_sc_hd__decap_12
X_494_ net84 net122 VGND VGND VPWR VPWR _221_ sky130_fd_sc_hd__or2_1
XFILLER_201_821 VPWR VGND VPWR VGND sky130_ef_sc_hd__decap_12
XFILLER_198_861 VGND VGND VPWR VPWR sky130_fd_sc_hd__decap_6
XFILLER_164_1261 VPWR VGND VPWR VGND sky130_ef_sc_hd__decap_12
XFILLER_207_1567 VGND VGND VPWR VPWR sky130_fd_sc_hd__fill_1
XFILLER_201_865 VPWR VGND VPWR VGND sky130_ef_sc_hd__decap_12
XFILLER_199_1313 VPWR VGND VPWR VGND sky130_ef_sc_hd__decap_12
XFILLER_197_393 VPWR VGND VPWR VGND sky130_ef_sc_hd__decap_12
XFILLER_125_1256 VPWR VGND VPWR VGND sky130_ef_sc_hd__decap_12
XFILLER_103_1510 VPWR VGND VPWR VGND sky130_ef_sc_hd__decap_12
XFILLER_16_1562 VPWR VGND VPWR VGND sky130_ef_sc_hd__decap_12
XFILLER_51_1442 VPWR VGND VPWR VGND sky130_ef_sc_hd__decap_12
XFILLER_201_1133 VPWR VGND VPWR VGND sky130_ef_sc_hd__decap_12
XFILLER_199_1357 VPWR VGND VPWR VGND sky130_ef_sc_hd__decap_12
XTAP_TAPCELL_ROW_191_2196 VGND VPWR sky130_fd_sc_hd__tapvpwrvgnd_1
XTAP_TAPCELL_ROW_191_2185 VGND VPWR sky130_fd_sc_hd__tapvpwrvgnd_1
XTAP_TAPCELL_ROW_191_2174 VGND VPWR sky130_fd_sc_hd__tapvpwrvgnd_1
XFILLER_103_1554 VPWR VGND VPWR VGND sky130_ef_sc_hd__decap_12
XFILLER_12_1426 VPWR VGND VPWR VGND sky130_ef_sc_hd__decap_12
XFILLER_60_83 VGND VGND VPWR VPWR sky130_fd_sc_hd__fill_1
XTAP_TAPCELL_ROW_216_2892 VGND VPWR sky130_fd_sc_hd__tapvpwrvgnd_1
XFILLER_201_1177 VPWR VGND VPWR VGND sky130_ef_sc_hd__decap_12
XFILLER_176_83 VGND VGND VPWR VPWR sky130_fd_sc_hd__fill_1
XPHY_EDGE_ROW_135_1_Right_721 VGND VGND VPWR VPWR sky130_fd_sc_hd__decap_3
XFILLER_5_930 VPWR VGND VPWR VGND sky130_ef_sc_hd__decap_12
XTAP_TAPCELL_ROW_212_2778 VGND VPWR sky130_fd_sc_hd__tapvpwrvgnd_1
XFILLER_181_783 VGND VGND VPWR VPWR sky130_fd_sc_hd__fill_1
XFILLER_86_1538 VPWR VGND VPWR VGND sky130_ef_sc_hd__decap_12
XTAP_TAPCELL_ROW_212_2789 VGND VPWR sky130_fd_sc_hd__tapvpwrvgnd_1
XFILLER_69_81 VPWR VGND VPWR VGND sky130_ef_sc_hd__decap_12
XFILLER_39_105 VGND VGND VPWR VPWR sky130_fd_sc_hd__decap_6
XFILLER_45_1268 VGND VGND VPWR VPWR sky130_fd_sc_hd__decap_4
XFILLER_209_921 VPWR VGND VPWR VGND sky130_ef_sc_hd__decap_12
XFILLER_171_1287 VGND VGND VPWR VPWR sky130_fd_sc_hd__fill_1
XFILLER_0_690 VGND VGND VPWR VPWR sky130_fd_sc_hd__fill_1
XFILLER_23_1522 VPWR VGND VPWR VGND sky130_ef_sc_hd__decap_12
XTAP_TAPCELL_ROW_36_2_3214 VGND VPWR sky130_fd_sc_hd__tapvpwrvgnd_1
XFILLER_62_1582 VPWR VGND VPWR VGND sky130_ef_sc_hd__decap_12
XFILLER_212_1273 VPWR VGND VPWR VGND sky130_ef_sc_hd__decap_12
XFILLER_209_965 VPWR VGND VPWR VGND sky130_ef_sc_hd__decap_12
XFILLER_23_1566 VPWR VGND VPWR VGND sky130_ef_sc_hd__decap_12
XFILLER_208_475 VGND VGND VPWR VPWR sky130_fd_sc_hd__fill_1
XFILLER_208_1309 VGND VGND VPWR VPWR sky130_fd_sc_hd__decap_6
XFILLER_211_629 VPWR VGND VPWR VGND sky130_ef_sc_hd__decap_12
XFILLER_204_681 VPWR VGND VPWR VGND sky130_ef_sc_hd__decap_12
XFILLER_91_1244 VPWR VGND VPWR VGND sky130_ef_sc_hd__decap_12
XFILLER_210_139 VGND VGND VPWR VPWR sky130_fd_sc_hd__fill_1
XFILLER_176_533 VPWR VGND VPWR VGND sky130_ef_sc_hd__decap_12
XTAP_TAPCELL_ROW_142_1_1301 VGND VPWR sky130_fd_sc_hd__tapvpwrvgnd_1
XFILLER_143_1378 VGND VGND VPWR VPWR sky130_fd_sc_hd__decap_6
XFILLER_191_503 VGND VGND VPWR VPWR sky130_fd_sc_hd__fill_1
XFILLER_30_1526 VPWR VGND VPWR VGND sky130_ef_sc_hd__decap_12
XTAP_TAPCELL_ROW_174_1693 VGND VPWR sky130_fd_sc_hd__tapvpwrvgnd_1
XFILLER_163_249 VGND VGND VPWR VPWR sky130_fd_sc_hd__decap_3
XFILLER_116_121 VGND VGND VPWR VPWR sky130_fd_sc_hd__decap_6
XTAP_TAPCELL_ROW_170_1579 VGND VPWR sky130_fd_sc_hd__tapvpwrvgnd_1
XFILLER_131_113 VPWR VGND VPWR VGND sky130_ef_sc_hd__decap_12
XANTENNA__573__CLK clknet_3_1_0_clk VGND VGND VPWR VPWR sky130_fd_sc_hd__diode_2
XFILLER_172_1029 VGND VGND VPWR VPWR sky130_fd_sc_hd__decap_6
XFILLER_171_293 VPWR VGND VPWR VGND sky130_ef_sc_hd__decap_12
XTAP_TAPCELL_ROW_133_2_3842 VGND VPWR sky130_fd_sc_hd__tapvpwrvgnd_1
XFILLER_8_1538 VPWR VGND VPWR VGND sky130_ef_sc_hd__decap_12
XFILLER_219_729 VPWR VGND VPWR VGND sky130_ef_sc_hd__decap_12
XFILLER_150_1338 VPWR VGND VPWR VGND sky130_ef_sc_hd__decap_12
XFILLER_105_57 VPWR VGND VPWR VGND sky130_ef_sc_hd__decap_12
XFILLER_189_1537 VPWR VGND VPWR VGND sky130_ef_sc_hd__decap_12
XFILLER_65_39 VPWR VGND VPWR VGND sky130_ef_sc_hd__decap_12
XFILLER_6_1273 VPWR VGND VPWR VGND sky130_ef_sc_hd__decap_12
XTAP_TAPCELL_ROW_88_1_1193 VGND VPWR sky130_fd_sc_hd__tapvpwrvgnd_1
XFILLER_214_401 VPWR VGND VPWR VGND sky130_ef_sc_hd__decap_12
XFILLER_214_445 VPWR VGND VPWR VGND sky130_ef_sc_hd__decap_12
XFILLER_187_809 VPWR VGND VPWR VGND sky130_ef_sc_hd__decap_12
XFILLER_81_27 VPWR VGND VPWR VGND sky130_ef_sc_hd__decap_12
XFILLER_214_489 VPWR VGND VPWR VGND sky130_ef_sc_hd__decap_12
XFILLER_197_27 VPWR VGND VPWR VGND sky130_ef_sc_hd__decap_12
XFILLER_183_1169 VGND VGND VPWR VPWR sky130_fd_sc_hd__decap_6
XFILLER_165_1581 VPWR VGND VPWR VGND sky130_ef_sc_hd__decap_12
XFILLER_161_1434 VGND VGND VPWR VPWR sky130_fd_sc_hd__decap_6
XPHY_EDGE_ROW_37_2_Right_94 VGND VGND VPWR VPWR sky130_fd_sc_hd__decap_3
XFILLER_195_853 VPWR VGND VPWR VGND sky130_ef_sc_hd__decap_12
XFILLER_179_393 VPWR VGND VPWR VGND sky130_ef_sc_hd__decap_12
XFILLER_161_1478 VPWR VGND VPWR VGND sky130_ef_sc_hd__decap_12
XFILLER_202_1453 VPWR VGND VPWR VGND sky130_ef_sc_hd__decap_12
XFILLER_195_897 VPWR VGND VPWR VGND sky130_ef_sc_hd__decap_12
XFILLER_194_363 VGND VGND VPWR VPWR sky130_fd_sc_hd__fill_1
XFILLER_182_525 VGND VGND VPWR VPWR sky130_fd_sc_hd__decap_6
XFILLER_5_204 VGND VGND VPWR VPWR sky130_fd_sc_hd__decap_4
XFILLER_159_1330 VPWR VGND VPWR VGND sky130_ef_sc_hd__decap_12
XFILLER_5_237 VPWR VGND VPWR VGND sky130_ef_sc_hd__decap_12
XFILLER_5_215 VGND VGND VPWR VPWR sky130_fd_sc_hd__decap_8
XFILLER_6_749 VGND VGND VPWR VPWR sky130_fd_sc_hd__decap_6
XFILLER_205_3 VPWR VGND VPWR VGND sky130_ef_sc_hd__decap_12
XFILLER_202_1497 VPWR VGND VPWR VGND sky130_ef_sc_hd__decap_12
XFILLER_182_569 VPWR VGND VPWR VGND sky130_ef_sc_hd__decap_12
XFILLER_68_1246 VPWR VGND VPWR VGND sky130_ef_sc_hd__decap_12
XFILLER_146_53 VPWR VGND VPWR VGND sky130_ef_sc_hd__decap_12
XFILLER_190_1129 VPWR VGND VPWR VGND sky130_ef_sc_hd__decap_12
XFILLER_172_1541 VPWR VGND VPWR VGND sky130_ef_sc_hd__decap_12
XFILLER_146_97 VPWR VGND VPWR VGND sky130_ef_sc_hd__decap_12
XFILLER_1_432 VGND VGND VPWR VPWR sky130_fd_sc_hd__fill_2
XFILLER_2_977 VGND VGND VPWR VPWR sky130_fd_sc_hd__decap_3
XTAP_TAPCELL_ROW_22_2_3122 VGND VPWR sky130_fd_sc_hd__tapvpwrvgnd_1
XFILLER_39_51 VGND VGND VPWR VPWR sky130_fd_sc_hd__decap_4
XFILLER_209_217 VGND VGND VPWR VPWR sky130_fd_sc_hd__decap_6
XFILLER_162_41 VPWR VGND VPWR VGND sky130_ef_sc_hd__decap_12
XFILLER_7_1037 VPWR VGND VPWR VGND sky130_ef_sc_hd__decap_12
XFILLER_162_85 VPWR VGND VPWR VGND sky130_ef_sc_hd__decap_12
XFILLER_213_1593 VPWR VGND VPWR VGND sky130_ef_sc_hd__decap_12
XPHY_EDGE_ROW_154_2_Left_586 VGND VGND VPWR VPWR sky130_fd_sc_hd__decap_3
XFILLER_79_1342 VPWR VGND VPWR VGND sky130_ef_sc_hd__decap_12
XFILLER_217_261 VPWR VGND VPWR VGND sky130_ef_sc_hd__decap_12
XTAP_TAPCELL_ROW_205_2582 VGND VPWR sky130_fd_sc_hd__tapvpwrvgnd_1
XTAP_TAPCELL_ROW_205_2571 VGND VPWR sky130_fd_sc_hd__tapvpwrvgnd_1
X_615_ clknet_3_6_0_clk _049_ VGND VGND VPWR VPWR net72 sky130_fd_sc_hd__dfxtp_1
XFILLER_206_979 VGND VGND VPWR VPWR sky130_fd_sc_hd__fill_1
XTAP_TAPCELL_ROW_205_2593 VGND VPWR sky130_fd_sc_hd__tapvpwrvgnd_1
XTAP_TAPCELL_ROW_201_2457 VGND VPWR sky130_fd_sc_hd__tapvpwrvgnd_1
XFILLER_189_113 VPWR VGND VPWR VGND sky130_ef_sc_hd__decap_12
XFILLER_79_1386 VPWR VGND VPWR VGND sky130_ef_sc_hd__decap_12
X_546_ net81 net123 VGND VGND VPWR VPWR _247_ sky130_fd_sc_hd__or2_1
XTAP_TAPCELL_ROW_201_2479 VGND VPWR sky130_fd_sc_hd__tapvpwrvgnd_1
XTAP_TAPCELL_ROW_201_2468 VGND VPWR sky130_fd_sc_hd__tapvpwrvgnd_1
XTAP_TAPCELL_ROW_197_2361 VGND VPWR sky130_fd_sc_hd__tapvpwrvgnd_1
XTAP_TAPCELL_ROW_197_2350 VGND VPWR sky130_fd_sc_hd__tapvpwrvgnd_1
XPHY_EDGE_ROW_91_2_Left_523 VGND VGND VPWR VPWR sky130_fd_sc_hd__decap_3
XFILLER_18_1602 VGND VGND VPWR VPWR sky130_fd_sc_hd__decap_3
XTAP_TAPCELL_ROW_193_2247 VGND VPWR sky130_fd_sc_hd__tapvpwrvgnd_1
XTAP_TAPCELL_ROW_193_2236 VGND VPWR sky130_fd_sc_hd__tapvpwrvgnd_1
X_477_ _181_ _185_ _195_ _196_ VGND VGND VPWR VPWR _209_ sky130_fd_sc_hd__or4_1
XTAP_TAPCELL_ROW_218_2954 VGND VPWR sky130_fd_sc_hd__tapvpwrvgnd_1
XTAP_TAPCELL_ROW_218_2943 VGND VPWR sky130_fd_sc_hd__tapvpwrvgnd_1
XFILLER_201_673 VPWR VGND VPWR VGND sky130_ef_sc_hd__decap_12
XFILLER_199_1121 VPWR VGND VPWR VGND sky130_ef_sc_hd__decap_12
XFILLER_164_1091 VGND VGND VPWR VPWR sky130_fd_sc_hd__fill_1
XFILLER_140_1518 VGND VGND VPWR VPWR sky130_fd_sc_hd__decap_6
XPHY_EDGE_ROW_11_1_Left_230 VGND VGND VPWR VPWR sky130_fd_sc_hd__decap_3
XTAP_TAPCELL_ROW_218_2965 VGND VPWR sky130_fd_sc_hd__tapvpwrvgnd_1
XTAP_TAPCELL_ROW_214_2829 VGND VPWR sky130_fd_sc_hd__tapvpwrvgnd_1
XFILLER_187_93 VPWR VGND VPWR VGND sky130_ef_sc_hd__decap_12
XFILLER_185_385 VGND VGND VPWR VPWR sky130_fd_sc_hd__decap_6
XFILLER_173_503 VGND VGND VPWR VPWR sky130_fd_sc_hd__fill_1
XFILLER_71_93 VPWR VGND VPWR VGND sky130_ef_sc_hd__decap_12
XFILLER_16_1370 VPWR VGND VPWR VGND sky130_ef_sc_hd__decap_12
XFILLER_195_1007 VGND VGND VPWR VPWR sky130_fd_sc_hd__fill_1
XFILLER_86_1302 VPWR VGND VPWR VGND sky130_ef_sc_hd__decap_12
XFILLER_51_1272 VGND VGND VPWR VPWR sky130_fd_sc_hd__fill_1
XPHY_EDGE_ROW_136_1_Right_722 VGND VGND VPWR VPWR sky130_fd_sc_hd__decap_3
XFILLER_103_1384 VGND VGND VPWR VPWR sky130_fd_sc_hd__fill_1
XANTENNA__560__S net122 VGND VGND VPWR VPWR sky130_fd_sc_hd__diode_2
XFILLER_138_1414 VPWR VGND VPWR VGND sky130_ef_sc_hd__decap_12
XFILLER_113_113 VPWR VGND VPWR VGND sky130_ef_sc_hd__decap_12
XTAP_TAPCELL_ROW_118_2_3744 VGND VPWR sky130_fd_sc_hd__tapvpwrvgnd_1
XFILLER_3_1413 VPWR VGND VPWR VGND sky130_ef_sc_hd__decap_12
XFILLER_23_1330 VPWR VGND VPWR VGND sky130_ef_sc_hd__decap_12
XTAP_TAPCELL_ROW_182_1940 VGND VPWR sky130_fd_sc_hd__tapvpwrvgnd_1
XFILLER_110_1300 VGND VGND VPWR VPWR sky130_fd_sc_hd__fill_1
XFILLER_7_1593 VGND VGND VPWR VPWR sky130_fd_sc_hd__decap_3
XTAP_TAPCELL_ROW_163_1383 VGND VPWR sky130_fd_sc_hd__tapvpwrvgnd_1
XTAP_TAPCELL_ROW_163_1372 VGND VPWR sky130_fd_sc_hd__tapvpwrvgnd_1
XTAP_TAPCELL_ROW_163_1361 VGND VPWR sky130_fd_sc_hd__tapvpwrvgnd_1
XTAP_TAPCELL_ROW_163_1350 VGND VPWR sky130_fd_sc_hd__tapvpwrvgnd_1
XFILLER_149_1510 VPWR VGND VPWR VGND sky130_ef_sc_hd__decap_12
XFILLER_97_1442 VPWR VGND VPWR VGND sky130_ef_sc_hd__decap_12
XFILLER_3_1457 VPWR VGND VPWR VGND sky130_ef_sc_hd__decap_12
XFILLER_212_905 VPWR VGND VPWR VGND sky130_ef_sc_hd__decap_12
XFILLER_208_1117 VPWR VGND VPWR VGND sky130_ef_sc_hd__decap_12
XTAP_TAPCELL_ROW_163_1394 VGND VPWR sky130_fd_sc_hd__tapvpwrvgnd_1
XFILLER_149_1554 VPWR VGND VPWR VGND sky130_ef_sc_hd__decap_12
XFILLER_93_1328 VGND VGND VPWR VPWR sky130_fd_sc_hd__fill_1
XFILLER_58_1426 VPWR VGND VPWR VGND sky130_ef_sc_hd__decap_12
XFILLER_212_949 VPWR VGND VPWR VGND sky130_ef_sc_hd__decap_12
XFILLER_180_1309 VGND VGND VPWR VPWR sky130_fd_sc_hd__decap_6
XFILLER_169_809 VPWR VGND VPWR VGND sky130_ef_sc_hd__decap_12
XFILLER_195_105 VGND VGND VPWR VPWR sky130_fd_sc_hd__decap_6
XANTENNA__366__A1 net153 VGND VGND VPWR VPWR sky130_fd_sc_hd__diode_2
XFILLER_195_149 VPWR VGND VPWR VGND sky130_ef_sc_hd__decap_12
XFILLER_177_853 VPWR VGND VPWR VGND sky130_ef_sc_hd__decap_12
XTAP_TAPCELL_ROW_176_1755 VGND VPWR sky130_fd_sc_hd__tapvpwrvgnd_1
XTAP_TAPCELL_ROW_176_1744 VGND VPWR sky130_fd_sc_hd__tapvpwrvgnd_1
XFILLER_178_1205 VPWR VGND VPWR VGND sky130_ef_sc_hd__decap_12
XFILLER_177_897 VPWR VGND VPWR VGND sky130_ef_sc_hd__decap_12
XTAP_TAPCELL_ROW_176_1766 VGND VPWR sky130_fd_sc_hd__tapvpwrvgnd_1
XFILLER_176_363 VGND VGND VPWR VPWR sky130_fd_sc_hd__fill_1
XFILLER_34_1470 VPWR VGND VPWR VGND sky130_ef_sc_hd__decap_12
XFILLER_192_867 VGND VGND VPWR VPWR sky130_fd_sc_hd__fill_1
XFILLER_164_525 VGND VGND VPWR VPWR sky130_fd_sc_hd__decap_6
XFILLER_121_1440 VGND VGND VPWR VPWR sky130_fd_sc_hd__fill_1
XFILLER_164_569 VPWR VGND VPWR VGND sky130_ef_sc_hd__decap_12
XFILLER_69_1522 VPWR VGND VPWR VGND sky130_ef_sc_hd__decap_12
XFILLER_30_1356 VGND VGND VPWR VPWR sky130_fd_sc_hd__fill_1
XFILLER_69_1566 VPWR VGND VPWR VGND sky130_ef_sc_hd__decap_12
XFILLER_219_1257 VGND VGND VPWR VPWR sky130_fd_sc_hd__decap_3
XFILLER_191_1449 VGND VGND VPWR VPWR sky130_fd_sc_hd__decap_6
XFILLER_8_1302 VPWR VGND VPWR VGND sky130_ef_sc_hd__decap_12
XFILLER_189_1301 VPWR VGND VPWR VGND sky130_ef_sc_hd__decap_12
XFILLER_154_1282 VPWR VGND VPWR VGND sky130_ef_sc_hd__decap_12
XFILLER_115_1244 VPWR VGND VPWR VGND sky130_ef_sc_hd__decap_12
XPHY_EDGE_ROW_87_1_Left_306 VGND VGND VPWR VPWR sky130_fd_sc_hd__decap_3
XFILLER_76_27 VGND VGND VPWR VPWR sky130_fd_sc_hd__fill_1
XFILLER_206_209 VPWR VGND VPWR VGND sky130_ef_sc_hd__decap_12
XFILLER_189_1345 VPWR VGND VPWR VGND sky130_ef_sc_hd__decap_12
XFILLER_132_1580 VGND VGND VPWR VPWR sky130_fd_sc_hd__fill_1
XFILLER_215_721 VGND VGND VPWR VPWR sky130_fd_sc_hd__decap_6
XFILLER_132_77 VGND VGND VPWR VPWR sky130_fd_sc_hd__decap_6
XFILLER_92_15 VPWR VGND VPWR VGND sky130_ef_sc_hd__decap_12
XFILLER_41_1496 VGND VGND VPWR VPWR sky130_fd_sc_hd__fill_1
XFILLER_215_765 VPWR VGND VPWR VGND sky130_ef_sc_hd__decap_12
XFILLER_76_1526 VPWR VGND VPWR VGND sky130_ef_sc_hd__decap_12
X_400_ _135_ _136_ _117_ VGND VGND VPWR VPWR _137_ sky130_fd_sc_hd__a21oi_1
XFILLER_214_253 VPWR VGND VPWR VGND sky130_ef_sc_hd__decap_12
XFILLER_187_617 VPWR VGND VPWR VGND sky130_ef_sc_hd__decap_12
XFILLER_155_3 VPWR VGND VPWR VGND sky130_ef_sc_hd__decap_12
XFILLER_25_42 VPWR VGND VPWR VGND sky130_ef_sc_hd__decap_12
XFILLER_41_111 VGND VGND VPWR VPWR sky130_fd_sc_hd__fill_1
X_331_ b_addr\[6\] net9 net140 VGND VGND VPWR VPWR s_addr\[6\] sky130_fd_sc_hd__mux2_1
XFILLER_161_1220 VPWR VGND VPWR VGND sky130_ef_sc_hd__decap_12
XFILLER_74_1294 VGND VGND VPWR VPWR sky130_fd_sc_hd__decap_6
XFILLER_35_1256 VPWR VGND VPWR VGND sky130_ef_sc_hd__decap_12
XFILLER_161_1286 VPWR VGND VPWR VGND sky130_ef_sc_hd__decap_12
XTAP_TAPCELL_ROW_124_2_3787 VGND VPWR sky130_fd_sc_hd__tapvpwrvgnd_1
XFILLER_13_1510 VPWR VGND VPWR VGND sky130_ef_sc_hd__decap_12
XTAP_TAPCELL_ROW_16_1_1050 VGND VPWR sky130_fd_sc_hd__tapvpwrvgnd_1
XFILLER_202_1261 VPWR VGND VPWR VGND sky130_ef_sc_hd__decap_12
XFILLER_182_333 VPWR VGND VPWR VGND sky130_ef_sc_hd__decap_12
XFILLER_167_385 VGND VGND VPWR VPWR sky130_fd_sc_hd__decap_6
XFILLER_13_1554 VPWR VGND VPWR VGND sky130_ef_sc_hd__decap_12
XFILLER_183_889 VGND VGND VPWR VPWR sky130_fd_sc_hd__decap_6
XFILLER_100_1524 VGND VGND VPWR VPWR sky130_fd_sc_hd__fill_1
XTAP_TAPCELL_ROW_92_2_3576 VGND VPWR sky130_fd_sc_hd__tapvpwrvgnd_1
XFILLER_6_557 VGND VGND VPWR VPWR sky130_fd_sc_hd__decap_3
XFILLER_182_377 VPWR VGND VPWR VGND sky130_ef_sc_hd__decap_12
XTAP_TAPCELL_ROW_104_2_3652 VGND VPWR sky130_fd_sc_hd__tapvpwrvgnd_1
XFILLER_194_1073 VPWR VGND VPWR VGND sky130_ef_sc_hd__decap_12
XTAP_TAPCELL_ROW_186_2051 VGND VPWR sky130_fd_sc_hd__tapvpwrvgnd_1
XTAP_TAPCELL_ROW_186_2040 VGND VPWR sky130_fd_sc_hd__tapvpwrvgnd_1
XFILLER_173_51 VGND VGND VPWR VPWR sky130_fd_sc_hd__decap_4
XTAP_TAPCELL_ROW_104_1_1226 VGND VPWR sky130_fd_sc_hd__tapvpwrvgnd_1
XFILLER_81_1232 VPWR VGND VPWR VGND sky130_ef_sc_hd__decap_12
XFILLER_172_1371 VGND VGND VPWR VPWR sky130_fd_sc_hd__fill_1
XFILLER_133_1322 VGND VGND VPWR VPWR sky130_fd_sc_hd__decap_6
XTAP_TAPCELL_ROW_207_2644 VGND VPWR sky130_fd_sc_hd__tapvpwrvgnd_1
XTAP_TAPCELL_ROW_207_2633 VGND VPWR sky130_fd_sc_hd__tapvpwrvgnd_1
XFILLER_133_1366 VPWR VGND VPWR VGND sky130_ef_sc_hd__decap_12
XFILLER_81_1298 VPWR VGND VPWR VGND sky130_ef_sc_hd__decap_12
XPHY_EDGE_ROW_204_Left_423 VGND VGND VPWR VPWR sky130_fd_sc_hd__decap_3
XFILLER_218_581 VGND VGND VPWR VPWR sky130_fd_sc_hd__decap_6
XTAP_TAPCELL_ROW_203_2519 VGND VPWR sky130_fd_sc_hd__tapvpwrvgnd_1
XTAP_TAPCELL_ROW_199_2423 VGND VPWR sky130_fd_sc_hd__tapvpwrvgnd_1
XTAP_TAPCELL_ROW_199_2412 VGND VPWR sky130_fd_sc_hd__tapvpwrvgnd_1
XTAP_TAPCELL_ROW_199_2401 VGND VPWR sky130_fd_sc_hd__tapvpwrvgnd_1
XFILLER_168_1429 VPWR VGND VPWR VGND sky130_ef_sc_hd__decap_12
XTAP_TAPCELL_ROW_71_1_1160 VGND VPWR sky130_fd_sc_hd__tapvpwrvgnd_1
XFILLER_209_1437 VPWR VGND VPWR VGND sky130_ef_sc_hd__decap_12
XTAP_TAPCELL_ROW_195_2309 VGND VPWR sky130_fd_sc_hd__tapvpwrvgnd_1
XFILLER_177_105 VGND VGND VPWR VPWR sky130_fd_sc_hd__decap_6
XFILLER_166_1197 VGND VGND VPWR VPWR sky130_fd_sc_hd__decap_6
XFILLER_92_1350 VGND VGND VPWR VPWR sky130_fd_sc_hd__decap_6
X_529_ net149 _190_ net127 net138 _238_ VGND VGND VPWR VPWR _048_ sky130_fd_sc_hd__o311a_1
XANTENNA__348__A1 b_addr\[5\] VGND VGND VPWR VPWR sky130_fd_sc_hd__diode_2
XFILLER_193_609 VGND VGND VPWR VPWR sky130_fd_sc_hd__decap_6
XFILLER_177_149 VPWR VGND VPWR VGND sky130_ef_sc_hd__decap_12
XFILLER_144_1462 VGND VGND VPWR VPWR sky130_fd_sc_hd__decap_6
XFILLER_92_1394 VPWR VGND VPWR VGND sky130_ef_sc_hd__decap_12
XPHY_EDGE_ROW_213_Left_432 VGND VGND VPWR VPWR sky130_fd_sc_hd__decap_3
XFILLER_202_993 VPWR VGND VPWR VGND sky130_ef_sc_hd__decap_12
XFILLER_140_1326 VPWR VGND VPWR VGND sky130_ef_sc_hd__decap_12
XFILLER_53_1378 VGND VGND VPWR VPWR sky130_fd_sc_hd__decap_6
XFILLER_185_193 VPWR VGND VPWR VGND sky130_ef_sc_hd__decap_12
XFILLER_179_1525 VPWR VGND VPWR VGND sky130_ef_sc_hd__decap_12
XFILLER_70_3 VPWR VGND VPWR VGND sky130_ef_sc_hd__decap_12
XFILLER_179_1569 VPWR VGND VPWR VGND sky130_ef_sc_hd__decap_12
XFILLER_174_867 VGND VGND VPWR VPWR sky130_fd_sc_hd__fill_1
XFILLER_99_111 VGND VGND VPWR VPWR sky130_fd_sc_hd__fill_1
Xoutput103 net103 VGND VGND VPWR VPWR func_rdata[22] sky130_fd_sc_hd__buf_2
Xoutput114 net114 VGND VGND VPWR VPWR func_rdata[3] sky130_fd_sc_hd__buf_2
XFILLER_217_55 VGND VGND VPWR VPWR sky130_fd_sc_hd__fill_1
XFILLER_173_1113 VGND VGND VPWR VPWR sky130_fd_sc_hd__decap_6
XFILLER_138_1244 VGND VGND VPWR VPWR sky130_fd_sc_hd__fill_1
XPHY_EDGE_ROW_137_1_Right_723 VGND VGND VPWR VPWR sky130_fd_sc_hd__decap_3
XFILLER_173_1157 VPWR VGND VPWR VGND sky130_ef_sc_hd__decap_12
XFILLER_101_105 VGND VGND VPWR VPWR sky130_fd_sc_hd__decap_6
XFILLER_151_1422 VPWR VGND VPWR VGND sky130_ef_sc_hd__decap_12
XTAP_TAPCELL_ROW_169_1570 VGND VPWR sky130_fd_sc_hd__tapvpwrvgnd_1
XTAP_TAPCELL_ROW_165_1434 VGND VPWR sky130_fd_sc_hd__tapvpwrvgnd_1
XFILLER_151_1466 VPWR VGND VPWR VGND sky130_ef_sc_hd__decap_12
XFILLER_112_1406 VGND VGND VPWR VPWR sky130_fd_sc_hd__decap_6
XANTENNA__611__CLK clknet_3_6_0_clk VGND VGND VPWR VPWR sky130_fd_sc_hd__diode_2
XANTENNA__284__B1 net153 VGND VGND VPWR VPWR sky130_fd_sc_hd__diode_2
XFILLER_60_1338 VPWR VGND VPWR VGND sky130_ef_sc_hd__decap_12
XFILLER_210_1029 VGND VGND VPWR VPWR sky130_fd_sc_hd__decap_6
XTAP_TAPCELL_ROW_165_1456 VGND VPWR sky130_fd_sc_hd__tapvpwrvgnd_1
XTAP_TAPCELL_ROW_165_1445 VGND VPWR sky130_fd_sc_hd__tapvpwrvgnd_1
XFILLER_97_1272 VGND VGND VPWR VPWR sky130_fd_sc_hd__fill_1
XFILLER_3_1287 VGND VGND VPWR VPWR sky130_fd_sc_hd__fill_1
XFILLER_212_713 VPWR VGND VPWR VGND sky130_ef_sc_hd__decap_12
XFILLER_184_1253 VGND VGND VPWR VPWR sky130_fd_sc_hd__decap_6
XTAP_TAPCELL_ROW_178_1806 VGND VPWR sky130_fd_sc_hd__tapvpwrvgnd_1
XFILLER_149_1384 VGND VGND VPWR VPWR sky130_fd_sc_hd__fill_1
XFILLER_212_757 VPWR VGND VPWR VGND sky130_ef_sc_hd__decap_12
XFILLER_211_223 VGND VGND VPWR VPWR sky130_fd_sc_hd__fill_1
XFILLER_184_1297 VPWR VGND VPWR VGND sky130_ef_sc_hd__decap_12
XFILLER_180_1117 VPWR VGND VPWR VGND sky130_ef_sc_hd__decap_12
XTAP_TAPCELL_ROW_178_1817 VGND VPWR sky130_fd_sc_hd__tapvpwrvgnd_1
XFILLER_169_617 VPWR VGND VPWR VGND sky130_ef_sc_hd__decap_12
XFILLER_62_29 VPWR VGND VPWR VGND sky130_ef_sc_hd__decap_12
XFILLER_196_469 VGND VGND VPWR VPWR sky130_fd_sc_hd__decap_6
XFILLER_178_29 VPWR VGND VPWR VGND sky130_ef_sc_hd__decap_12
XFILLER_162_1562 VPWR VGND VPWR VGND sky130_ef_sc_hd__decap_12
XTAP_TAPCELL_ROW_110_2_3695 VGND VPWR sky130_fd_sc_hd__tapvpwrvgnd_1
XFILLER_71_1434 VGND VGND VPWR VPWR sky130_fd_sc_hd__decap_6
XANTENNA_fanout148_X net148 VGND VGND VPWR VPWR sky130_fd_sc_hd__diode_2
XFILLER_123_1546 VGND VGND VPWR VPWR sky130_fd_sc_hd__decap_6
XTAP_TAPCELL_ROW_109_2_3689 VGND VPWR sky130_fd_sc_hd__tapvpwrvgnd_1
XFILLER_71_1478 VPWR VGND VPWR VGND sky130_ef_sc_hd__decap_12
XFILLER_164_333 VPWR VGND VPWR VGND sky130_ef_sc_hd__decap_12
XTAP_TAPCELL_ROW_77_2_3478 VGND VPWR sky130_fd_sc_hd__tapvpwrvgnd_1
XFILLER_203_1581 VPWR VGND VPWR VGND sky130_ef_sc_hd__decap_12
XFILLER_178_1035 VGND VGND VPWR VPWR sky130_fd_sc_hd__fill_1
XFILLER_165_889 VGND VGND VPWR VPWR sky130_fd_sc_hd__decap_6
XFILLER_219_1021 VPWR VGND VPWR VGND sky130_ef_sc_hd__decap_12
XFILLER_180_837 VPWR VGND VPWR VGND sky130_ef_sc_hd__decap_12
XFILLER_164_377 VPWR VGND VPWR VGND sky130_ef_sc_hd__decap_12
XFILLER_156_1300 VGND VGND VPWR VPWR sky130_fd_sc_hd__fill_1
XFILLER_69_1330 VPWR VGND VPWR VGND sky130_ef_sc_hd__decap_12
XFILLER_11_55 VGND VGND VPWR VPWR sky130_fd_sc_hd__fill_1
XFILLER_195_1393 VGND VGND VPWR VPWR sky130_fd_sc_hd__decap_6
XFILLER_191_1213 VPWR VGND VPWR VGND sky130_ef_sc_hd__decap_12
XFILLER_127_55 VGND VGND VPWR VPWR sky130_fd_sc_hd__fill_1
XFILLER_87_15 VPWR VGND VPWR VGND sky130_ef_sc_hd__decap_12
XANTENNA__511__A1 net149 VGND VGND VPWR VPWR sky130_fd_sc_hd__diode_2
XFILLER_219_1065 VPWR VGND VPWR VGND sky130_ef_sc_hd__decap_12
XFILLER_191_1257 VPWR VGND VPWR VGND sky130_ef_sc_hd__decap_12
XFILLER_117_1328 VGND VGND VPWR VPWR sky130_fd_sc_hd__fill_1
XFILLER_82_1574 VGND VGND VPWR VPWR sky130_fd_sc_hd__decap_6
XFILLER_130_1506 VPWR VGND VPWR VGND sky130_ef_sc_hd__decap_12
XFILLER_4_1029 VGND VGND VPWR VPWR sky130_fd_sc_hd__decap_6
XFILLER_219_389 VGND VGND VPWR VPWR sky130_fd_sc_hd__decap_3
XFILLER_210_1541 VPWR VGND VPWR VGND sky130_ef_sc_hd__decap_12
XFILLER_207_529 VPWR VGND VPWR VGND sky130_ef_sc_hd__decap_12
XFILLER_189_1175 VGND VGND VPWR VPWR sky130_fd_sc_hd__fill_1
XFILLER_36_41 VPWR VGND VPWR VGND sky130_ef_sc_hd__decap_12
XFILLER_215_573 VPWR VGND VPWR VGND sky130_ef_sc_hd__decap_12
XFILLER_76_1356 VGND VGND VPWR VPWR sky130_fd_sc_hd__fill_1
XFILLER_36_85 VPWR VGND VPWR VGND sky130_ef_sc_hd__decap_12
XFILLER_188_937 VPWR VGND VPWR VGND sky130_ef_sc_hd__decap_12
XFILLER_159_105 VGND VGND VPWR VPWR sky130_fd_sc_hd__decap_6
XFILLER_202_245 VGND VGND VPWR VPWR sky130_fd_sc_hd__decap_6
XFILLER_187_447 VGND VGND VPWR VPWR sky130_fd_sc_hd__fill_1
XFILLER_175_609 VGND VGND VPWR VPWR sky130_fd_sc_hd__decap_6
XFILLER_141_1602 VGND VGND VPWR VPWR sky130_fd_sc_hd__decap_3
XFILLER_128_1468 VGND VGND VPWR VPWR sky130_fd_sc_hd__fill_1
X_314_ net25 net143 net133 VGND VGND VPWR VPWR s_wdata\[21\] sky130_fd_sc_hd__a21o_1
XFILLER_202_289 VPWR VGND VPWR VGND sky130_ef_sc_hd__decap_12
XFILLER_196_981 VPWR VGND VPWR VGND sky130_ef_sc_hd__decap_12
XFILLER_50_1518 VGND VGND VPWR VPWR sky130_fd_sc_hd__decap_6
Xinput16 func_wdata[13] VGND VGND VPWR VPWR net16 sky130_fd_sc_hd__clkbuf_1
Xinput27 func_wdata[23] VGND VGND VPWR VPWR net27 sky130_fd_sc_hd__clkbuf_1
XTAP_TAPCELL_ROW_47_1_1111 VGND VPWR sky130_fd_sc_hd__tapvpwrvgnd_1
XFILLER_183_653 VPWR VGND VPWR VGND sky130_ef_sc_hd__decap_12
XFILLER_182_141 VPWR VGND VPWR VGND sky130_ef_sc_hd__decap_12
XFILLER_167_193 VPWR VGND VPWR VGND sky130_ef_sc_hd__decap_12
Xinput38 func_wdata[4] VGND VGND VPWR VPWR net38 sky130_fd_sc_hd__clkbuf_1
XFILLER_6_321 VPWR VGND VPWR VGND sky130_ef_sc_hd__decap_12
XFILLER_202_1091 VGND VGND VPWR VPWR sky130_fd_sc_hd__fill_1
XTAP_TAPCELL_ROW_188_2102 VGND VPWR sky130_fd_sc_hd__tapvpwrvgnd_1
XFILLER_183_697 VPWR VGND VPWR VGND sky130_ef_sc_hd__decap_12
XTAP_TAPCELL_ROW_154_2_3982 VGND VPWR sky130_fd_sc_hd__tapvpwrvgnd_1
XFILLER_6_365 VGND VGND VPWR VPWR sky130_fd_sc_hd__decap_6
XFILLER_13_1384 VGND VGND VPWR VPWR sky130_fd_sc_hd__fill_1
XANTENNA__404__A b_addr\[4\] VGND VGND VPWR VPWR sky130_fd_sc_hd__diode_2
XFILLER_48_1414 VPWR VGND VPWR VGND sky130_ef_sc_hd__decap_12
XFILLER_184_83 VGND VGND VPWR VPWR sky130_fd_sc_hd__fill_1
XFILLER_174_1477 VGND VGND VPWR VPWR sky130_fd_sc_hd__decap_6
XFILLER_87_1496 VGND VGND VPWR VPWR sky130_fd_sc_hd__fill_1
XANTENNA__634__CLK clknet_3_3_0_clk VGND VGND VPWR VPWR sky130_fd_sc_hd__diode_2
XTAP_TAPCELL_ROW_209_2706 VGND VPWR sky130_fd_sc_hd__tapvpwrvgnd_1
XFILLER_2_571 VGND VGND VPWR VPWR sky130_fd_sc_hd__fill_1
XFILLER_77_81 VPWR VGND VPWR VGND sky130_ef_sc_hd__decap_12
XFILLER_4_1541 VPWR VGND VPWR VGND sky130_ef_sc_hd__decap_12
XFILLER_20_1300 VGND VGND VPWR VPWR sky130_fd_sc_hd__fill_1
XFILLER_203_57 VPWR VGND VPWR VGND sky130_ef_sc_hd__decap_12
XFILLER_168_1259 VGND VGND VPWR VPWR sky130_fd_sc_hd__fill_1
XFILLER_94_1412 VGND VGND VPWR VPWR sky130_fd_sc_hd__fill_1
XFILLER_59_1510 VPWR VGND VPWR VGND sky130_ef_sc_hd__decap_12
XFILLER_209_1201 VPWR VGND VPWR VGND sky130_ef_sc_hd__decap_12
XFILLER_59_1554 VPWR VGND VPWR VGND sky130_ef_sc_hd__decap_12
XFILLER_209_1245 VPWR VGND VPWR VGND sky130_ef_sc_hd__decap_12
XFILLER_181_1437 VPWR VGND VPWR VGND sky130_ef_sc_hd__decap_12
XFILLER_146_1524 VGND VGND VPWR VPWR sky130_fd_sc_hd__fill_1
XPHY_EDGE_ROW_117_2_Left_549 VGND VGND VPWR VPWR sky130_fd_sc_hd__decap_3
XFILLER_209_1289 VPWR VGND VPWR VGND sky130_ef_sc_hd__decap_12
XFILLER_20_114 VPWR VGND VPWR VGND sky130_ef_sc_hd__decap_12
XFILLER_193_417 VPWR VGND VPWR VGND sky130_ef_sc_hd__decap_12
XFILLER_178_469 VGND VGND VPWR VPWR sky130_fd_sc_hd__decap_6
XFILLER_144_1270 VPWR VGND VPWR VGND sky130_ef_sc_hd__decap_12
XTAP_TAPCELL_ROW_63_2_3386 VGND VPWR sky130_fd_sc_hd__tapvpwrvgnd_1
XFILLER_105_1232 VPWR VGND VPWR VGND sky130_ef_sc_hd__decap_12
XFILLER_105_1298 VPWR VGND VPWR VGND sky130_ef_sc_hd__decap_12
XFILLER_31_1440 VGND VGND VPWR VPWR sky130_fd_sc_hd__fill_1
XFILLER_192_1533 VGND VGND VPWR VPWR sky130_fd_sc_hd__decap_6
XFILLER_179_1399 VGND VGND VPWR VPWR sky130_fd_sc_hd__fill_1
XFILLER_216_1205 VPWR VGND VPWR VGND sky130_ef_sc_hd__decap_12
XFILLER_170_881 VPWR VGND VPWR VGND sky130_ef_sc_hd__decap_12
XPHY_EDGE_ROW_138_1_Right_724 VGND VGND VPWR VPWR sky130_fd_sc_hd__decap_3
XFILLER_192_1577 VPWR VGND VPWR VGND sky130_ef_sc_hd__decap_12
XTAP_TAPCELL_ROW_167_1507 VGND VPWR sky130_fd_sc_hd__tapvpwrvgnd_1
XFILLER_87_125 VGND VGND VPWR VPWR sky130_fd_sc_hd__fill_2
XFILLER_116_1350 VGND VGND VPWR VPWR sky130_fd_sc_hd__decap_6
XFILLER_64_1282 VPWR VGND VPWR VGND sky130_ef_sc_hd__decap_12
XFILLER_25_1244 VPWR VGND VPWR VGND sky130_ef_sc_hd__decap_12
XFILLER_151_1274 VPWR VGND VPWR VGND sky130_ef_sc_hd__decap_12
XFILLER_116_1394 VPWR VGND VPWR VGND sky130_ef_sc_hd__decap_12
XFILLER_9_1496 VGND VGND VPWR VPWR sky130_fd_sc_hd__fill_1
XFILLER_186_1315 VGND VGND VPWR VPWR sky130_fd_sc_hd__fill_1
XFILLER_112_1258 VPWR VGND VPWR VGND sky130_ef_sc_hd__decap_12
XFILLER_42_1580 VGND VGND VPWR VPWR sky130_fd_sc_hd__fill_1
XFILLER_113_57 VPWR VGND VPWR VGND sky130_ef_sc_hd__decap_12
XFILLER_99_1378 VGND VGND VPWR VPWR sky130_fd_sc_hd__decap_6
XTAP_TAPCELL_ROW_219_3002 VGND VPWR sky130_fd_sc_hd__tapvpwrvgnd_1
XFILLER_73_39 VPWR VGND VPWR VGND sky130_ef_sc_hd__decap_12
XTAP_TAPCELL_ROW_219_3024 VGND VPWR sky130_fd_sc_hd__tapvpwrvgnd_1
XTAP_TAPCELL_ROW_219_3013 VGND VPWR sky130_fd_sc_hd__tapvpwrvgnd_1
XFILLER_189_39 VPWR VGND VPWR VGND sky130_ef_sc_hd__decap_12
XFILLER_184_1061 VPWR VGND VPWR VGND sky130_ef_sc_hd__decap_12
XFILLER_196_233 VPWR VGND VPWR VGND sky130_ef_sc_hd__decap_12
XFILLER_169_447 VGND VGND VPWR VPWR sky130_fd_sc_hd__fill_1
XFILLER_71_1220 VPWR VGND VPWR VGND sky130_ef_sc_hd__decap_12
XFILLER_212_587 VGND VGND VPWR VPWR sky130_fd_sc_hd__fill_1
XFILLER_200_749 VGND VGND VPWR VPWR sky130_fd_sc_hd__decap_6
XFILLER_196_277 VPWR VGND VPWR VGND sky130_ef_sc_hd__decap_12
XFILLER_178_981 VPWR VGND VPWR VGND sky130_ef_sc_hd__decap_12
XFILLER_162_1370 VPWR VGND VPWR VGND sky130_ef_sc_hd__decap_12
XTAP_TAPCELL_ROW_128_1_1274 VGND VPWR sky130_fd_sc_hd__tapvpwrvgnd_1
XFILLER_127_1490 VGND VGND VPWR VPWR sky130_fd_sc_hd__decap_6
XFILLER_123_1310 VPWR VGND VPWR VGND sky130_ef_sc_hd__decap_12
XFILLER_123_1354 VPWR VGND VPWR VGND sky130_ef_sc_hd__decap_12
XFILLER_71_1286 VPWR VGND VPWR VGND sky130_ef_sc_hd__decap_12
XFILLER_193_951 VGND VGND VPWR VPWR sky130_fd_sc_hd__fill_1
XFILLER_165_653 VPWR VGND VPWR VGND sky130_ef_sc_hd__decap_12
XFILLER_164_141 VPWR VGND VPWR VGND sky130_ef_sc_hd__decap_12
XTAP_TAPCELL_ROW_140_2_3890 VGND VPWR sky130_fd_sc_hd__tapvpwrvgnd_1
XTAP_TAPCELL_ROW_139_2_3884 VGND VPWR sky130_fd_sc_hd__tapvpwrvgnd_1
XFILLER_197_1455 VGND VGND VPWR VPWR sky130_fd_sc_hd__fill_1
XFILLER_180_601 VPWR VGND VPWR VGND sky130_ef_sc_hd__decap_12
XFILLER_165_697 VPWR VGND VPWR VGND sky130_ef_sc_hd__decap_12
XFILLER_158_1406 VGND VGND VPWR VPWR sky130_fd_sc_hd__decap_6
XFILLER_138_65 VPWR VGND VPWR VGND sky130_ef_sc_hd__decap_12
XFILLER_123_1398 VPWR VGND VPWR VGND sky130_ef_sc_hd__decap_12
XFILLER_118_3 VPWR VGND VPWR VGND sky130_ef_sc_hd__decap_12
XFILLER_4_825 VPWR VGND VPWR VGND sky130_ef_sc_hd__decap_12
XFILLER_10_1524 VGND VGND VPWR VPWR sky130_fd_sc_hd__fill_1
XFILLER_180_645 VPWR VGND VPWR VGND sky130_ef_sc_hd__decap_12
XFILLER_4_869 VGND VGND VPWR VPWR sky130_fd_sc_hd__fill_2
XFILLER_191_1021 VPWR VGND VPWR VGND sky130_ef_sc_hd__decap_12
XFILLER_0_3 VPWR VGND VPWR VGND sky130_ef_sc_hd__decap_12
XFILLER_191_1065 VPWR VGND VPWR VGND sky130_ef_sc_hd__decap_12
XFILLER_154_53 VPWR VGND VPWR VGND sky130_ef_sc_hd__decap_12
XFILLER_154_97 VPWR VGND VPWR VGND sky130_ef_sc_hd__decap_12
XFILLER_134_1450 VPWR VGND VPWR VGND sky130_ef_sc_hd__decap_12
XTAP_TAPCELL_ROW_132_2_3838 VGND VPWR sky130_fd_sc_hd__tapvpwrvgnd_1
XFILLER_82_1382 VPWR VGND VPWR VGND sky130_ef_sc_hd__decap_12
XANTENNA_input38_A func_wdata[4] VGND VGND VPWR VPWR sky130_fd_sc_hd__diode_2
XFILLER_43_1322 VGND VGND VPWR VPWR sky130_fd_sc_hd__decap_6
XFILLER_208_805 VGND VGND VPWR VPWR sky130_fd_sc_hd__decap_6
XFILLER_130_1314 VPWR VGND VPWR VGND sky130_ef_sc_hd__decap_12
XFILLER_43_1366 VPWR VGND VPWR VGND sky130_ef_sc_hd__decap_12
XFILLER_219_153 VPWR VGND VPWR VGND sky130_ef_sc_hd__decap_12
XFILLER_208_849 VPWR VGND VPWR VGND sky130_ef_sc_hd__decap_12
XFILLER_170_41 VPWR VGND VPWR VGND sky130_ef_sc_hd__decap_12
XFILLER_169_1513 VPWR VGND VPWR VGND sky130_ef_sc_hd__decap_12
XFILLER_134_1494 VPWR VGND VPWR VGND sky130_ef_sc_hd__decap_12
XFILLER_130_1358 VPWR VGND VPWR VGND sky130_ef_sc_hd__decap_12
XFILLER_47_51 VGND VGND VPWR VPWR sky130_fd_sc_hd__decap_4
XFILLER_219_197 VPWR VGND VPWR VGND sky130_ef_sc_hd__decap_12
XFILLER_210_1371 VGND VGND VPWR VPWR sky130_fd_sc_hd__fill_1
XFILLER_207_337 VPWR VGND VPWR VGND sky130_ef_sc_hd__decap_12
XTAP_TAPCELL_ROW_112_2_3703 VGND VPWR sky130_fd_sc_hd__tapvpwrvgnd_1
XTAP_TAPCELL_ROW_3_891 VGND VPWR sky130_fd_sc_hd__tapvpwrvgnd_1
XTAP_TAPCELL_ROW_3_880 VGND VPWR sky130_fd_sc_hd__tapvpwrvgnd_1
XFILLER_170_85 VPWR VGND VPWR VGND sky130_ef_sc_hd__decap_12
XPHY_EDGE_ROW_100_1_Right_686 VGND VGND VPWR VPWR sky130_fd_sc_hd__decap_3
XFILLER_216_893 VPWR VGND VPWR VGND sky130_ef_sc_hd__decap_12
XFILLER_188_701 VPWR VGND VPWR VGND sky130_ef_sc_hd__decap_12
XFILLER_167_1281 VGND VGND VPWR VPWR sky130_fd_sc_hd__decap_6
XFILLER_128_1232 VPWR VGND VPWR VGND sky130_ef_sc_hd__decap_12
XFILLER_206_1429 VPWR VGND VPWR VGND sky130_ef_sc_hd__decap_12
XFILLER_163_1145 VGND VGND VPWR VPWR sky130_fd_sc_hd__decap_3
XFILLER_175_417 VPWR VGND VPWR VGND sky130_ef_sc_hd__decap_12
XFILLER_163_1189 VPWR VGND VPWR VGND sky130_ef_sc_hd__decap_12
XFILLER_141_1410 VPWR VGND VPWR VGND sky130_ef_sc_hd__decap_12
XTAP_TAPCELL_ROW_48_2_3288 VGND VPWR sky130_fd_sc_hd__tapvpwrvgnd_1
XFILLER_54_1462 VGND VGND VPWR VPWR sky130_fd_sc_hd__decap_6
XFILLER_145_1590 VPWR VGND VPWR VGND sky130_ef_sc_hd__decap_12
XFILLER_50_1326 VPWR VGND VPWR VGND sky130_ef_sc_hd__decap_12
XFILLER_204_1197 VGND VGND VPWR VPWR sky130_fd_sc_hd__decap_6
XFILLER_200_1017 VPWR VGND VPWR VGND sky130_ef_sc_hd__decap_12
XFILLER_184_973 VGND VGND VPWR VPWR sky130_fd_sc_hd__decap_6
XFILLER_141_1454 VPWR VGND VPWR VGND sky130_ef_sc_hd__decap_12
XFILLER_106_1574 VGND VGND VPWR VPWR sky130_fd_sc_hd__decap_6
XFILLER_102_1438 VPWR VGND VPWR VGND sky130_ef_sc_hd__decap_12
XFILLER_183_461 VPWR VGND VPWR VGND sky130_ef_sc_hd__decap_12
XFILLER_141_1498 VPWR VGND VPWR VGND sky130_ef_sc_hd__decap_12
XFILLER_7_685 VPWR VGND VPWR VGND sky130_ef_sc_hd__decap_12
XFILLER_195_93 VPWR VGND VPWR VGND sky130_ef_sc_hd__decap_12
XFILLER_176_1539 VGND VGND VPWR VPWR sky130_fd_sc_hd__fill_1
XFILLER_170_133 VGND VGND VPWR VPWR sky130_fd_sc_hd__decap_6
XFILLER_6_195 VGND VGND VPWR VPWR sky130_fd_sc_hd__fill_1
XFILLER_217_1525 VPWR VGND VPWR VGND sky130_ef_sc_hd__decap_12
XFILLER_174_1241 VPWR VGND VPWR VGND sky130_ef_sc_hd__decap_12
XANTENNA__487__B1 net135 VGND VGND VPWR VPWR sky130_fd_sc_hd__diode_2
XFILLER_48_1244 VGND VGND VPWR VPWR sky130_fd_sc_hd__fill_1
XFILLER_217_1569 VPWR VGND VPWR VGND sky130_ef_sc_hd__decap_12
XFILLER_174_1285 VPWR VGND VPWR VGND sky130_ef_sc_hd__decap_12
XFILLER_170_1105 VPWR VGND VPWR VGND sky130_ef_sc_hd__decap_12
XFILLER_170_177 VPWR VGND VPWR VGND sky130_ef_sc_hd__decap_12
XFILLER_69_125 VGND VGND VPWR VPWR sky130_fd_sc_hd__fill_2
XFILLER_33_3 VPWR VGND VPWR VGND sky130_ef_sc_hd__decap_12
XFILLER_170_1149 VPWR VGND VPWR VGND sky130_ef_sc_hd__decap_12
XFILLER_61_1422 VPWR VGND VPWR VGND sky130_ef_sc_hd__decap_12
XFILLER_211_1113 VGND VGND VPWR VPWR sky130_fd_sc_hd__decap_6
XFILLER_152_1550 VPWR VGND VPWR VGND sky130_ef_sc_hd__decap_12
XFILLER_113_1534 VPWR VGND VPWR VGND sky130_ef_sc_hd__decap_12
XFILLER_22_1406 VGND VGND VPWR VPWR sky130_fd_sc_hd__decap_6
XFILLER_61_1466 VPWR VGND VPWR VGND sky130_ef_sc_hd__decap_12
XFILLER_211_1157 VPWR VGND VPWR VGND sky130_ef_sc_hd__decap_12
XFILLER_152_1594 VGND VGND VPWR VPWR sky130_fd_sc_hd__decap_8
XTAP_TAPCELL_ROW_1_817 VGND VPWR sky130_fd_sc_hd__tapvpwrvgnd_1
XFILLER_113_1578 VPWR VGND VPWR VGND sky130_ef_sc_hd__decap_12
XFILLER_96_1518 VGND VGND VPWR VPWR sky130_fd_sc_hd__decap_6
XFILLER_4_1371 VGND VGND VPWR VPWR sky130_fd_sc_hd__fill_1
XTAP_TAPCELL_ROW_1_828 VGND VPWR sky130_fd_sc_hd__tapvpwrvgnd_1
XFILLER_94_1220 VPWR VGND VPWR VGND sky130_ef_sc_hd__decap_12
XFILLER_213_329 VGND VGND VPWR VPWR sky130_fd_sc_hd__decap_6
XFILLER_185_1381 VPWR VGND VPWR VGND sky130_ef_sc_hd__decap_12
XFILLER_181_1201 VPWR VGND VPWR VGND sky130_ef_sc_hd__decap_12
XFILLER_0_1257 VGND VGND VPWR VPWR sky130_fd_sc_hd__decap_3
XFILLER_59_1384 VGND VGND VPWR VPWR sky130_fd_sc_hd__fill_1
XFILLER_181_1245 VPWR VGND VPWR VGND sky130_ef_sc_hd__decap_12
XFILLER_178_233 VPWR VGND VPWR VGND sky130_ef_sc_hd__decap_12
XPHY_EDGE_ROW_159_1_Left_378 VGND VGND VPWR VPWR sky130_fd_sc_hd__decap_3
XFILLER_194_737 VPWR VGND VPWR VGND sky130_ef_sc_hd__decap_12
XFILLER_193_225 VPWR VGND VPWR VGND sky130_ef_sc_hd__decap_12
XFILLER_181_1289 VPWR VGND VPWR VGND sky130_ef_sc_hd__decap_12
XFILLER_178_277 VPWR VGND VPWR VGND sky130_ef_sc_hd__decap_12
XPHY_EDGE_ROW_164_Left_383 VGND VGND VPWR VPWR sky130_fd_sc_hd__decap_3
XTAP_TAPCELL_ROW_125_2_3792 VGND VPWR sky130_fd_sc_hd__tapvpwrvgnd_1
XPHY_EDGE_ROW_96_1_Left_315 VGND VGND VPWR VPWR sky130_fd_sc_hd__decap_3
XFILLER_72_1562 VPWR VGND VPWR VGND sky130_ef_sc_hd__decap_12
XFILLER_33_1546 VGND VGND VPWR VPWR sky130_fd_sc_hd__decap_6
XFILLER_175_951 VGND VGND VPWR VPWR sky130_fd_sc_hd__fill_1
XFILLER_120_1538 VPWR VGND VPWR VGND sky130_ef_sc_hd__decap_12
XTAP_TAPCELL_ROW_93_2_3581 VGND VPWR sky130_fd_sc_hd__tapvpwrvgnd_1
XFILLER_161_111 VGND VGND VPWR VPWR sky130_fd_sc_hd__fill_1
XFILLER_66_1300 VGND VGND VPWR VPWR sky130_fd_sc_hd__fill_1
XFILLER_200_1595 VGND VGND VPWR VPWR sky130_fd_sc_hd__fill_1
XFILLER_192_1341 VPWR VGND VPWR VGND sky130_ef_sc_hd__decap_12
XFILLER_118_1412 VGND VGND VPWR VPWR sky130_fd_sc_hd__fill_1
XFILLER_216_1035 VGND VGND VPWR VPWR sky130_fd_sc_hd__fill_1
XFILLER_1_839 VGND VGND VPWR VPWR sky130_fd_sc_hd__fill_1
XFILLER_27_1328 VGND VGND VPWR VPWR sky130_fd_sc_hd__fill_1
XFILLER_192_1385 VPWR VGND VPWR VGND sky130_ef_sc_hd__decap_12
XPHY_EDGE_ROW_173_Left_392 VGND VGND VPWR VPWR sky130_fd_sc_hd__decap_3
XPHY_EDGE_ROW_139_1_Right_725 VGND VGND VPWR VPWR sky130_fd_sc_hd__decap_3
XTAP_TAPCELL_ROW_85_2_3529 VGND VPWR sky130_fd_sc_hd__tapvpwrvgnd_1
XFILLER_5_1113 VGND VGND VPWR VPWR sky130_fd_sc_hd__decap_6
XFILLER_40_1506 VPWR VGND VPWR VGND sky130_ef_sc_hd__decap_12
XFILLER_84_27 VGND VGND VPWR VPWR sky130_fd_sc_hd__fill_1
XFILLER_5_1157 VPWR VGND VPWR VGND sky130_ef_sc_hd__decap_12
XFILLER_90_109 VPWR VGND VPWR VGND sky130_ef_sc_hd__decap_12
XFILLER_204_307 VGND VGND VPWR VPWR sky130_fd_sc_hd__fill_1
XFILLER_77_1440 VGND VGND VPWR VPWR sky130_fd_sc_hd__fill_1
XFILLER_17_54 VGND VGND VPWR VPWR sky130_fd_sc_hd__fill_2
XFILLER_216_189 VGND VGND VPWR VPWR sky130_fd_sc_hd__decap_6
XFILLER_164_1421 VGND VGND VPWR VPWR sky130_fd_sc_hd__decap_6
XFILLER_213_841 VPWR VGND VPWR VGND sky130_ef_sc_hd__decap_12
XFILLER_140_77 VGND VGND VPWR VPWR sky130_fd_sc_hd__decap_6
XFILLER_129_1552 VGND VGND VPWR VPWR sky130_fd_sc_hd__fill_1
XANTENNA__402__B1 net156 VGND VGND VPWR VPWR sky130_fd_sc_hd__diode_2
XTAP_TAPCELL_ROW_34_2_3196 VGND VPWR sky130_fd_sc_hd__tapvpwrvgnd_1
XFILLER_200_513 VPWR VGND VPWR VGND sky130_ef_sc_hd__decap_12
XFILLER_197_553 VGND VGND VPWR VPWR sky130_fd_sc_hd__decap_6
XFILLER_164_1465 VPWR VGND VPWR VGND sky130_ef_sc_hd__decap_12
XFILLER_38_1468 VGND VGND VPWR VPWR sky130_fd_sc_hd__fill_1
XFILLER_51_1602 VGND VGND VPWR VPWR sky130_fd_sc_hd__decap_3
XFILLER_200_557 VPWR VGND VPWR VGND sky130_ef_sc_hd__decap_12
XFILLER_197_597 VPWR VGND VPWR VGND sky130_ef_sc_hd__decap_12
XTAP_TAPCELL_ROW_159_1_1335 VGND VPWR sky130_fd_sc_hd__tapvpwrvgnd_1
XFILLER_201_1337 VGND VGND VPWR VPWR sky130_fd_sc_hd__decap_6
XPHY_EDGE_ROW_80_1_Left_299 VGND VGND VPWR VPWR sky130_fd_sc_hd__decap_3
XTAP_TAPCELL_ROW_64_1_1146 VGND VPWR sky130_fd_sc_hd__tapvpwrvgnd_1
XTAP_TAPCELL_ROW_14_2_3072 VGND VPWR sky130_fd_sc_hd__tapvpwrvgnd_1
XFILLER_181_921 VPWR VGND VPWR VGND sky130_ef_sc_hd__decap_12
XFILLER_166_973 VGND VGND VPWR VPWR sky130_fd_sc_hd__decap_6
XFILLER_165_461 VPWR VGND VPWR VGND sky130_ef_sc_hd__decap_12
XFILLER_181_965 VPWR VGND VPWR VGND sky130_ef_sc_hd__decap_12
XFILLER_180_475 VGND VGND VPWR VPWR sky130_fd_sc_hd__fill_1
XFILLER_158_1258 VPWR VGND VPWR VGND sky130_ef_sc_hd__decap_12
XFILLER_88_1580 VGND VGND VPWR VPWR sky130_fd_sc_hd__fill_1
XFILLER_175_1561 VGND VGND VPWR VPWR sky130_fd_sc_hd__decap_6
XFILLER_3_165 VGND VGND VPWR VPWR sky130_fd_sc_hd__fill_1
XFILLER_171_1425 VPWR VGND VPWR VGND sky130_ef_sc_hd__decap_12
XFILLER_181_51 VGND VGND VPWR VPWR sky130_fd_sc_hd__decap_4
XFILLER_171_1469 VPWR VGND VPWR VGND sky130_ef_sc_hd__decap_12
XFILLER_58_83 VGND VGND VPWR VPWR sky130_fd_sc_hd__fill_1
XFILLER_208_613 VPWR VGND VPWR VGND sky130_ef_sc_hd__decap_12
Xhold5 net88 VGND VGND VPWR VPWR net175 sky130_fd_sc_hd__dlygate4sd3_1
XFILLER_212_1477 VGND VGND VPWR VPWR sky130_fd_sc_hd__decap_6
XFILLER_208_657 VPWR VGND VPWR VGND sky130_ef_sc_hd__decap_12
XFILLER_1_1511 VGND VGND VPWR VPWR sky130_fd_sc_hd__fill_1
XFILLER_207_167 VGND VGND VPWR VPWR sky130_fd_sc_hd__fill_1
XFILLER_169_1343 VGND VGND VPWR VPWR sky130_fd_sc_hd__fill_1
XPHY_EDGE_ROW_101_1_Right_687 VGND VGND VPWR VPWR sky130_fd_sc_hd__decap_3
XFILLER_188_531 VGND VGND VPWR VPWR sky130_fd_sc_hd__fill_1
XFILLER_182_1521 VPWR VGND VPWR VGND sky130_ef_sc_hd__decap_12
XFILLER_56_1524 VGND VGND VPWR VPWR sky130_fd_sc_hd__fill_1
XFILLER_203_373 VPWR VGND VPWR VGND sky130_ef_sc_hd__decap_12
XFILLER_182_1565 VPWR VGND VPWR VGND sky130_ef_sc_hd__decap_12
Xu_sram.u_mem_165 VGND VGND VPWR VPWR u_sram.u_mem_165/HI net165 sky130_fd_sc_hd__conb_1
XFILLER_206_1259 VGND VGND VPWR VPWR sky130_fd_sc_hd__fill_1
XFILLER_198_1005 VPWR VGND VPWR VGND sky130_ef_sc_hd__decap_12
XFILLER_176_737 VPWR VGND VPWR VGND sky130_ef_sc_hd__decap_12
XFILLER_175_225 VPWR VGND VPWR VGND sky130_ef_sc_hd__decap_12
XFILLER_54_1270 VPWR VGND VPWR VGND sky130_ef_sc_hd__decap_12
XTAP_TAPCELL_ROW_78_2_3483 VGND VPWR sky130_fd_sc_hd__tapvpwrvgnd_1
XFILLER_15_1232 VPWR VGND VPWR VGND sky130_ef_sc_hd__decap_12
XFILLER_198_1049 VPWR VGND VPWR VGND sky130_ef_sc_hd__decap_12
XFILLER_191_729 VPWR VGND VPWR VGND sky130_ef_sc_hd__decap_12
XFILLER_184_781 VPWR VGND VPWR VGND sky130_ef_sc_hd__decap_12
XFILLER_106_1382 VPWR VGND VPWR VGND sky130_ef_sc_hd__decap_12
XFILLER_102_1246 VPWR VGND VPWR VGND sky130_ef_sc_hd__decap_12
XFILLER_89_1322 VGND VGND VPWR VPWR sky130_fd_sc_hd__decap_6
XFILLER_15_1298 VPWR VGND VPWR VGND sky130_ef_sc_hd__decap_12
XFILLER_143_111 VGND VGND VPWR VPWR sky130_fd_sc_hd__fill_1
XFILLER_89_1366 VPWR VGND VPWR VGND sky130_ef_sc_hd__decap_12
XTAP_TAPCELL_ROW_103_2_3648 VGND VPWR sky130_fd_sc_hd__tapvpwrvgnd_1
XFILLER_171_497 VGND VGND VPWR VPWR sky130_fd_sc_hd__decap_6
XFILLER_174_1093 VPWR VGND VPWR VGND sky130_ef_sc_hd__decap_12
XTAP_TAPCELL_ROW_71_2_3437 VGND VPWR sky130_fd_sc_hd__tapvpwrvgnd_1
XFILLER_217_1399 VGND VGND VPWR VPWR sky130_fd_sc_hd__fill_1
XFILLER_26_1350 VGND VGND VPWR VPWR sky130_fd_sc_hd__decap_6
XFILLER_113_1342 VPWR VGND VPWR VGND sky130_ef_sc_hd__decap_12
XFILLER_26_1394 VPWR VGND VPWR VGND sky130_ef_sc_hd__decap_12
XFILLER_61_1274 VPWR VGND VPWR VGND sky130_ef_sc_hd__decap_12
XFILLER_72_109 VPWR VGND VPWR VGND sky130_ef_sc_hd__decap_12
XFILLER_6_1477 VGND VGND VPWR VPWR sky130_fd_sc_hd__decap_6
XFILLER_22_1258 VPWR VGND VPWR VGND sky130_ef_sc_hd__decap_12
XFILLER_113_1386 VPWR VGND VPWR VGND sky130_ef_sc_hd__decap_12
XFILLER_96_1326 VPWR VGND VPWR VGND sky130_ef_sc_hd__decap_12
XFILLER_148_1438 VPWR VGND VPWR VGND sky130_ef_sc_hd__decap_12
XFILLER_74_1602 VGND VGND VPWR VPWR sky130_fd_sc_hd__decap_3
XFILLER_0_1021 VPWR VGND VPWR VGND sky130_ef_sc_hd__decap_12
XFILLER_213_137 VPWR VGND VPWR VGND sky130_ef_sc_hd__decap_12
XFILLER_0_1065 VPWR VGND VPWR VGND sky130_ef_sc_hd__decap_12
XFILLER_210_811 VGND VGND VPWR VPWR sky130_fd_sc_hd__fill_1
XFILLER_194_501 VPWR VGND VPWR VGND sky130_ef_sc_hd__decap_12
XFILLER_179_553 VGND VGND VPWR VPWR sky130_fd_sc_hd__decap_6
XFILLER_179_597 VPWR VGND VPWR VGND sky130_ef_sc_hd__decap_12
XFILLER_72_1370 VPWR VGND VPWR VGND sky130_ef_sc_hd__decap_12
XFILLER_70_29 VPWR VGND VPWR VGND sky130_ef_sc_hd__decap_12
XFILLER_33_1310 VPWR VGND VPWR VGND sky130_ef_sc_hd__decap_12
XFILLER_194_545 VPWR VGND VPWR VGND sky130_ef_sc_hd__decap_12
XFILLER_186_29 VPWR VGND VPWR VGND sky130_ef_sc_hd__decap_12
XFILLER_120_1302 VPWR VGND VPWR VGND sky130_ef_sc_hd__decap_12
XFILLER_33_1354 VPWR VGND VPWR VGND sky130_ef_sc_hd__decap_12
XFILLER_37_1490 VGND VGND VPWR VPWR sky130_fd_sc_hd__decap_6
XFILLER_194_589 VPWR VGND VPWR VGND sky130_ef_sc_hd__decap_12
XFILLER_181_217 VGND VGND VPWR VPWR sky130_fd_sc_hd__decap_6
XFILLER_163_921 VGND VGND VPWR VPWR sky130_fd_sc_hd__decap_3
XFILLER_124_1482 VPWR VGND VPWR VGND sky130_ef_sc_hd__decap_12
XFILLER_159_1534 VPWR VGND VPWR VGND sky130_ef_sc_hd__decap_12
XFILLER_79_27 VPWR VGND VPWR VGND sky130_ef_sc_hd__decap_12
XFILLER_68_1406 VGND VGND VPWR VPWR sky130_fd_sc_hd__decap_6
XFILLER_33_1398 VPWR VGND VPWR VGND sky130_ef_sc_hd__decap_12
XFILLER_163_965 VPWR VGND VPWR VGND sky130_ef_sc_hd__decap_12
XFILLER_159_1578 VPWR VGND VPWR VGND sky130_ef_sc_hd__decap_12
XPHY_EDGE_ROW_181_Left_400 VGND VGND VPWR VPWR sky130_fd_sc_hd__decap_3
XFILLER_118_1220 VPWR VGND VPWR VGND sky130_ef_sc_hd__decap_12
XFILLER_135_55 VGND VGND VPWR VPWR sky130_fd_sc_hd__fill_1
XFILLER_0_113 VPWR VGND VPWR VGND sky130_ef_sc_hd__decap_12
XFILLER_95_15 VPWR VGND VPWR VGND sky130_ef_sc_hd__decap_12
XFILLER_0_179 VGND VGND VPWR VPWR sky130_fd_sc_hd__decap_3
XTAP_TAPCELL_ROW_5_931 VGND VPWR sky130_fd_sc_hd__tapvpwrvgnd_1
XTAP_TAPCELL_ROW_5_942 VGND VPWR sky130_fd_sc_hd__tapvpwrvgnd_1
XFILLER_44_1450 VPWR VGND VPWR VGND sky130_ef_sc_hd__decap_12
XTAP_TAPCELL_ROW_147_2_3935 VGND VPWR sky130_fd_sc_hd__tapvpwrvgnd_1
XFILLER_40_1314 VPWR VGND VPWR VGND sky130_ef_sc_hd__decap_12
XFILLER_188_1229 VPWR VGND VPWR VGND sky130_ef_sc_hd__decap_12
XFILLER_185_3 VPWR VGND VPWR VGND sky130_ef_sc_hd__decap_12
XFILLER_131_1442 VPWR VGND VPWR VGND sky130_ef_sc_hd__decap_12
X_631_ clknet_3_1_0_clk _065_ VGND VGND VPWR VPWR net56 sky130_fd_sc_hd__dfxtp_1
XFILLER_40_1358 VPWR VGND VPWR VGND sky130_ef_sc_hd__decap_12
XFILLER_44_1494 VPWR VGND VPWR VGND sky130_ef_sc_hd__decap_12
XFILLER_79_1546 VGND VGND VPWR VPWR sky130_fd_sc_hd__decap_6
X_562_ net56 u_ctrl.cmp_addr\[7\] net122 VGND VGND VPWR VPWR _255_ sky130_fd_sc_hd__mux2_1
XFILLER_189_317 VPWR VGND VPWR VGND sky130_ef_sc_hd__decap_12
XFILLER_207_1513 VPWR VGND VPWR VGND sky130_ef_sc_hd__decap_12
X_493_ net149 _187_ net127 net135 _220_ VGND VGND VPWR VPWR _030_ sky130_fd_sc_hd__o311a_1
XFILLER_44_41 VPWR VGND VPWR VGND sky130_ef_sc_hd__decap_12
XFILLER_213_671 VGND VGND VPWR VPWR sky130_fd_sc_hd__fill_1
XFILLER_38_1243 VGND VGND VPWR VPWR sky130_fd_sc_hd__fill_2
XFILLER_44_85 VPWR VGND VPWR VGND sky130_ef_sc_hd__decap_12
XFILLER_201_833 VGND VGND VPWR VPWR sky130_fd_sc_hd__decap_6
XFILLER_200_321 VPWR VGND VPWR VGND sky130_ef_sc_hd__decap_12
XFILLER_197_361 VPWR VGND VPWR VGND sky130_ef_sc_hd__decap_12
XFILLER_164_1273 VPWR VGND VPWR VGND sky130_ef_sc_hd__decap_12
XTAP_TAPCELL_ROW_64_2_3391 VGND VPWR sky130_fd_sc_hd__tapvpwrvgnd_1
XFILLER_51_1410 VPWR VGND VPWR VGND sky130_ef_sc_hd__decap_12
XFILLER_201_1101 VPWR VGND VPWR VGND sky130_ef_sc_hd__decap_12
XFILLER_201_877 VPWR VGND VPWR VGND sky130_ef_sc_hd__decap_12
XFILLER_200_365 VPWR VGND VPWR VGND sky130_ef_sc_hd__decap_12
XFILLER_199_1325 VPWR VGND VPWR VGND sky130_ef_sc_hd__decap_12
XFILLER_125_1268 VGND VGND VPWR VPWR sky130_fd_sc_hd__decap_4
XTAP_TAPCELL_ROW_95_1_1207 VGND VPWR sky130_fd_sc_hd__tapvpwrvgnd_1
XFILLER_90_1470 VPWR VGND VPWR VGND sky130_ef_sc_hd__decap_12
XFILLER_55_1590 VPWR VGND VPWR VGND sky130_ef_sc_hd__decap_12
XFILLER_205_1281 VGND VGND VPWR VPWR sky130_fd_sc_hd__decap_6
XFILLER_201_1145 VPWR VGND VPWR VGND sky130_ef_sc_hd__decap_12
XFILLER_199_1369 VPWR VGND VPWR VGND sky130_ef_sc_hd__decap_12
XTAP_TAPCELL_ROW_191_2186 VGND VPWR sky130_fd_sc_hd__tapvpwrvgnd_1
XTAP_TAPCELL_ROW_191_2175 VGND VPWR sky130_fd_sc_hd__tapvpwrvgnd_1
XFILLER_173_729 VPWR VGND VPWR VGND sky130_ef_sc_hd__decap_12
XFILLER_166_781 VPWR VGND VPWR VGND sky130_ef_sc_hd__decap_12
XFILLER_142_1582 VPWR VGND VPWR VGND sky130_ef_sc_hd__decap_12
XFILLER_103_1522 VPWR VGND VPWR VGND sky130_ef_sc_hd__decap_12
XFILLER_12_1438 VPWR VGND VPWR VGND sky130_ef_sc_hd__decap_12
XFILLER_16_1574 VGND VGND VPWR VPWR sky130_fd_sc_hd__decap_6
XFILLER_51_1454 VPWR VGND VPWR VGND sky130_ef_sc_hd__decap_12
XTAP_TAPCELL_ROW_216_2893 VGND VPWR sky130_fd_sc_hd__tapvpwrvgnd_1
XTAP_TAPCELL_ROW_216_2882 VGND VPWR sky130_fd_sc_hd__tapvpwrvgnd_1
XTAP_TAPCELL_ROW_191_2197 VGND VPWR sky130_fd_sc_hd__tapvpwrvgnd_1
XFILLER_125_111 VGND VGND VPWR VPWR sky130_fd_sc_hd__fill_1
XFILLER_103_1566 VPWR VGND VPWR VGND sky130_ef_sc_hd__decap_12
XFILLER_86_1506 VPWR VGND VPWR VGND sky130_ef_sc_hd__decap_12
XFILLER_5_942 VGND VGND VPWR VPWR sky130_fd_sc_hd__decap_8
XFILLER_51_1498 VPWR VGND VPWR VGND sky130_ef_sc_hd__decap_12
XTAP_TAPCELL_ROW_212_2768 VGND VPWR sky130_fd_sc_hd__tapvpwrvgnd_1
XFILLER_201_1189 VPWR VGND VPWR VGND sky130_ef_sc_hd__decap_12
XFILLER_5_953 VPWR VGND VPWR VGND sky130_ef_sc_hd__decap_12
XTAP_TAPCELL_ROW_212_2779 VGND VPWR sky130_fd_sc_hd__tapvpwrvgnd_1
XANTENNA__412__A b_addr\[4\] VGND VGND VPWR VPWR sky130_fd_sc_hd__diode_2
XTAP_TAPCELL_ROW_56_2_3339 VGND VPWR sky130_fd_sc_hd__tapvpwrvgnd_1
XFILLER_171_1233 VPWR VGND VPWR VGND sky130_ef_sc_hd__decap_12
XFILLER_69_93 VPWR VGND VPWR VGND sky130_ef_sc_hd__decap_12
XFILLER_214_1539 VGND VGND VPWR VPWR sky130_fd_sc_hd__fill_1
XFILLER_192_83 VGND VGND VPWR VPWR sky130_fd_sc_hd__fill_1
XPHY_EDGE_ROW_126_2_Left_558 VGND VGND VPWR VPWR sky130_fd_sc_hd__decap_3
XFILLER_212_1241 VPWR VGND VPWR VGND sky130_ef_sc_hd__decap_12
XTAP_TAPCELL_ROW_36_2_3215 VGND VPWR sky130_fd_sc_hd__tapvpwrvgnd_1
XFILLER_62_1550 VPWR VGND VPWR VGND sky130_ef_sc_hd__decap_12
XFILLER_209_933 VPWR VGND VPWR VGND sky130_ef_sc_hd__decap_12
XFILLER_208_421 VPWR VGND VPWR VGND sky130_ef_sc_hd__decap_12
XFILLER_97_1602 VGND VGND VPWR VPWR sky130_fd_sc_hd__decap_3
XFILLER_62_1594 VGND VGND VPWR VPWR sky130_fd_sc_hd__decap_8
XANTENNA__558__S net122 VGND VGND VPWR VPWR sky130_fd_sc_hd__diode_2
XFILLER_23_1534 VPWR VGND VPWR VGND sky130_ef_sc_hd__decap_12
XFILLER_212_1285 VPWR VGND VPWR VGND sky130_ef_sc_hd__decap_12
XFILLER_209_977 VPWR VGND VPWR VGND sky130_ef_sc_hd__decap_12
XFILLER_110_1526 VPWR VGND VPWR VGND sky130_ef_sc_hd__decap_12
XFILLER_85_81 VPWR VGND VPWR VGND sky130_ef_sc_hd__decap_12
XFILLER_23_1578 VPWR VGND VPWR VGND sky130_ef_sc_hd__decap_12
XFILLER_211_57 VPWR VGND VPWR VGND sky130_ef_sc_hd__decap_12
XPHY_EDGE_ROW_102_1_Right_688 VGND VGND VPWR VPWR sky130_fd_sc_hd__decap_3
XFILLER_204_693 VGND VGND VPWR VPWR sky130_fd_sc_hd__decap_6
XFILLER_203_181 VPWR VGND VPWR VGND sky130_ef_sc_hd__decap_12
XFILLER_189_895 VGND VGND VPWR VPWR sky130_fd_sc_hd__fill_1
XFILLER_182_1373 VPWR VGND VPWR VGND sky130_ef_sc_hd__decap_12
XFILLER_176_501 VPWR VGND VPWR VGND sky130_ef_sc_hd__decap_12
XFILLER_91_1256 VPWR VGND VPWR VGND sky130_ef_sc_hd__decap_12
XFILLER_176_545 VPWR VGND VPWR VGND sky130_ef_sc_hd__decap_12
XTAP_TAPCELL_ROW_142_1_1302 VGND VPWR sky130_fd_sc_hd__tapvpwrvgnd_1
XFILLER_178_1409 VPWR VGND VPWR VGND sky130_ef_sc_hd__decap_12
XFILLER_176_589 VPWR VGND VPWR VGND sky130_ef_sc_hd__decap_12
XANTENNA__590__Q b_addr\[6\] VGND VGND VPWR VPWR sky130_fd_sc_hd__diode_2
XFILLER_191_559 VGND VGND VPWR VPWR sky130_fd_sc_hd__fill_1
XTAP_TAPCELL_ROW_174_1694 VGND VPWR sky130_fd_sc_hd__tapvpwrvgnd_1
XFILLER_30_1538 VPWR VGND VPWR VGND sky130_ef_sc_hd__decap_12
XFILLER_171_261 VPWR VGND VPWR VGND sky130_ef_sc_hd__decap_12
XFILLER_28_1412 VGND VGND VPWR VPWR sky130_fd_sc_hd__fill_1
XFILLER_131_125 VGND VGND VPWR VPWR sky130_fd_sc_hd__fill_2
XFILLER_8_1506 VPWR VGND VPWR VGND sky130_ef_sc_hd__decap_12
XTAP_TAPCELL_ROW_133_2_3843 VGND VPWR sky130_fd_sc_hd__tapvpwrvgnd_1
XFILLER_189_1505 VGND VGND VPWR VPWR sky130_fd_sc_hd__decap_6
XFILLER_189_1549 VPWR VGND VPWR VGND sky130_ef_sc_hd__decap_12
XFILLER_105_69 VPWR VGND VPWR VGND sky130_ef_sc_hd__decap_12
XFILLER_2_1105 VPWR VGND VPWR VGND sky130_ef_sc_hd__decap_12
XFILLER_6_1241 VPWR VGND VPWR VGND sky130_ef_sc_hd__decap_12
XTAP_TAPCELL_ROW_88_1_1194 VGND VPWR sky130_fd_sc_hd__tapvpwrvgnd_1
XPHY_EDGE_ROW_64_1_Right_650 VGND VGND VPWR VPWR sky130_fd_sc_hd__decap_3
XFILLER_6_1285 VPWR VGND VPWR VGND sky130_ef_sc_hd__decap_12
XFILLER_214_413 VGND VGND VPWR VPWR sky130_fd_sc_hd__decap_6
XFILLER_199_615 VGND VGND VPWR VPWR sky130_fd_sc_hd__fill_1
XFILLER_2_1149 VPWR VGND VPWR VGND sky130_ef_sc_hd__decap_12
XFILLER_214_457 VPWR VGND VPWR VGND sky130_ef_sc_hd__decap_12
XFILLER_148_1246 VPWR VGND VPWR VGND sky130_ef_sc_hd__decap_12
XFILLER_121_57 VPWR VGND VPWR VGND sky130_ef_sc_hd__decap_12
XFILLER_186_309 VPWR VGND VPWR VGND sky130_ef_sc_hd__decap_12
XFILLER_81_39 VPWR VGND VPWR VGND sky130_ef_sc_hd__decap_12
XFILLER_39_1552 VGND VGND VPWR VPWR sky130_fd_sc_hd__fill_1
XFILLER_197_39 VPWR VGND VPWR VGND sky130_ef_sc_hd__decap_12
XFILLER_195_821 VPWR VGND VPWR VGND sky130_ef_sc_hd__decap_12
XFILLER_179_361 VPWR VGND VPWR VGND sky130_ef_sc_hd__decap_12
XFILLER_165_1593 VPWR VGND VPWR VGND sky130_ef_sc_hd__decap_12
XFILLER_195_865 VPWR VGND VPWR VGND sky130_ef_sc_hd__decap_12
XFILLER_14_77 VGND VGND VPWR VPWR sky130_fd_sc_hd__decap_6
XFILLER_14_66 VGND VGND VPWR VPWR sky130_fd_sc_hd__fill_2
XFILLER_202_1421 VGND VGND VPWR VPWR sky130_fd_sc_hd__decap_6
XFILLER_196_1509 VPWR VGND VPWR VGND sky130_ef_sc_hd__decap_12
XFILLER_202_1465 VPWR VGND VPWR VGND sky130_ef_sc_hd__decap_12
XFILLER_107_111 VGND VGND VPWR VPWR sky130_fd_sc_hd__fill_1
XFILLER_159_1342 VPWR VGND VPWR VGND sky130_ef_sc_hd__decap_12
XFILLER_5_249 VPWR VGND VPWR VGND sky130_ef_sc_hd__decap_12
XFILLER_190_581 VGND VGND VPWR VPWR sky130_fd_sc_hd__decap_6
XFILLER_159_1386 VPWR VGND VPWR VGND sky130_ef_sc_hd__decap_12
XFILLER_146_65 VPWR VGND VPWR VGND sky130_ef_sc_hd__decap_12
XFILLER_100_3 VPWR VGND VPWR VGND sky130_ef_sc_hd__decap_12
XFILLER_68_1258 VPWR VGND VPWR VGND sky130_ef_sc_hd__decap_12
XFILLER_2_923 VGND VGND VPWR VPWR sky130_fd_sc_hd__fill_1
XFILLER_172_1553 VPWR VGND VPWR VGND sky130_ef_sc_hd__decap_12
XFILLER_7_1005 VGND VGND VPWR VPWR sky130_fd_sc_hd__decap_3
XTAP_TAPCELL_ROW_22_2_3123 VGND VPWR sky130_fd_sc_hd__tapvpwrvgnd_1
XFILLER_172_1597 VGND VGND VPWR VPWR sky130_fd_sc_hd__decap_8
XFILLER_162_53 VPWR VGND VPWR VGND sky130_ef_sc_hd__decap_12
XFILLER_1_488 VPWR VGND VPWR VGND sky130_ef_sc_hd__decap_12
XFILLER_7_1049 VGND VGND VPWR VPWR sky130_fd_sc_hd__fill_2
XFILLER_213_1561 VGND VGND VPWR VPWR sky130_fd_sc_hd__decap_6
XANTENNA_input20_A func_wdata[17] VGND VGND VPWR VPWR sky130_fd_sc_hd__diode_2
XFILLER_188_1037 VPWR VGND VPWR VGND sky130_ef_sc_hd__decap_12
XFILLER_162_97 VPWR VGND VPWR VGND sky130_ef_sc_hd__decap_12
XFILLER_131_1272 VGND VGND VPWR VPWR sky130_fd_sc_hd__fill_1
XFILLER_79_1310 VPWR VGND VPWR VGND sky130_ef_sc_hd__decap_12
XFILLER_36_109 VGND VGND VPWR VPWR sky130_fd_sc_hd__decap_3
XFILLER_217_273 VGND VGND VPWR VPWR sky130_fd_sc_hd__decap_6
XFILLER_206_925 VPWR VGND VPWR VGND sky130_ef_sc_hd__decap_12
XTAP_TAPCELL_ROW_205_2583 VGND VPWR sky130_fd_sc_hd__tapvpwrvgnd_1
XTAP_TAPCELL_ROW_205_2572 VGND VPWR sky130_fd_sc_hd__tapvpwrvgnd_1
XFILLER_79_1354 VPWR VGND VPWR VGND sky130_ef_sc_hd__decap_12
X_614_ clknet_3_5_0_clk _048_ VGND VGND VPWR VPWR net71 sky130_fd_sc_hd__dfxtp_1
XTAP_TAPCELL_ROW_205_2594 VGND VPWR sky130_fd_sc_hd__tapvpwrvgnd_1
XFILLER_189_125 VPWR VGND VPWR VGND sky130_ef_sc_hd__decap_12
XFILLER_79_1398 VPWR VGND VPWR VGND sky130_ef_sc_hd__decap_12
X_545_ net139 _246_ VGND VGND VPWR VPWR _056_ sky130_fd_sc_hd__and2_1
XTAP_TAPCELL_ROW_201_2469 VGND VPWR sky130_fd_sc_hd__tapvpwrvgnd_1
XTAP_TAPCELL_ROW_201_2458 VGND VPWR sky130_fd_sc_hd__tapvpwrvgnd_1
XTAP_TAPCELL_ROW_197_2362 VGND VPWR sky130_fd_sc_hd__tapvpwrvgnd_1
XTAP_TAPCELL_ROW_197_2351 VGND VPWR sky130_fd_sc_hd__tapvpwrvgnd_1
XFILLER_189_169 VPWR VGND VPWR VGND sky130_ef_sc_hd__decap_12
XFILLER_207_1343 VGND VGND VPWR VPWR sky130_fd_sc_hd__fill_1
XFILLER_198_681 VPWR VGND VPWR VGND sky130_ef_sc_hd__decap_12
XTAP_TAPCELL_ROW_193_2248 VGND VPWR sky130_fd_sc_hd__tapvpwrvgnd_1
XTAP_TAPCELL_ROW_193_2237 VGND VPWR sky130_fd_sc_hd__tapvpwrvgnd_1
X_476_ _169_ _180_ _189_ _190_ VGND VGND VPWR VPWR _208_ sky130_fd_sc_hd__or4_1
XTAP_TAPCELL_ROW_218_2955 VGND VPWR sky130_fd_sc_hd__tapvpwrvgnd_1
XTAP_TAPCELL_ROW_218_2944 VGND VPWR sky130_fd_sc_hd__tapvpwrvgnd_1
XPHY_EDGE_ROW_207_Right_52 VGND VGND VPWR VPWR sky130_fd_sc_hd__decap_3
XFILLER_201_641 VPWR VGND VPWR VGND sky130_ef_sc_hd__decap_12
XTAP_TAPCELL_ROW_218_2966 VGND VPWR sky130_fd_sc_hd__tapvpwrvgnd_1
XFILLER_201_685 VPWR VGND VPWR VGND sky130_ef_sc_hd__decap_12
XFILLER_199_1133 VPWR VGND VPWR VGND sky130_ef_sc_hd__decap_12
XFILLER_200_195 VGND VGND VPWR VPWR sky130_fd_sc_hd__fill_1
XFILLER_199_1177 VPWR VGND VPWR VGND sky130_ef_sc_hd__decap_12
XFILLER_173_559 VGND VGND VPWR VPWR sky130_fd_sc_hd__fill_1
XFILLER_103_1330 VPWR VGND VPWR VGND sky130_ef_sc_hd__decap_12
XFILLER_12_1246 VPWR VGND VPWR VGND sky130_ef_sc_hd__decap_12
XFILLER_16_1382 VPWR VGND VPWR VGND sky130_ef_sc_hd__decap_12
XFILLER_86_1314 VPWR VGND VPWR VGND sky130_ef_sc_hd__decap_12
XFILLER_138_1426 VPWR VGND VPWR VGND sky130_ef_sc_hd__decap_12
XFILLER_86_1358 VPWR VGND VPWR VGND sky130_ef_sc_hd__decap_12
XTAP_TAPCELL_ROW_118_2_3745 VGND VPWR sky130_fd_sc_hd__tapvpwrvgnd_1
XFILLER_113_125 VGND VGND VPWR VPWR sky130_fd_sc_hd__fill_2
XFILLER_218_1483 VGND VGND VPWR VPWR sky130_fd_sc_hd__fill_1
XPHY_EDGE_ROW_216_Right_61 VGND VGND VPWR VPWR sky130_fd_sc_hd__decap_3
XFILLER_171_1063 VGND VGND VPWR VPWR sky130_fd_sc_hd__fill_1
XTAP_TAPCELL_ROW_86_2_3534 VGND VPWR sky130_fd_sc_hd__tapvpwrvgnd_1
XFILLER_23_1342 VPWR VGND VPWR VGND sky130_ef_sc_hd__decap_12
XFILLER_209_741 VPWR VGND VPWR VGND sky130_ef_sc_hd__decap_12
XTAP_TAPCELL_ROW_182_1941 VGND VPWR sky130_fd_sc_hd__tapvpwrvgnd_1
XTAP_TAPCELL_ROW_182_1930 VGND VPWR sky130_fd_sc_hd__tapvpwrvgnd_1
XFILLER_114_1470 VPWR VGND VPWR VGND sky130_ef_sc_hd__decap_12
XFILLER_97_1410 VPWR VGND VPWR VGND sky130_ef_sc_hd__decap_12
XFILLER_3_1425 VPWR VGND VPWR VGND sky130_ef_sc_hd__decap_12
XFILLER_212_1093 VPWR VGND VPWR VGND sky130_ef_sc_hd__decap_12
XFILLER_209_785 VPWR VGND VPWR VGND sky130_ef_sc_hd__decap_12
XFILLER_208_251 VGND VGND VPWR VPWR sky130_fd_sc_hd__fill_1
XTAP_TAPCELL_ROW_163_1373 VGND VPWR sky130_fd_sc_hd__tapvpwrvgnd_1
XTAP_TAPCELL_ROW_163_1362 VGND VPWR sky130_fd_sc_hd__tapvpwrvgnd_1
XTAP_TAPCELL_ROW_163_1351 VGND VPWR sky130_fd_sc_hd__tapvpwrvgnd_1
XFILLER_149_1522 VPWR VGND VPWR VGND sky130_ef_sc_hd__decap_12
XFILLER_110_1356 VGND VGND VPWR VPWR sky130_fd_sc_hd__fill_1
XFILLER_97_1454 VPWR VGND VPWR VGND sky130_ef_sc_hd__decap_12
XTAP_TAPCELL_ROW_66_2_3410 VGND VPWR sky130_fd_sc_hd__tapvpwrvgnd_1
XFILLER_3_1469 VPWR VGND VPWR VGND sky130_ef_sc_hd__decap_12
XANTENNA__585__Q b_addr\[1\] VGND VGND VPWR VPWR sky130_fd_sc_hd__diode_2
XFILLER_23_1386 VPWR VGND VPWR VGND sky130_ef_sc_hd__decap_12
XTAP_TAPCELL_ROW_163_1395 VGND VPWR sky130_fd_sc_hd__tapvpwrvgnd_1
XTAP_TAPCELL_ROW_163_1384 VGND VPWR sky130_fd_sc_hd__tapvpwrvgnd_1
XFILLER_149_1566 VPWR VGND VPWR VGND sky130_ef_sc_hd__decap_12
XFILLER_97_1498 VPWR VGND VPWR VGND sky130_ef_sc_hd__decap_12
XFILLER_58_1438 VPWR VGND VPWR VGND sky130_ef_sc_hd__decap_12
XFILLER_212_917 VGND VGND VPWR VPWR sky130_fd_sc_hd__decap_6
XFILLER_211_405 VPWR VGND VPWR VGND sky130_ef_sc_hd__decap_12
XFILLER_208_1129 VPWR VGND VPWR VGND sky130_ef_sc_hd__decap_12
XFILLER_168_309 VPWR VGND VPWR VGND sky130_ef_sc_hd__decap_12
XFILLER_211_449 VPWR VGND VPWR VGND sky130_ef_sc_hd__decap_12
XFILLER_177_821 VPWR VGND VPWR VGND sky130_ef_sc_hd__decap_12
XPHY_EDGE_ROW_103_1_Right_689 VGND VGND VPWR VPWR sky130_fd_sc_hd__decap_3
XFILLER_177_865 VPWR VGND VPWR VGND sky130_ef_sc_hd__decap_12
XTAP_TAPCELL_ROW_176_1745 VGND VPWR sky130_fd_sc_hd__tapvpwrvgnd_1
XFILLER_192_813 VPWR VGND VPWR VGND sky130_ef_sc_hd__decap_12
XTAP_TAPCELL_ROW_176_1767 VGND VPWR sky130_fd_sc_hd__tapvpwrvgnd_1
XTAP_TAPCELL_ROW_176_1756 VGND VPWR sky130_fd_sc_hd__tapvpwrvgnd_1
XANTENNA_fanout138_A net139 VGND VGND VPWR VPWR sky130_fd_sc_hd__diode_2
XFILLER_30_1302 VPWR VGND VPWR VGND sky130_ef_sc_hd__decap_12
XFILLER_178_1217 VPWR VGND VPWR VGND sky130_ef_sc_hd__decap_12
XFILLER_34_1482 VPWR VGND VPWR VGND sky130_ef_sc_hd__decap_12
XFILLER_69_1534 VPWR VGND VPWR VGND sky130_ef_sc_hd__decap_12
XFILLER_172_581 VGND VGND VPWR VPWR sky130_fd_sc_hd__decap_6
XFILLER_156_1526 VPWR VGND VPWR VGND sky130_ef_sc_hd__decap_12
XFILLER_121_1496 VGND VGND VPWR VPWR sky130_fd_sc_hd__fill_1
XFILLER_69_1578 VPWR VGND VPWR VGND sky130_ef_sc_hd__decap_12
XANTENNA_u_sram.u_mem_clk0 clknet_3_2_0_clk VGND VGND VPWR VPWR sky130_fd_sc_hd__diode_2
XFILLER_28_1220 VPWR VGND VPWR VGND sky130_ef_sc_hd__decap_12
XFILLER_8_1314 VPWR VGND VPWR VGND sky130_ef_sc_hd__decap_12
XFILLER_219_505 VPWR VGND VPWR VGND sky130_ef_sc_hd__decap_12
XFILLER_8_1358 VPWR VGND VPWR VGND sky130_ef_sc_hd__decap_12
XFILLER_189_1313 VPWR VGND VPWR VGND sky130_ef_sc_hd__decap_12
XFILLER_154_1294 VGND VGND VPWR VPWR sky130_fd_sc_hd__decap_6
XFILLER_115_1256 VPWR VGND VPWR VGND sky130_ef_sc_hd__decap_12
XFILLER_189_1357 VPWR VGND VPWR VGND sky130_ef_sc_hd__decap_12
XFILLER_41_1442 VPWR VGND VPWR VGND sky130_ef_sc_hd__decap_12
XFILLER_92_27 VGND VGND VPWR VPWR sky130_fd_sc_hd__fill_1
XFILLER_6_1093 VPWR VGND VPWR VGND sky130_ef_sc_hd__decap_12
XFILLER_214_221 VPWR VGND VPWR VGND sky130_ef_sc_hd__decap_12
XFILLER_76_1538 VPWR VGND VPWR VGND sky130_ef_sc_hd__decap_12
XPHY_EDGE_ROW_65_1_Right_651 VGND VGND VPWR VPWR sky130_fd_sc_hd__decap_3
XFILLER_215_777 VGND VGND VPWR VPWR sky130_fd_sc_hd__decap_6
XFILLER_214_265 VPWR VGND VPWR VGND sky130_ef_sc_hd__decap_12
XFILLER_25_54 VGND VGND VPWR VPWR sky130_fd_sc_hd__fill_2
X_330_ b_addr\[5\] net8 net140 VGND VGND VPWR VPWR s_addr\[5\] sky130_fd_sc_hd__mux2_1
XFILLER_187_629 VPWR VGND VPWR VGND sky130_ef_sc_hd__decap_12
XFILLER_148_3 VPWR VGND VPWR VGND sky130_ef_sc_hd__decap_12
XFILLER_186_139 VGND VGND VPWR VPWR sky130_fd_sc_hd__fill_1
XFILLER_161_1232 VPWR VGND VPWR VGND sky130_ef_sc_hd__decap_12
XFILLER_25_98 VPWR VGND VPWR VGND sky130_ef_sc_hd__decap_12
XFILLER_195_673 VPWR VGND VPWR VGND sky130_ef_sc_hd__decap_12
XFILLER_35_1268 VGND VGND VPWR VPWR sky130_fd_sc_hd__decap_4
XFILLER_196_1317 VPWR VGND VPWR VGND sky130_ef_sc_hd__decap_12
XFILLER_182_301 VGND VGND VPWR VPWR sky130_fd_sc_hd__decap_6
XFILLER_161_1298 VPWR VGND VPWR VGND sky130_ef_sc_hd__decap_12
XFILLER_6_503 VGND VGND VPWR VPWR sky130_fd_sc_hd__decap_8
XFILLER_13_1522 VPWR VGND VPWR VGND sky130_ef_sc_hd__decap_12
XFILLER_52_1582 VPWR VGND VPWR VGND sky130_ef_sc_hd__decap_12
XFILLER_202_1273 VPWR VGND VPWR VGND sky130_ef_sc_hd__decap_12
XFILLER_182_345 VPWR VGND VPWR VGND sky130_ef_sc_hd__decap_12
XTAP_TAPCELL_ROW_92_2_3577 VGND VPWR sky130_fd_sc_hd__tapvpwrvgnd_1
XFILLER_13_1566 VPWR VGND VPWR VGND sky130_ef_sc_hd__decap_12
XFILLER_182_389 VPWR VGND VPWR VGND sky130_ef_sc_hd__decap_12
XTAP_TAPCELL_ROW_104_2_3653 VGND VPWR sky130_fd_sc_hd__tapvpwrvgnd_1
XFILLER_194_1085 VGND VGND VPWR VPWR sky130_fd_sc_hd__decap_6
XTAP_TAPCELL_ROW_186_2052 VGND VPWR sky130_fd_sc_hd__tapvpwrvgnd_1
XTAP_TAPCELL_ROW_186_2041 VGND VPWR sky130_fd_sc_hd__tapvpwrvgnd_1
XTAP_TAPCELL_ROW_186_2030 VGND VPWR sky130_fd_sc_hd__tapvpwrvgnd_1
XFILLER_1_230 VGND VGND VPWR VPWR sky130_fd_sc_hd__fill_1
XFILLER_81_1244 VPWR VGND VPWR VGND sky130_ef_sc_hd__decap_12
XTAP_TAPCELL_ROW_207_2634 VGND VPWR sky130_fd_sc_hd__tapvpwrvgnd_1
XTAP_TAPCELL_ROW_207_2645 VGND VPWR sky130_fd_sc_hd__tapvpwrvgnd_1
XFILLER_133_1378 VGND VGND VPWR VPWR sky130_fd_sc_hd__decap_6
XTAP_TAPCELL_ROW_199_2424 VGND VPWR sky130_fd_sc_hd__tapvpwrvgnd_1
XTAP_TAPCELL_ROW_199_2413 VGND VPWR sky130_fd_sc_hd__tapvpwrvgnd_1
XTAP_TAPCELL_ROW_199_2402 VGND VPWR sky130_fd_sc_hd__tapvpwrvgnd_1
XFILLER_66_83 VGND VGND VPWR VPWR sky130_fd_sc_hd__fill_1
XFILLER_20_1526 VPWR VGND VPWR VGND sky130_ef_sc_hd__decap_12
XFILLER_206_755 VGND VGND VPWR VPWR sky130_fd_sc_hd__fill_1
XFILLER_209_1449 VGND VGND VPWR VPWR sky130_fd_sc_hd__decap_6
X_528_ net179 net125 VGND VGND VPWR VPWR _238_ sky130_fd_sc_hd__or2_1
XFILLER_202_961 VPWR VGND VPWR VGND sky130_ef_sc_hd__decap_12
X_459_ net148 net112 VGND VGND VPWR VPWR _191_ sky130_fd_sc_hd__xor2_2
XFILLER_192_109 VPWR VGND VPWR VGND sky130_ef_sc_hd__decap_12
XFILLER_174_813 VPWR VGND VPWR VGND sky130_ef_sc_hd__decap_12
XFILLER_185_161 VGND VGND VPWR VPWR sky130_fd_sc_hd__decap_6
XFILLER_179_1537 VPWR VGND VPWR VGND sky130_ef_sc_hd__decap_12
XFILLER_140_1338 VPWR VGND VPWR VGND sky130_ef_sc_hd__decap_12
XTAP_TAPCELL_ROW_171_1620 VGND VPWR sky130_fd_sc_hd__tapvpwrvgnd_1
XFILLER_63_3 VPWR VGND VPWR VGND sky130_ef_sc_hd__decap_12
Xoutput104 net104 VGND VGND VPWR VPWR func_rdata[23] sky130_fd_sc_hd__buf_2
Xoutput115 net115 VGND VGND VPWR VPWR func_rdata[4] sky130_fd_sc_hd__buf_2
XFILLER_216_1409 VPWR VGND VPWR VGND sky130_ef_sc_hd__decap_12
XFILLER_173_1169 VGND VGND VPWR VPWR sky130_fd_sc_hd__decap_6
XTAP_TAPCELL_ROW_169_1560 VGND VPWR sky130_fd_sc_hd__tapvpwrvgnd_1
XFILLER_190_1483 VGND VGND VPWR VPWR sky130_fd_sc_hd__fill_1
XFILLER_151_1434 VGND VGND VPWR VPWR sky130_fd_sc_hd__decap_6
XTAP_TAPCELL_ROW_148_2_3940 VGND VPWR sky130_fd_sc_hd__tapvpwrvgnd_1
XTAP_TAPCELL_ROW_165_1446 VGND VPWR sky130_fd_sc_hd__tapvpwrvgnd_1
XTAP_TAPCELL_ROW_165_1435 VGND VPWR sky130_fd_sc_hd__tapvpwrvgnd_1
XFILLER_151_1478 VPWR VGND VPWR VGND sky130_ef_sc_hd__decap_12
XFILLER_3_1233 VPWR VGND VPWR VGND sky130_ef_sc_hd__decap_12
XFILLER_149_1330 VPWR VGND VPWR VGND sky130_ef_sc_hd__decap_12
XFILLER_102_15 VPWR VGND VPWR VGND sky130_ef_sc_hd__decap_12
XTAP_TAPCELL_ROW_22_1_1061 VGND VPWR sky130_fd_sc_hd__tapvpwrvgnd_1
XFILLER_58_1246 VPWR VGND VPWR VGND sky130_ef_sc_hd__decap_12
XFILLER_212_725 VPWR VGND VPWR VGND sky130_ef_sc_hd__decap_12
XFILLER_180_1129 VPWR VGND VPWR VGND sky130_ef_sc_hd__decap_12
XTAP_TAPCELL_ROW_178_1818 VGND VPWR sky130_fd_sc_hd__tapvpwrvgnd_1
XTAP_TAPCELL_ROW_178_1807 VGND VPWR sky130_fd_sc_hd__tapvpwrvgnd_1
XFILLER_169_629 VPWR VGND VPWR VGND sky130_ef_sc_hd__decap_12
XFILLER_212_769 VPWR VGND VPWR VGND sky130_ef_sc_hd__decap_12
XFILLER_168_139 VGND VGND VPWR VPWR sky130_fd_sc_hd__fill_1
XFILLER_211_279 VGND VGND VPWR VPWR sky130_fd_sc_hd__fill_1
XFILLER_177_673 VPWR VGND VPWR VGND sky130_ef_sc_hd__decap_12
XFILLER_162_1574 VGND VGND VPWR VPWR sky130_fd_sc_hd__decap_6
XTAP_TAPCELL_ROW_110_2_3696 VGND VPWR sky130_fd_sc_hd__tapvpwrvgnd_1
XFILLER_164_301 VGND VGND VPWR VPWR sky130_fd_sc_hd__decap_6
XTAP_TAPCELL_ROW_110_1_1237 VGND VPWR sky130_fd_sc_hd__tapvpwrvgnd_1
XTAP_TAPCELL_ROW_77_2_3479 VGND VPWR sky130_fd_sc_hd__tapvpwrvgnd_1
XFILLER_203_1593 VPWR VGND VPWR VGND sky130_ef_sc_hd__decap_12
XFILLER_194_29 VPWR VGND VPWR VGND sky130_ef_sc_hd__decap_12
XFILLER_192_643 VGND VGND VPWR VPWR sky130_fd_sc_hd__fill_1
XFILLER_180_805 VGND VGND VPWR VPWR sky130_fd_sc_hd__decap_6
XFILLER_164_345 VPWR VGND VPWR VGND sky130_ef_sc_hd__decap_12
XFILLER_180_849 VPWR VGND VPWR VGND sky130_ef_sc_hd__decap_12
XFILLER_164_389 VPWR VGND VPWR VGND sky130_ef_sc_hd__decap_12
XFILLER_69_1342 VPWR VGND VPWR VGND sky130_ef_sc_hd__decap_12
XFILLER_3_517 VGND VGND VPWR VPWR sky130_fd_sc_hd__decap_6
XFILLER_11_45 VGND VGND VPWR VPWR sky130_fd_sc_hd__fill_1
XFILLER_219_1033 VGND VGND VPWR VPWR sky130_fd_sc_hd__decap_3
XFILLER_191_1225 VGND VGND VPWR VPWR sky130_fd_sc_hd__decap_6
XFILLER_69_1386 VPWR VGND VPWR VGND sky130_ef_sc_hd__decap_12
XPHY_EDGE_ROW_18_2_Right_75 VGND VGND VPWR VPWR sky130_fd_sc_hd__decap_3
XFILLER_219_1077 VPWR VGND VPWR VGND sky130_ef_sc_hd__decap_12
XFILLER_156_1356 VGND VGND VPWR VPWR sky130_fd_sc_hd__fill_1
XFILLER_87_27 VPWR VGND VPWR VGND sky130_ef_sc_hd__decap_12
XFILLER_191_1269 VPWR VGND VPWR VGND sky130_ef_sc_hd__decap_12
XTAP_TAPCELL_ROW_37_2_3220 VGND VPWR sky130_fd_sc_hd__tapvpwrvgnd_1
XFILLER_189_1121 VPWR VGND VPWR VGND sky130_ef_sc_hd__decap_12
XFILLER_143_55 VGND VGND VPWR VPWR sky130_fd_sc_hd__fill_1
XFILLER_130_1518 VGND VGND VPWR VPWR sky130_fd_sc_hd__decap_6
XFILLER_210_1553 VPWR VGND VPWR VGND sky130_ef_sc_hd__decap_12
XFILLER_185_1007 VGND VGND VPWR VPWR sky130_fd_sc_hd__fill_1
XANTENNA__586__CLK clknet_3_1_0_clk VGND VGND VPWR VPWR sky130_fd_sc_hd__diode_2
XFILLER_41_1272 VGND VGND VPWR VPWR sky130_fd_sc_hd__fill_1
XFILLER_215_541 VPWR VGND VPWR VGND sky130_ef_sc_hd__decap_12
XFILLER_210_1597 VGND VGND VPWR VPWR sky130_fd_sc_hd__decap_8
XFILLER_76_1302 VPWR VGND VPWR VGND sky130_ef_sc_hd__decap_12
XFILLER_36_53 VPWR VGND VPWR VGND sky130_ef_sc_hd__decap_12
XFILLER_188_905 VPWR VGND VPWR VGND sky130_ef_sc_hd__decap_12
XFILLER_128_1414 VPWR VGND VPWR VGND sky130_ef_sc_hd__decap_12
XPHY_EDGE_ROW_66_1_Right_652 VGND VGND VPWR VPWR sky130_fd_sc_hd__decap_3
XFILLER_36_97 VPWR VGND VPWR VGND sky130_ef_sc_hd__decap_12
XFILLER_215_585 VPWR VGND VPWR VGND sky130_ef_sc_hd__decap_12
XFILLER_188_949 VPWR VGND VPWR VGND sky130_ef_sc_hd__decap_12
X_313_ net24 net143 net133 VGND VGND VPWR VPWR s_wdata\[20\] sky130_fd_sc_hd__a21o_1
XFILLER_52_41 VPWR VGND VPWR VGND sky130_ef_sc_hd__decap_12
XFILLER_174_109 VPWR VGND VPWR VGND sky130_ef_sc_hd__decap_12
XFILLER_168_41 VPWR VGND VPWR VGND sky130_ef_sc_hd__decap_12
XPHY_EDGE_ROW_135_2_Left_567 VGND VGND VPWR VPWR sky130_fd_sc_hd__decap_3
XFILLER_196_993 VPWR VGND VPWR VGND sky130_ef_sc_hd__decap_12
XFILLER_168_85 VPWR VGND VPWR VGND sky130_ef_sc_hd__decap_12
XFILLER_167_161 VGND VGND VPWR VPWR sky130_fd_sc_hd__decap_6
Xinput17 func_wdata[14] VGND VGND VPWR VPWR net17 sky130_fd_sc_hd__clkbuf_1
Xinput28 func_wdata[24] VGND VGND VPWR VPWR net28 sky130_fd_sc_hd__clkbuf_1
XTAP_TAPCELL_ROW_47_1_1112 VGND VPWR sky130_fd_sc_hd__tapvpwrvgnd_1
XFILLER_183_665 VGND VGND VPWR VPWR sky130_fd_sc_hd__decap_6
XFILLER_100_1300 VGND VGND VPWR VPWR sky130_fd_sc_hd__fill_1
Xinput39 func_wdata[5] VGND VGND VPWR VPWR net39 sky130_fd_sc_hd__clkbuf_1
XFILLER_6_333 VPWR VGND VPWR VGND sky130_ef_sc_hd__decap_12
XFILLER_13_1330 VPWR VGND VPWR VGND sky130_ef_sc_hd__decap_12
XFILLER_196_1147 VGND VGND VPWR VPWR sky130_fd_sc_hd__fill_1
XTAP_TAPCELL_ROW_188_2103 VGND VPWR sky130_fd_sc_hd__tapvpwrvgnd_1
XFILLER_182_153 VPWR VGND VPWR VGND sky130_ef_sc_hd__decap_12
XFILLER_139_1510 VPWR VGND VPWR VGND sky130_ef_sc_hd__decap_12
XFILLER_87_1442 VPWR VGND VPWR VGND sky130_ef_sc_hd__decap_12
XPHY_EDGE_ROW_72_2_Left_504 VGND VGND VPWR VPWR sky130_fd_sc_hd__decap_3
XFILLER_6_377 VPWR VGND VPWR VGND sky130_ef_sc_hd__decap_12
XFILLER_182_197 VPWR VGND VPWR VGND sky130_ef_sc_hd__decap_12
XFILLER_139_1554 VPWR VGND VPWR VGND sky130_ef_sc_hd__decap_12
XFILLER_48_1426 VPWR VGND VPWR VGND sky130_ef_sc_hd__decap_12
XFILLER_83_1328 VGND VGND VPWR VPWR sky130_fd_sc_hd__fill_1
XTAP_TAPCELL_ROW_209_2707 VGND VPWR sky130_fd_sc_hd__tapvpwrvgnd_1
XFILLER_170_1309 VGND VGND VPWR VPWR sky130_fd_sc_hd__decap_6
XANTENNA__420__A net156 VGND VGND VPWR VPWR sky130_fd_sc_hd__diode_2
XFILLER_77_93 VPWR VGND VPWR VGND sky130_ef_sc_hd__decap_12
XFILLER_168_1205 VPWR VGND VPWR VGND sky130_ef_sc_hd__decap_12
XFILLER_111_1440 VGND VGND VPWR VPWR sky130_fd_sc_hd__fill_1
XFILLER_4_1553 VPWR VGND VPWR VGND sky130_ef_sc_hd__decap_12
XFILLER_24_1470 VPWR VGND VPWR VGND sky130_ef_sc_hd__decap_12
XFILLER_203_69 VPWR VGND VPWR VGND sky130_ef_sc_hd__decap_12
XFILLER_98_1582 VPWR VGND VPWR VGND sky130_ef_sc_hd__decap_12
XFILLER_4_1597 VGND VGND VPWR VPWR sky130_fd_sc_hd__decap_8
XFILLER_20_1356 VGND VGND VPWR VPWR sky130_fd_sc_hd__fill_1
XFILLER_59_1522 VPWR VGND VPWR VGND sky130_ef_sc_hd__decap_12
XFILLER_209_1213 VPWR VGND VPWR VGND sky130_ef_sc_hd__decap_12
XFILLER_93_81 VPWR VGND VPWR VGND sky130_ef_sc_hd__decap_12
XFILLER_59_1566 VPWR VGND VPWR VGND sky130_ef_sc_hd__decap_12
XFILLER_209_1257 VPWR VGND VPWR VGND sky130_ef_sc_hd__decap_12
XFILLER_94_1468 VGND VGND VPWR VPWR sky130_fd_sc_hd__fill_1
XFILLER_181_1449 VGND VGND VPWR VPWR sky130_fd_sc_hd__decap_6
XPHY_EDGE_ROW_67_2_Left_499 VGND VGND VPWR VPWR sky130_fd_sc_hd__decap_3
XFILLER_20_104 VGND VGND VPWR VPWR sky130_fd_sc_hd__fill_1
XTAP_TAPCELL_ROW_63_2_3387 VGND VPWR sky130_fd_sc_hd__tapvpwrvgnd_1
XFILLER_20_126 VGND VGND VPWR VPWR sky130_fd_sc_hd__fill_1
XFILLER_193_429 VPWR VGND VPWR VGND sky130_ef_sc_hd__decap_12
XFILLER_179_1301 VPWR VGND VPWR VGND sky130_ef_sc_hd__decap_12
XFILLER_144_1282 VPWR VGND VPWR VGND sky130_ef_sc_hd__decap_12
XFILLER_105_1244 VPWR VGND VPWR VGND sky130_ef_sc_hd__decap_12
XFILLER_179_1345 VPWR VGND VPWR VGND sky130_ef_sc_hd__decap_12
XFILLER_174_643 VGND VGND VPWR VPWR sky130_fd_sc_hd__fill_1
XFILLER_122_1580 VGND VGND VPWR VPWR sky130_fd_sc_hd__fill_1
XFILLER_66_1526 VPWR VGND VPWR VGND sky130_ef_sc_hd__decap_12
XFILLER_31_1496 VGND VGND VPWR VPWR sky130_fd_sc_hd__fill_1
XFILLER_216_1217 VPWR VGND VPWR VGND sky130_ef_sc_hd__decap_12
XFILLER_192_1589 VGND VGND VPWR VPWR sky130_fd_sc_hd__decap_6
XFILLER_170_893 VPWR VGND VPWR VGND sky130_ef_sc_hd__decap_12
XTAP_TAPCELL_ROW_167_1508 VGND VPWR sky130_fd_sc_hd__tapvpwrvgnd_1
XFILLER_151_1220 VPWR VGND VPWR VGND sky130_ef_sc_hd__decap_12
XFILLER_9_1442 VPWR VGND VPWR VGND sky130_ef_sc_hd__decap_12
XFILLER_64_1294 VGND VGND VPWR VPWR sky130_fd_sc_hd__decap_6
XFILLER_25_1256 VPWR VGND VPWR VGND sky130_ef_sc_hd__decap_12
XFILLER_217_839 VGND VGND VPWR VPWR sky130_fd_sc_hd__fill_1
XFILLER_151_1286 VPWR VGND VPWR VGND sky130_ef_sc_hd__decap_12
XFILLER_113_69 VPWR VGND VPWR VGND sky130_ef_sc_hd__decap_12
XFILLER_3_1063 VGND VGND VPWR VPWR sky130_fd_sc_hd__fill_1
XTAP_TAPCELL_ROW_219_3014 VGND VPWR sky130_fd_sc_hd__tapvpwrvgnd_1
XTAP_TAPCELL_ROW_219_3003 VGND VPWR sky130_fd_sc_hd__tapvpwrvgnd_1
XFILLER_184_1073 VPWR VGND VPWR VGND sky130_ef_sc_hd__decap_12
XFILLER_212_533 VPWR VGND VPWR VGND sky130_ef_sc_hd__decap_12
XFILLER_196_245 VGND VGND VPWR VPWR sky130_fd_sc_hd__decap_6
XFILLER_156_109 VPWR VGND VPWR VGND sky130_ef_sc_hd__decap_12
XPHY_EDGE_ROW_120_1_Left_339 VGND VGND VPWR VPWR sky130_fd_sc_hd__decap_3
XFILLER_71_1232 VPWR VGND VPWR VGND sky130_ef_sc_hd__decap_12
XFILLER_197_1401 VPWR VGND VPWR VGND sky130_ef_sc_hd__decap_12
XFILLER_196_289 VPWR VGND VPWR VGND sky130_ef_sc_hd__decap_12
XFILLER_178_993 VPWR VGND VPWR VGND sky130_ef_sc_hd__decap_12
XFILLER_162_1382 VPWR VGND VPWR VGND sky130_ef_sc_hd__decap_12
XFILLER_123_1322 VGND VGND VPWR VPWR sky130_fd_sc_hd__decap_6
XFILLER_165_665 VGND VGND VPWR VPWR sky130_fd_sc_hd__decap_6
XTAP_TAPCELL_ROW_140_2_3891 VGND VPWR sky130_fd_sc_hd__tapvpwrvgnd_1
XFILLER_123_1366 VPWR VGND VPWR VGND sky130_ef_sc_hd__decap_12
XFILLER_71_1298 VPWR VGND VPWR VGND sky130_ef_sc_hd__decap_12
XFILLER_180_613 VPWR VGND VPWR VGND sky130_ef_sc_hd__decap_12
XFILLER_164_153 VPWR VGND VPWR VGND sky130_ef_sc_hd__decap_12
XFILLER_138_77 VGND VGND VPWR VPWR sky130_fd_sc_hd__decap_6
XFILLER_98_15 VPWR VGND VPWR VGND sky130_ef_sc_hd__decap_12
XFILLER_180_657 VPWR VGND VPWR VGND sky130_ef_sc_hd__decap_12
XFILLER_164_197 VPWR VGND VPWR VGND sky130_ef_sc_hd__decap_12
XFILLER_4_837 VPWR VGND VPWR VGND sky130_ef_sc_hd__decap_12
XFILLER_191_1033 VPWR VGND VPWR VGND sky130_ef_sc_hd__decap_12
XTAP_TAPCELL_ROW_119_2_3750 VGND VPWR sky130_fd_sc_hd__tapvpwrvgnd_1
XFILLER_191_1077 VPWR VGND VPWR VGND sky130_ef_sc_hd__decap_12
XFILLER_154_65 VPWR VGND VPWR VGND sky130_ef_sc_hd__decap_12
XTAP_TAPCELL_ROW_132_2_3839 VGND VPWR sky130_fd_sc_hd__tapvpwrvgnd_1
XFILLER_82_1350 VGND VGND VPWR VPWR sky130_fd_sc_hd__decap_6
XFILLER_134_1462 VGND VGND VPWR VPWR sky130_fd_sc_hd__decap_6
XFILLER_82_1394 VPWR VGND VPWR VGND sky130_ef_sc_hd__decap_12
Xfanout150 net151 VGND VGND VPWR VPWR net150 sky130_fd_sc_hd__buf_2
XFILLER_219_165 VGND VGND VPWR VPWR sky130_fd_sc_hd__decap_3
XFILLER_207_305 VPWR VGND VPWR VGND sky130_ef_sc_hd__decap_12
XFILLER_169_1525 VPWR VGND VPWR VGND sky130_ef_sc_hd__decap_12
XFILLER_130_1326 VPWR VGND VPWR VGND sky130_ef_sc_hd__decap_12
XFILLER_43_1378 VGND VGND VPWR VPWR sky130_fd_sc_hd__decap_6
XFILLER_207_349 VPWR VGND VPWR VGND sky130_ef_sc_hd__decap_12
XFILLER_170_53 VPWR VGND VPWR VGND sky130_ef_sc_hd__decap_12
XTAP_TAPCELL_ROW_112_2_3704 VGND VPWR sky130_fd_sc_hd__tapvpwrvgnd_1
XTAP_TAPCELL_ROW_3_881 VGND VPWR sky130_fd_sc_hd__tapvpwrvgnd_1
XTAP_TAPCELL_ROW_3_870 VGND VPWR sky130_fd_sc_hd__tapvpwrvgnd_1
XFILLER_216_861 VGND VGND VPWR VPWR sky130_fd_sc_hd__decap_6
XFILLER_170_97 VPWR VGND VPWR VGND sky130_ef_sc_hd__decap_12
XFILLER_169_1569 VPWR VGND VPWR VGND sky130_ef_sc_hd__decap_12
XFILLER_188_713 VPWR VGND VPWR VGND sky130_ef_sc_hd__decap_12
XPHY_EDGE_ROW_67_1_Right_653 VGND VGND VPWR VPWR sky130_fd_sc_hd__decap_3
XFILLER_63_51 VGND VGND VPWR VPWR sky130_fd_sc_hd__decap_4
XFILLER_215_393 VPWR VGND VPWR VGND sky130_ef_sc_hd__decap_12
XFILLER_188_757 VPWR VGND VPWR VGND sky130_ef_sc_hd__decap_12
XFILLER_187_223 VGND VGND VPWR VPWR sky130_fd_sc_hd__fill_1
XFILLER_179_51 VGND VGND VPWR VPWR sky130_fd_sc_hd__decap_4
XFILLER_128_1244 VGND VGND VPWR VPWR sky130_fd_sc_hd__fill_1
XFILLER_93_1490 VGND VGND VPWR VPWR sky130_fd_sc_hd__decap_6
XTAP_TAPCELL_ROW_48_2_3289 VGND VPWR sky130_fd_sc_hd__tapvpwrvgnd_1
XFILLER_175_429 VPWR VGND VPWR VGND sky130_ef_sc_hd__decap_12
XFILLER_141_1422 VPWR VGND VPWR VGND sky130_ef_sc_hd__decap_12
XFILLER_200_1029 VGND VGND VPWR VPWR sky130_fd_sc_hd__decap_6
XFILLER_141_1466 VPWR VGND VPWR VGND sky130_ef_sc_hd__decap_12
XFILLER_102_1406 VGND VGND VPWR VPWR sky130_fd_sc_hd__decap_6
XFILLER_8_68 VPWR VGND VPWR VGND sky130_ef_sc_hd__decap_12
XANTENNA__415__A b_addr\[5\] VGND VGND VPWR VPWR sky130_fd_sc_hd__diode_2
XFILLER_50_1338 VPWR VGND VPWR VGND sky130_ef_sc_hd__decap_12
XFILLER_183_473 VPWR VGND VPWR VGND sky130_ef_sc_hd__decap_12
XFILLER_6_141 VGND VGND VPWR VPWR sky130_fd_sc_hd__decap_6
XFILLER_6_163 VPWR VGND VPWR VGND sky130_ef_sc_hd__decap_12
XFILLER_7_697 VGND VGND VPWR VPWR sky130_fd_sc_hd__decap_3
XFILLER_87_1272 VGND VGND VPWR VPWR sky130_fd_sc_hd__fill_1
XANTENNA__487__A1 net149 VGND VGND VPWR VPWR sky130_fd_sc_hd__diode_2
XFILLER_217_1537 VPWR VGND VPWR VGND sky130_ef_sc_hd__decap_12
XFILLER_174_1253 VGND VGND VPWR VPWR sky130_fd_sc_hd__decap_6
XFILLER_170_189 VGND VGND VPWR VPWR sky130_fd_sc_hd__decap_6
XFILLER_139_1384 VGND VGND VPWR VPWR sky130_fd_sc_hd__fill_1
XFILLER_3_892 VGND VGND VPWR VPWR sky130_fd_sc_hd__fill_2
XFILLER_174_1297 VPWR VGND VPWR VGND sky130_ef_sc_hd__decap_12
XFILLER_170_1117 VPWR VGND VPWR VGND sky130_ef_sc_hd__decap_12
XFILLER_152_1562 VPWR VGND VPWR VGND sky130_ef_sc_hd__decap_12
XFILLER_26_3 VGND VGND VPWR VPWR sky130_fd_sc_hd__decap_8
XFILLER_61_1434 VGND VGND VPWR VPWR sky130_fd_sc_hd__decap_6
XFILLER_113_1546 VGND VGND VPWR VPWR sky130_fd_sc_hd__decap_6
XTAP_TAPCELL_ROW_1_807 VGND VPWR sky130_fd_sc_hd__tapvpwrvgnd_1
XTAP_TAPCELL_ROW_1_818 VGND VPWR sky130_fd_sc_hd__tapvpwrvgnd_1
XFILLER_61_1478 VPWR VGND VPWR VGND sky130_ef_sc_hd__decap_12
XFILLER_211_1169 VGND VGND VPWR VPWR sky130_fd_sc_hd__decap_6
XTAP_TAPCELL_ROW_134_1_1285 VGND VPWR sky130_fd_sc_hd__tapvpwrvgnd_1
XTAP_TAPCELL_ROW_1_829 VGND VPWR sky130_fd_sc_hd__tapvpwrvgnd_1
XFILLER_168_1035 VGND VGND VPWR VPWR sky130_fd_sc_hd__fill_1
XPHY_EDGE_ROW_166_Right_11 VGND VGND VPWR VPWR sky130_fd_sc_hd__decap_3
XFILLER_59_1330 VPWR VGND VPWR VGND sky130_ef_sc_hd__decap_12
XFILLER_209_1021 VPWR VGND VPWR VGND sky130_ef_sc_hd__decap_12
XFILLER_146_1300 VGND VGND VPWR VPWR sky130_fd_sc_hd__fill_1
XFILLER_94_1232 VPWR VGND VPWR VGND sky130_ef_sc_hd__decap_12
XFILLER_209_1065 VPWR VGND VPWR VGND sky130_ef_sc_hd__decap_12
XFILLER_185_1393 VGND VGND VPWR VPWR sky130_fd_sc_hd__decap_6
XFILLER_181_1213 VPWR VGND VPWR VGND sky130_ef_sc_hd__decap_12
XFILLER_181_1257 VPWR VGND VPWR VGND sky130_ef_sc_hd__decap_12
XFILLER_178_245 VGND VGND VPWR VPWR sky130_fd_sc_hd__decap_6
XFILLER_107_1328 VGND VGND VPWR VPWR sky130_fd_sc_hd__fill_1
XFILLER_194_749 VGND VGND VPWR VPWR sky130_fd_sc_hd__decap_6
XFILLER_178_289 VPWR VGND VPWR VGND sky130_ef_sc_hd__decap_12
XFILLER_138_109 VPWR VGND VPWR VGND sky130_ef_sc_hd__decap_12
XTAP_TAPCELL_ROW_125_2_3793 VGND VPWR sky130_fd_sc_hd__tapvpwrvgnd_1
XFILLER_72_1574 VGND VGND VPWR VPWR sky130_fd_sc_hd__decap_6
XFILLER_193_237 VPWR VGND VPWR VGND sky130_ef_sc_hd__decap_12
XFILLER_120_1506 VPWR VGND VPWR VGND sky130_ef_sc_hd__decap_12
XFILLER_200_1541 VPWR VGND VPWR VGND sky130_ef_sc_hd__decap_12
XTAP_TAPCELL_ROW_93_2_3582 VGND VPWR sky130_fd_sc_hd__tapvpwrvgnd_1
XFILLER_179_1175 VGND VGND VPWR VPWR sky130_fd_sc_hd__fill_1
XPHY_EDGE_ROW_175_Right_20 VGND VGND VPWR VPWR sky130_fd_sc_hd__decap_3
XFILLER_157_1440 VGND VGND VPWR VPWR sky130_fd_sc_hd__fill_1
XFILLER_192_1353 VPWR VGND VPWR VGND sky130_ef_sc_hd__decap_12
XFILLER_68_29 VPWR VGND VPWR VGND sky130_ef_sc_hd__decap_12
XFILLER_66_1356 VGND VGND VPWR VPWR sky130_fd_sc_hd__fill_1
XFILLER_192_1397 VPWR VGND VPWR VGND sky130_ef_sc_hd__decap_12
XFILLER_118_1468 VGND VGND VPWR VPWR sky130_fd_sc_hd__fill_1
XFILLER_131_1602 VGND VGND VPWR VPWR sky130_fd_sc_hd__decap_3
XFILLER_9_1272 VGND VGND VPWR VPWR sky130_fd_sc_hd__fill_1
XFILLER_40_1518 VGND VGND VPWR VPWR sky130_fd_sc_hd__decap_6
XFILLER_5_1169 VGND VGND VPWR VPWR sky130_fd_sc_hd__decap_6
XFILLER_205_809 VPWR VGND VPWR VGND sky130_ef_sc_hd__decap_12
XFILLER_38_1414 VPWR VGND VPWR VGND sky130_ef_sc_hd__decap_12
XFILLER_213_853 VPWR VGND VPWR VGND sky130_ef_sc_hd__decap_12
XFILLER_169_223 VGND VGND VPWR VPWR sky130_fd_sc_hd__fill_1
XFILLER_77_1496 VGND VGND VPWR VPWR sky130_fd_sc_hd__fill_1
XTAP_TAPCELL_ROW_34_2_3197 VGND VPWR sky130_fd_sc_hd__tapvpwrvgnd_1
XFILLER_213_897 VPWR VGND VPWR VGND sky130_ef_sc_hd__decap_12
XFILLER_212_363 VGND VGND VPWR VPWR sky130_fd_sc_hd__fill_1
XFILLER_164_1477 VGND VGND VPWR VPWR sky130_fd_sc_hd__decap_6
XANTENNA__624__CLK clknet_3_1_0_clk VGND VGND VPWR VPWR sky130_fd_sc_hd__diode_2
XFILLER_200_525 VGND VGND VPWR VPWR sky130_fd_sc_hd__decap_6
XFILLER_185_727 VGND VGND VPWR VPWR sky130_fd_sc_hd__fill_1
XTAP_TAPCELL_ROW_159_1_1336 VGND VPWR sky130_fd_sc_hd__tapvpwrvgnd_1
XFILLER_130_3 VPWR VGND VPWR VGND sky130_ef_sc_hd__decap_12
XFILLER_200_569 VPWR VGND VPWR VGND sky130_ef_sc_hd__decap_12
XFILLER_197_1231 VGND VGND VPWR VPWR sky130_fd_sc_hd__fill_1
XFILLER_165_473 VPWR VGND VPWR VGND sky130_ef_sc_hd__decap_12
XFILLER_10_1300 VGND VGND VPWR VPWR sky130_fd_sc_hd__fill_1
XFILLER_181_933 VPWR VGND VPWR VGND sky130_ef_sc_hd__decap_12
XFILLER_180_421 VPWR VGND VPWR VGND sky130_ef_sc_hd__decap_12
XFILLER_3_111 VGND VGND VPWR VPWR sky130_fd_sc_hd__fill_1
XFILLER_49_1510 VPWR VGND VPWR VGND sky130_ef_sc_hd__decap_12
XFILLER_181_977 VPWR VGND VPWR VGND sky130_ef_sc_hd__decap_12
XFILLER_84_1412 VGND VGND VPWR VPWR sky130_fd_sc_hd__fill_1
XFILLER_4_645 VGND VGND VPWR VPWR sky130_fd_sc_hd__fill_2
XFILLER_49_1554 VPWR VGND VPWR VGND sky130_ef_sc_hd__decap_12
XFILLER_136_1524 VGND VGND VPWR VPWR sky130_fd_sc_hd__fill_1
XFILLER_171_1437 VPWR VGND VPWR VGND sky130_ef_sc_hd__decap_12
XFILLER_0_873 VGND VGND VPWR VPWR sky130_fd_sc_hd__fill_2
XFILLER_0_851 VGND VGND VPWR VPWR sky130_fd_sc_hd__decap_3
XFILLER_134_1270 VPWR VGND VPWR VGND sky130_ef_sc_hd__decap_12
Xhold6 net86 VGND VGND VPWR VPWR net176 sky130_fd_sc_hd__dlygate4sd3_1
XFILLER_208_625 VPWR VGND VPWR VGND sky130_ef_sc_hd__decap_12
XFILLER_207_113 VPWR VGND VPWR VGND sky130_ef_sc_hd__decap_12
XFILLER_208_669 VPWR VGND VPWR VGND sky130_ef_sc_hd__decap_12
XFILLER_21_1440 VGND VGND VPWR VPWR sky130_fd_sc_hd__fill_1
XFILLER_169_1399 VGND VGND VPWR VPWR sky130_fd_sc_hd__fill_1
XFILLER_95_1552 VGND VGND VPWR VPWR sky130_fd_sc_hd__fill_1
XFILLER_74_83 VGND VGND VPWR VPWR sky130_fd_sc_hd__fill_1
XFILLER_1_1567 VGND VGND VPWR VPWR sky130_fd_sc_hd__fill_1
XFILLER_206_1205 VPWR VGND VPWR VGND sky130_ef_sc_hd__decap_12
XFILLER_200_15 VPWR VGND VPWR VGND sky130_ef_sc_hd__decap_12
XFILLER_182_1533 VGND VGND VPWR VPWR sky130_fd_sc_hd__decap_6
XFILLER_182_1577 VPWR VGND VPWR VGND sky130_ef_sc_hd__decap_12
Xu_sram.u_mem_166 VGND VGND VPWR VPWR net166 u_sram.u_mem_166/LO sky130_fd_sc_hd__conb_1
XPHY_EDGE_ROW_68_1_Right_654 VGND VGND VPWR VPWR sky130_fd_sc_hd__decap_3
XFILLER_203_385 VGND VGND VPWR VPWR sky130_fd_sc_hd__decap_6
XFILLER_188_587 VGND VGND VPWR VPWR sky130_fd_sc_hd__fill_1
XFILLER_176_749 VGND VGND VPWR VPWR sky130_fd_sc_hd__decap_6
XFILLER_198_1017 VPWR VGND VPWR VGND sky130_ef_sc_hd__decap_12
XFILLER_175_237 VPWR VGND VPWR VGND sky130_ef_sc_hd__decap_12
XFILLER_106_1350 VGND VGND VPWR VPWR sky130_fd_sc_hd__decap_6
XTAP_TAPCELL_ROW_78_2_3484 VGND VPWR sky130_fd_sc_hd__tapvpwrvgnd_1
XFILLER_15_1244 VPWR VGND VPWR VGND sky130_ef_sc_hd__decap_12
XFILLER_54_1282 VPWR VGND VPWR VGND sky130_ef_sc_hd__decap_12
XFILLER_141_1274 VPWR VGND VPWR VGND sky130_ef_sc_hd__decap_12
XFILLER_106_1394 VPWR VGND VPWR VGND sky130_ef_sc_hd__decap_12
XTAP_TAPCELL_ROW_15_1_1047 VGND VPWR sky130_fd_sc_hd__tapvpwrvgnd_1
XFILLER_209_57 VPWR VGND VPWR VGND sky130_ef_sc_hd__decap_12
XFILLER_184_793 VPWR VGND VPWR VGND sky130_ef_sc_hd__decap_12
XFILLER_183_281 VPWR VGND VPWR VGND sky130_ef_sc_hd__decap_12
XFILLER_176_1315 VGND VGND VPWR VPWR sky130_fd_sc_hd__fill_1
XFILLER_102_1258 VPWR VGND VPWR VGND sky130_ef_sc_hd__decap_12
XFILLER_89_1378 VGND VGND VPWR VPWR sky130_fd_sc_hd__decap_6
XFILLER_7_461 VPWR VGND VPWR VGND sky130_ef_sc_hd__decap_12
XFILLER_32_1580 VGND VGND VPWR VPWR sky130_fd_sc_hd__fill_1
XFILLER_217_1301 VPWR VGND VPWR VGND sky130_ef_sc_hd__decap_12
XTAP_TAPCELL_ROW_103_2_3649 VGND VPWR sky130_fd_sc_hd__tapvpwrvgnd_1
XFILLER_154_1602 VGND VGND VPWR VPWR sky130_fd_sc_hd__decap_3
XFILLER_217_1345 VPWR VGND VPWR VGND sky130_ef_sc_hd__decap_12
XFILLER_174_1061 VPWR VGND VPWR VGND sky130_ef_sc_hd__decap_12
XTAP_TAPCELL_ROW_71_2_3438 VGND VPWR sky130_fd_sc_hd__tapvpwrvgnd_1
XANTENNA__588__Q b_addr\[4\] VGND VGND VPWR VPWR sky130_fd_sc_hd__diode_2
XFILLER_61_1220 VPWR VGND VPWR VGND sky130_ef_sc_hd__decap_12
XFILLER_152_1370 VPWR VGND VPWR VGND sky130_ef_sc_hd__decap_12
XFILLER_117_1490 VGND VGND VPWR VPWR sky130_fd_sc_hd__decap_6
XFILLER_113_1310 VPWR VGND VPWR VGND sky130_ef_sc_hd__decap_12
XFILLER_113_1354 VPWR VGND VPWR VGND sky130_ef_sc_hd__decap_12
XFILLER_2_1309 VGND VGND VPWR VPWR sky130_fd_sc_hd__decap_6
XFILLER_61_1286 VPWR VGND VPWR VGND sky130_ef_sc_hd__decap_12
XFILLER_187_1455 VGND VGND VPWR VPWR sky130_fd_sc_hd__fill_1
XFILLER_148_1406 VGND VGND VPWR VPWR sky130_fd_sc_hd__decap_6
XFILLER_113_1398 VPWR VGND VPWR VGND sky130_ef_sc_hd__decap_12
XFILLER_96_1338 VPWR VGND VPWR VGND sky130_ef_sc_hd__decap_12
XTAP_TAPCELL_ROW_70_1_1157 VGND VPWR sky130_fd_sc_hd__tapvpwrvgnd_1
XFILLER_213_105 VGND VGND VPWR VPWR sky130_fd_sc_hd__decap_6
XFILLER_198_307 VGND VGND VPWR VPWR sky130_fd_sc_hd__fill_1
XFILLER_80_121 VGND VGND VPWR VPWR sky130_fd_sc_hd__decap_6
XFILLER_0_1033 VGND VGND VPWR VPWR sky130_fd_sc_hd__decap_3
XTAP_TAPCELL_ROW_19_2_3099 VGND VPWR sky130_fd_sc_hd__tapvpwrvgnd_1
XFILLER_213_149 VPWR VGND VPWR VGND sky130_ef_sc_hd__decap_12
XFILLER_110_15 VPWR VGND VPWR VGND sky130_ef_sc_hd__decap_12
XFILLER_0_1077 VPWR VGND VPWR VGND sky130_ef_sc_hd__decap_12
XPHY_EDGE_ROW_27_2_Right_84 VGND VGND VPWR VPWR sky130_fd_sc_hd__decap_3
XFILLER_181_1021 VPWR VGND VPWR VGND sky130_ef_sc_hd__decap_12
XFILLER_194_513 VPWR VGND VPWR VGND sky130_ef_sc_hd__decap_12
XFILLER_181_1065 VPWR VGND VPWR VGND sky130_ef_sc_hd__decap_12
XFILLER_167_727 VGND VGND VPWR VPWR sky130_fd_sc_hd__fill_1
XPHY_EDGE_ROW_3_Right_3 VGND VGND VPWR VPWR sky130_fd_sc_hd__decap_3
XFILLER_210_867 VGND VGND VPWR VPWR sky130_fd_sc_hd__fill_1
XFILLER_194_557 VPWR VGND VPWR VGND sky130_ef_sc_hd__decap_12
XFILLER_124_1450 VPWR VGND VPWR VGND sky130_ef_sc_hd__decap_12
XFILLER_72_1382 VPWR VGND VPWR VGND sky130_ef_sc_hd__decap_12
XFILLER_33_1322 VGND VGND VPWR VPWR sky130_fd_sc_hd__decap_6
XFILLER_124_1494 VPWR VGND VPWR VGND sky130_ef_sc_hd__decap_12
XFILLER_120_1314 VPWR VGND VPWR VGND sky130_ef_sc_hd__decap_12
XFILLER_33_1366 VPWR VGND VPWR VGND sky130_ef_sc_hd__decap_12
XFILLER_198_1595 VGND VGND VPWR VPWR sky130_fd_sc_hd__fill_1
XFILLER_159_1546 VGND VGND VPWR VPWR sky130_fd_sc_hd__decap_6
XFILLER_120_1358 VPWR VGND VPWR VGND sky130_ef_sc_hd__decap_12
XFILLER_119_57 VPWR VGND VPWR VGND sky130_ef_sc_hd__decap_12
XFILLER_200_1371 VGND VGND VPWR VPWR sky130_fd_sc_hd__fill_1
XFILLER_163_977 VGND VGND VPWR VPWR sky130_fd_sc_hd__decap_3
XFILLER_79_39 VPWR VGND VPWR VGND sky130_ef_sc_hd__decap_12
XFILLER_1_615 VGND VGND VPWR VPWR sky130_fd_sc_hd__fill_1
XANTENNA__502__B net125 VGND VGND VPWR VPWR sky130_fd_sc_hd__diode_2
XFILLER_192_1161 VPWR VGND VPWR VGND sky130_ef_sc_hd__decap_12
XFILLER_118_1232 VPWR VGND VPWR VGND sky130_ef_sc_hd__decap_12
XFILLER_0_136 VGND VGND VPWR VPWR sky130_fd_sc_hd__fill_2
XFILLER_0_125 VGND VGND VPWR VPWR sky130_fd_sc_hd__fill_1
XFILLER_95_27 VPWR VGND VPWR VGND sky130_ef_sc_hd__decap_12
XTAP_TAPCELL_ROW_5_921 VGND VPWR sky130_fd_sc_hd__tapvpwrvgnd_1
XFILLER_0_169 VGND VGND VPWR VPWR sky130_fd_sc_hd__decap_6
XFILLER_0_158 VGND VGND VPWR VPWR sky130_fd_sc_hd__decap_8
XTAP_TAPCELL_ROW_5_932 VGND VPWR sky130_fd_sc_hd__tapvpwrvgnd_1
XFILLER_218_923 VGND VGND VPWR VPWR sky130_fd_sc_hd__fill_1
XTAP_TAPCELL_ROW_147_2_3936 VGND VPWR sky130_fd_sc_hd__tapvpwrvgnd_1
XFILLER_135_1590 VPWR VGND VPWR VGND sky130_ef_sc_hd__decap_12
XFILLER_131_1410 VPWR VGND VPWR VGND sky130_ef_sc_hd__decap_12
XTAP_TAPCELL_ROW_5_943 VGND VPWR sky130_fd_sc_hd__tapvpwrvgnd_1
XFILLER_44_1462 VGND VGND VPWR VPWR sky130_fd_sc_hd__decap_6
XPHY_EDGE_ROW_144_2_Left_576 VGND VGND VPWR VPWR sky130_fd_sc_hd__decap_3
XFILLER_131_1454 VPWR VGND VPWR VGND sky130_ef_sc_hd__decap_12
X_630_ clknet_3_3_0_clk _064_ VGND VGND VPWR VPWR net55 sky130_fd_sc_hd__dfxtp_1
XFILLER_40_1326 VPWR VGND VPWR VGND sky130_ef_sc_hd__decap_12
XFILLER_178_3 VPWR VGND VPWR VGND sky130_ef_sc_hd__decap_12
XFILLER_151_55 VGND VGND VPWR VPWR sky130_fd_sc_hd__fill_1
XFILLER_131_1498 VPWR VGND VPWR VGND sky130_ef_sc_hd__decap_12
XTAP_TAPCELL_ROW_127_2_3801 VGND VPWR sky130_fd_sc_hd__tapvpwrvgnd_1
X_561_ net136 _254_ VGND VGND VPWR VPWR _064_ sky130_fd_sc_hd__and2_1
XFILLER_205_617 VPWR VGND VPWR VGND sky130_ef_sc_hd__decap_12
XFILLER_166_1539 VGND VGND VPWR VPWR sky130_fd_sc_hd__fill_1
XFILLER_189_329 VGND VGND VPWR VPWR sky130_fd_sc_hd__decap_6
XPHY_EDGE_ROW_81_2_Left_513 VGND VGND VPWR VPWR sky130_fd_sc_hd__decap_3
X_492_ net83 net126 VGND VGND VPWR VPWR _220_ sky130_fd_sc_hd__or2_1
XFILLER_44_53 VPWR VGND VPWR VGND sky130_ef_sc_hd__decap_12
XFILLER_207_1525 VPWR VGND VPWR VGND sky130_ef_sc_hd__decap_12
XFILLER_164_1241 VPWR VGND VPWR VGND sky130_ef_sc_hd__decap_12
XFILLER_207_1569 VPWR VGND VPWR VGND sky130_ef_sc_hd__decap_12
XFILLER_197_373 VPWR VGND VPWR VGND sky130_ef_sc_hd__decap_12
XFILLER_164_1285 VPWR VGND VPWR VGND sky130_ef_sc_hd__decap_12
XTAP_TAPCELL_ROW_64_2_3392 VGND VPWR sky130_fd_sc_hd__tapvpwrvgnd_1
XFILLER_44_97 VPWR VGND VPWR VGND sky130_ef_sc_hd__decap_12
XFILLER_201_889 VGND VGND VPWR VPWR sky130_fd_sc_hd__decap_6
XFILLER_200_333 VPWR VGND VPWR VGND sky130_ef_sc_hd__decap_12
XFILLER_199_1337 VGND VGND VPWR VPWR sky130_fd_sc_hd__decap_6
XTAP_TAPCELL_ROW_195_2290 VGND VPWR sky130_fd_sc_hd__tapvpwrvgnd_1
XFILLER_142_1550 VPWR VGND VPWR VGND sky130_ef_sc_hd__decap_12
XTAP_TAPCELL_ROW_95_1_1208 VGND VPWR sky130_fd_sc_hd__tapvpwrvgnd_1
XFILLER_90_1482 VPWR VGND VPWR VGND sky130_ef_sc_hd__decap_12
XFILLER_51_1422 VPWR VGND VPWR VGND sky130_ef_sc_hd__decap_12
XFILLER_201_1113 VGND VGND VPWR VPWR sky130_fd_sc_hd__decap_6
XFILLER_200_377 VPWR VGND VPWR VGND sky130_ef_sc_hd__decap_12
XTAP_TAPCELL_ROW_191_2187 VGND VPWR sky130_fd_sc_hd__tapvpwrvgnd_1
XTAP_TAPCELL_ROW_191_2176 VGND VPWR sky130_fd_sc_hd__tapvpwrvgnd_1
XFILLER_142_1594 VGND VGND VPWR VPWR sky130_fd_sc_hd__decap_8
XFILLER_103_1534 VPWR VGND VPWR VGND sky130_ef_sc_hd__decap_12
XFILLER_12_1406 VGND VGND VPWR VPWR sky130_fd_sc_hd__decap_6
XFILLER_51_1466 VPWR VGND VPWR VGND sky130_ef_sc_hd__decap_12
XFILLER_60_41 VPWR VGND VPWR VGND sky130_ef_sc_hd__decap_12
XTAP_TAPCELL_ROW_216_2894 VGND VPWR sky130_fd_sc_hd__tapvpwrvgnd_1
XTAP_TAPCELL_ROW_216_2883 VGND VPWR sky130_fd_sc_hd__tapvpwrvgnd_1
XFILLER_201_1157 VPWR VGND VPWR VGND sky130_ef_sc_hd__decap_12
XFILLER_176_41 VPWR VGND VPWR VGND sky130_ef_sc_hd__decap_12
XFILLER_166_793 VPWR VGND VPWR VGND sky130_ef_sc_hd__decap_12
XFILLER_165_281 VPWR VGND VPWR VGND sky130_ef_sc_hd__decap_12
XFILLER_103_1578 VPWR VGND VPWR VGND sky130_ef_sc_hd__decap_12
XFILLER_86_1518 VGND VGND VPWR VPWR sky130_fd_sc_hd__decap_6
XFILLER_5_921 VGND VGND VPWR VPWR sky130_fd_sc_hd__decap_6
XFILLER_60_85 VPWR VGND VPWR VGND sky130_ef_sc_hd__decap_12
XTAP_TAPCELL_ROW_212_2769 VGND VPWR sky130_fd_sc_hd__tapvpwrvgnd_1
XFILLER_181_741 VPWR VGND VPWR VGND sky130_ef_sc_hd__decap_12
XFILLER_176_85 VPWR VGND VPWR VGND sky130_ef_sc_hd__decap_12
XFILLER_5_965 VPWR VGND VPWR VGND sky130_ef_sc_hd__decap_12
XFILLER_181_785 VPWR VGND VPWR VGND sky130_ef_sc_hd__decap_12
XFILLER_180_251 VGND VGND VPWR VPWR sky130_fd_sc_hd__fill_1
XFILLER_84_1220 VPWR VGND VPWR VGND sky130_ef_sc_hd__decap_12
XFILLER_5_69 VGND VGND VPWR VPWR sky130_fd_sc_hd__decap_8
XFILLER_4_475 VGND VGND VPWR VPWR sky130_fd_sc_hd__fill_1
XFILLER_175_1381 VPWR VGND VPWR VGND sky130_ef_sc_hd__decap_12
XFILLER_171_1201 VPWR VGND VPWR VGND sky130_ef_sc_hd__decap_12
XFILLER_49_1384 VGND VGND VPWR VPWR sky130_fd_sc_hd__fill_1
XFILLER_171_1245 VPWR VGND VPWR VGND sky130_ef_sc_hd__decap_12
XFILLER_171_1289 VPWR VGND VPWR VGND sky130_ef_sc_hd__decap_12
XFILLER_62_1562 VPWR VGND VPWR VGND sky130_ef_sc_hd__decap_12
XFILLER_212_1253 VGND VGND VPWR VPWR sky130_fd_sc_hd__decap_6
XFILLER_209_945 VGND VGND VPWR VPWR sky130_fd_sc_hd__decap_6
XFILLER_23_1546 VGND VGND VPWR VPWR sky130_fd_sc_hd__decap_6
XFILLER_212_1297 VPWR VGND VPWR VGND sky130_ef_sc_hd__decap_12
XFILLER_209_989 VPWR VGND VPWR VGND sky130_ef_sc_hd__decap_12
XFILLER_208_433 VPWR VGND VPWR VGND sky130_ef_sc_hd__decap_12
XFILLER_110_1538 VPWR VGND VPWR VGND sky130_ef_sc_hd__decap_12
XFILLER_85_93 VPWR VGND VPWR VGND sky130_ef_sc_hd__decap_12
XFILLER_208_477 VPWR VGND VPWR VGND sky130_ef_sc_hd__decap_12
XFILLER_62_121 VGND VGND VPWR VPWR sky130_fd_sc_hd__decap_6
XFILLER_211_69 VPWR VGND VPWR VGND sky130_ef_sc_hd__decap_12
XTAP_TAPCELL_ROW_180_1880 VGND VPWR sky130_fd_sc_hd__tapvpwrvgnd_1
XFILLER_56_1300 VGND VGND VPWR VPWR sky130_fd_sc_hd__fill_1
XFILLER_211_609 VGND VGND VPWR VPWR sky130_fd_sc_hd__decap_6
XFILLER_189_841 VPWR VGND VPWR VGND sky130_ef_sc_hd__decap_12
XFILLER_182_1341 VPWR VGND VPWR VGND sky130_ef_sc_hd__decap_12
XFILLER_108_1412 VGND VGND VPWR VPWR sky130_fd_sc_hd__fill_1
XFILLER_206_1035 VGND VGND VPWR VPWR sky130_fd_sc_hd__fill_1
XFILLER_182_1385 VPWR VGND VPWR VGND sky130_ef_sc_hd__decap_12
XFILLER_176_513 VPWR VGND VPWR VGND sky130_ef_sc_hd__decap_12
XFILLER_93_3 VPWR VGND VPWR VGND sky130_ef_sc_hd__decap_12
XFILLER_91_1268 VGND VGND VPWR VPWR sky130_fd_sc_hd__decap_4
XPHY_EDGE_ROW_69_1_Right_655 VGND VGND VPWR VPWR sky130_fd_sc_hd__decap_3
XFILLER_17_1328 VGND VGND VPWR VPWR sky130_fd_sc_hd__fill_1
XFILLER_203_193 VPWR VGND VPWR VGND sky130_ef_sc_hd__decap_12
XFILLER_176_557 VPWR VGND VPWR VGND sky130_ef_sc_hd__decap_12
XFILLER_191_505 VPWR VGND VPWR VGND sky130_ef_sc_hd__decap_12
XFILLER_30_1506 VPWR VGND VPWR VGND sky130_ef_sc_hd__decap_12
XTAP_TAPCELL_ROW_174_1695 VGND VPWR sky130_fd_sc_hd__tapvpwrvgnd_1
XFILLER_219_1429 VPWR VGND VPWR VGND sky130_ef_sc_hd__decap_12
XFILLER_171_273 VGND VGND VPWR VPWR sky130_fd_sc_hd__decap_6
XFILLER_67_1440 VGND VGND VPWR VPWR sky130_fd_sc_hd__fill_1
XFILLER_193_1481 VPWR VGND VPWR VGND sky130_ef_sc_hd__decap_12
XFILLER_119_1552 VGND VGND VPWR VPWR sky130_fd_sc_hd__fill_1
XFILLER_217_1175 VGND VGND VPWR VPWR sky130_fd_sc_hd__fill_1
XTAP_TAPCELL_ROW_133_2_3844 VGND VPWR sky130_fd_sc_hd__tapvpwrvgnd_1
XFILLER_105_15 VPWR VGND VPWR VGND sky130_ef_sc_hd__decap_12
XFILLER_8_1518 VGND VGND VPWR VPWR sky130_fd_sc_hd__decap_6
XFILLER_28_1468 VGND VGND VPWR VPWR sky130_fd_sc_hd__fill_1
XFILLER_41_1602 VGND VGND VPWR VPWR sky130_fd_sc_hd__decap_3
XFILLER_6_1253 VGND VGND VPWR VPWR sky130_fd_sc_hd__decap_6
XFILLER_2_1117 VPWR VGND VPWR VGND sky130_ef_sc_hd__decap_12
XFILLER_6_1297 VPWR VGND VPWR VGND sky130_ef_sc_hd__decap_12
XFILLER_148_1258 VPWR VGND VPWR VGND sky130_ef_sc_hd__decap_12
XFILLER_121_69 VPWR VGND VPWR VGND sky130_ef_sc_hd__decap_12
XFILLER_78_1580 VGND VGND VPWR VPWR sky130_fd_sc_hd__fill_1
XFILLER_214_469 VGND VGND VPWR VPWR sky130_fd_sc_hd__decap_6
XFILLER_165_1561 VGND VGND VPWR VPWR sky130_fd_sc_hd__decap_6
XFILLER_195_833 VGND VGND VPWR VPWR sky130_fd_sc_hd__decap_6
XFILLER_179_373 VPWR VGND VPWR VGND sky130_ef_sc_hd__decap_12
XFILLER_14_45 VGND VGND VPWR VPWR sky130_fd_sc_hd__fill_1
XTAP_TAPCELL_ROW_49_2_3294 VGND VPWR sky130_fd_sc_hd__tapvpwrvgnd_1
XFILLER_194_321 VPWR VGND VPWR VGND sky130_ef_sc_hd__decap_12
XFILLER_195_877 VPWR VGND VPWR VGND sky130_ef_sc_hd__decap_12
XFILLER_194_365 VPWR VGND VPWR VGND sky130_ef_sc_hd__decap_12
XFILLER_202_1477 VGND VGND VPWR VPWR sky130_fd_sc_hd__decap_6
XFILLER_159_1310 VPWR VGND VPWR VGND sky130_ef_sc_hd__decap_12
XFILLER_163_741 VPWR VGND VPWR VGND sky130_ef_sc_hd__decap_12
XFILLER_159_1354 VPWR VGND VPWR VGND sky130_ef_sc_hd__decap_12
XTAP_TAPCELL_ROW_42_2_3248 VGND VPWR sky130_fd_sc_hd__tapvpwrvgnd_1
XFILLER_163_785 VPWR VGND VPWR VGND sky130_ef_sc_hd__decap_12
XFILLER_172_1521 VPWR VGND VPWR VGND sky130_ef_sc_hd__decap_12
XFILLER_159_1398 VPWR VGND VPWR VGND sky130_ef_sc_hd__decap_12
XFILLER_146_77 VGND VGND VPWR VPWR sky130_fd_sc_hd__decap_6
XFILLER_2_957 VPWR VGND VPWR VGND sky130_ef_sc_hd__decap_12
XFILLER_1_412 VGND VGND VPWR VPWR sky130_fd_sc_hd__decap_8
XFILLER_46_1524 VGND VGND VPWR VPWR sky130_fd_sc_hd__fill_1
XFILLER_172_1565 VPWR VGND VPWR VGND sky130_ef_sc_hd__decap_12
XTAP_TAPCELL_ROW_22_2_3124 VGND VPWR sky130_fd_sc_hd__tapvpwrvgnd_1
XFILLER_188_1005 VPWR VGND VPWR VGND sky130_ef_sc_hd__decap_12
XFILLER_162_65 VPWR VGND VPWR VGND sky130_ef_sc_hd__decap_12
XFILLER_44_1270 VPWR VGND VPWR VGND sky130_ef_sc_hd__decap_12
XFILLER_188_1049 VPWR VGND VPWR VGND sky130_ef_sc_hd__decap_12
XFILLER_79_1322 VGND VGND VPWR VPWR sky130_fd_sc_hd__decap_6
X_613_ clknet_3_5_0_clk _047_ VGND VGND VPWR VPWR net70 sky130_fd_sc_hd__dfxtp_1
XFILLER_206_937 VPWR VGND VPWR VGND sky130_ef_sc_hd__decap_12
XTAP_TAPCELL_ROW_205_2573 VGND VPWR sky130_fd_sc_hd__tapvpwrvgnd_1
XFILLER_79_1366 VPWR VGND VPWR VGND sky130_ef_sc_hd__decap_12
XANTENNA_input13_A func_wdata[10] VGND VGND VPWR VPWR sky130_fd_sc_hd__diode_2
XTAP_TAPCELL_ROW_39_1_1095 VGND VPWR sky130_fd_sc_hd__tapvpwrvgnd_1
XFILLER_44_121 VGND VGND VPWR VPWR sky130_fd_sc_hd__decap_6
XTAP_TAPCELL_ROW_205_2595 VGND VPWR sky130_fd_sc_hd__tapvpwrvgnd_1
XTAP_TAPCELL_ROW_205_2584 VGND VPWR sky130_fd_sc_hd__tapvpwrvgnd_1
XFILLER_205_447 VGND VGND VPWR VPWR sky130_fd_sc_hd__fill_1
X_544_ net80 _191_ net123 VGND VGND VPWR VPWR _246_ sky130_fd_sc_hd__mux2_1
XTAP_TAPCELL_ROW_201_2459 VGND VPWR sky130_fd_sc_hd__tapvpwrvgnd_1
XTAP_TAPCELL_ROW_197_2363 VGND VPWR sky130_fd_sc_hd__tapvpwrvgnd_1
XTAP_TAPCELL_ROW_197_2352 VGND VPWR sky130_fd_sc_hd__tapvpwrvgnd_1
XTAP_TAPCELL_ROW_197_2341 VGND VPWR sky130_fd_sc_hd__tapvpwrvgnd_1
XFILLER_189_137 VPWR VGND VPWR VGND sky130_ef_sc_hd__decap_12
X_475_ _182_ _184_ _205_ _206_ VGND VGND VPWR VPWR _207_ sky130_fd_sc_hd__or4_1
XFILLER_214_981 VPWR VGND VPWR VGND sky130_ef_sc_hd__decap_12
XTAP_TAPCELL_ROW_193_2238 VGND VPWR sky130_fd_sc_hd__tapvpwrvgnd_1
XTAP_TAPCELL_ROW_193_2227 VGND VPWR sky130_fd_sc_hd__tapvpwrvgnd_1
XFILLER_186_811 VGND VGND VPWR VPWR sky130_fd_sc_hd__fill_1
XTAP_TAPCELL_ROW_218_2945 VGND VPWR sky130_fd_sc_hd__tapvpwrvgnd_1
XFILLER_207_1399 VGND VGND VPWR VPWR sky130_fd_sc_hd__fill_1
XFILLER_201_653 VPWR VGND VPWR VGND sky130_ef_sc_hd__decap_12
XFILLER_200_141 VPWR VGND VPWR VGND sky130_ef_sc_hd__decap_12
XFILLER_199_1101 VPWR VGND VPWR VGND sky130_ef_sc_hd__decap_12
XFILLER_198_693 VGND VGND VPWR VPWR sky130_fd_sc_hd__decap_6
XFILLER_197_181 VPWR VGND VPWR VGND sky130_ef_sc_hd__decap_12
XTAP_TAPCELL_ROW_193_2249 VGND VPWR sky130_fd_sc_hd__tapvpwrvgnd_1
XFILLER_164_1093 VPWR VGND VPWR VGND sky130_ef_sc_hd__decap_12
XFILLER_71_51 VGND VGND VPWR VPWR sky130_fd_sc_hd__decap_4
XTAP_TAPCELL_ROW_218_2967 VGND VPWR sky130_fd_sc_hd__tapvpwrvgnd_1
XTAP_TAPCELL_ROW_218_2956 VGND VPWR sky130_fd_sc_hd__tapvpwrvgnd_1
XFILLER_201_697 VPWR VGND VPWR VGND sky130_ef_sc_hd__decap_12
XFILLER_199_1145 VPWR VGND VPWR VGND sky130_ef_sc_hd__decap_12
XFILLER_187_51 VGND VGND VPWR VPWR sky130_fd_sc_hd__decap_4
XFILLER_173_505 VPWR VGND VPWR VGND sky130_ef_sc_hd__decap_12
XFILLER_16_1350 VGND VGND VPWR VPWR sky130_fd_sc_hd__decap_6
XFILLER_199_1189 VPWR VGND VPWR VGND sky130_ef_sc_hd__decap_12
XFILLER_195_1009 VPWR VGND VPWR VGND sky130_ef_sc_hd__decap_12
XFILLER_103_1342 VPWR VGND VPWR VGND sky130_ef_sc_hd__decap_12
XFILLER_16_1394 VPWR VGND VPWR VGND sky130_ef_sc_hd__decap_12
XFILLER_51_1274 VPWR VGND VPWR VGND sky130_ef_sc_hd__decap_12
XFILLER_103_1386 VPWR VGND VPWR VGND sky130_ef_sc_hd__decap_12
XFILLER_86_1326 VPWR VGND VPWR VGND sky130_ef_sc_hd__decap_12
XFILLER_12_1258 VPWR VGND VPWR VGND sky130_ef_sc_hd__decap_12
XANTENNA__423__A b_addr\[6\] VGND VGND VPWR VPWR sky130_fd_sc_hd__diode_2
XFILLER_138_1438 VPWR VGND VPWR VGND sky130_ef_sc_hd__decap_12
XTAP_TAPCELL_ROW_118_2_3746 VGND VPWR sky130_fd_sc_hd__tapvpwrvgnd_1
XFILLER_64_1602 VGND VGND VPWR VPWR sky130_fd_sc_hd__decap_3
XFILLER_214_1315 VGND VGND VPWR VPWR sky130_fd_sc_hd__fill_1
XTAP_TAPCELL_ROW_86_2_3535 VGND VPWR sky130_fd_sc_hd__tapvpwrvgnd_1
XTAP_TAPCELL_ROW_182_1920 VGND VPWR sky130_fd_sc_hd__tapvpwrvgnd_1
XFILLER_23_1310 VPWR VGND VPWR VGND sky130_ef_sc_hd__decap_12
XFILLER_27_1490 VGND VGND VPWR VPWR sky130_fd_sc_hd__decap_6
XFILLER_62_1370 VPWR VGND VPWR VGND sky130_ef_sc_hd__decap_12
XFILLER_212_1061 VPWR VGND VPWR VGND sky130_ef_sc_hd__decap_12
XFILLER_209_753 VPWR VGND VPWR VGND sky130_ef_sc_hd__decap_12
XTAP_TAPCELL_ROW_182_1931 VGND VPWR sky130_fd_sc_hd__tapvpwrvgnd_1
XFILLER_114_1482 VPWR VGND VPWR VGND sky130_ef_sc_hd__decap_12
XFILLER_110_1302 VPWR VGND VPWR VGND sky130_ef_sc_hd__decap_12
XFILLER_97_1422 VPWR VGND VPWR VGND sky130_ef_sc_hd__decap_12
XFILLER_3_1437 VPWR VGND VPWR VGND sky130_ef_sc_hd__decap_12
XFILLER_23_1354 VPWR VGND VPWR VGND sky130_ef_sc_hd__decap_12
XFILLER_209_797 VPWR VGND VPWR VGND sky130_ef_sc_hd__decap_12
XTAP_TAPCELL_ROW_163_1374 VGND VPWR sky130_fd_sc_hd__tapvpwrvgnd_1
XTAP_TAPCELL_ROW_163_1363 VGND VPWR sky130_fd_sc_hd__tapvpwrvgnd_1
XTAP_TAPCELL_ROW_163_1352 VGND VPWR sky130_fd_sc_hd__tapvpwrvgnd_1
XFILLER_23_1398 VPWR VGND VPWR VGND sky130_ef_sc_hd__decap_12
XFILLER_58_1406 VGND VGND VPWR VPWR sky130_fd_sc_hd__decap_6
XTAP_TAPCELL_ROW_163_1396 VGND VPWR sky130_fd_sc_hd__tapvpwrvgnd_1
XTAP_TAPCELL_ROW_163_1385 VGND VPWR sky130_fd_sc_hd__tapvpwrvgnd_1
XFILLER_149_1534 VPWR VGND VPWR VGND sky130_ef_sc_hd__decap_12
XFILLER_97_1466 VPWR VGND VPWR VGND sky130_ef_sc_hd__decap_12
XFILLER_149_1578 VPWR VGND VPWR VGND sky130_ef_sc_hd__decap_12
XFILLER_211_417 VPWR VGND VPWR VGND sky130_ef_sc_hd__decap_12
XFILLER_189_671 VGND VGND VPWR VPWR sky130_fd_sc_hd__fill_1
XFILLER_108_1220 VPWR VGND VPWR VGND sky130_ef_sc_hd__decap_12
XFILLER_177_833 VGND VGND VPWR VPWR sky130_fd_sc_hd__decap_6
XFILLER_176_321 VPWR VGND VPWR VGND sky130_ef_sc_hd__decap_12
XTAP_TAPCELL_ROW_176_1746 VGND VPWR sky130_fd_sc_hd__tapvpwrvgnd_1
XFILLER_177_877 VPWR VGND VPWR VGND sky130_ef_sc_hd__decap_12
XTAP_TAPCELL_ROW_176_1768 VGND VPWR sky130_fd_sc_hd__tapvpwrvgnd_1
XTAP_TAPCELL_ROW_176_1757 VGND VPWR sky130_fd_sc_hd__tapvpwrvgnd_1
XFILLER_176_365 VPWR VGND VPWR VGND sky130_ef_sc_hd__decap_12
XFILLER_34_1450 VPWR VGND VPWR VGND sky130_ef_sc_hd__decap_12
XFILLER_192_825 VPWR VGND VPWR VGND sky130_ef_sc_hd__decap_12
XFILLER_178_1229 VPWR VGND VPWR VGND sky130_ef_sc_hd__decap_12
XFILLER_121_1442 VPWR VGND VPWR VGND sky130_ef_sc_hd__decap_12
XFILLER_30_1314 VPWR VGND VPWR VGND sky130_ef_sc_hd__decap_12
XFILLER_34_1494 VPWR VGND VPWR VGND sky130_ef_sc_hd__decap_12
XFILLER_192_869 VPWR VGND VPWR VGND sky130_ef_sc_hd__decap_12
XFILLER_191_335 VGND VGND VPWR VPWR sky130_fd_sc_hd__fill_1
XFILLER_30_1358 VPWR VGND VPWR VGND sky130_ef_sc_hd__decap_12
XANTENNA_u_sram.u_mem_clk1 clknet_3_7_0_clk VGND VGND VPWR VPWR sky130_fd_sc_hd__diode_2
XFILLER_69_1546 VGND VGND VPWR VPWR sky130_fd_sc_hd__decap_6
XFILLER_156_1538 VPWR VGND VPWR VGND sky130_ef_sc_hd__decap_12
XFILLER_28_1232 VPWR VGND VPWR VGND sky130_ef_sc_hd__decap_12
XFILLER_219_517 VPWR VGND VPWR VGND sky130_ef_sc_hd__decap_12
XFILLER_76_29 VPWR VGND VPWR VGND sky130_ef_sc_hd__decap_12
XFILLER_8_1326 VPWR VGND VPWR VGND sky130_ef_sc_hd__decap_12
XANTENNA_input5_A func_addr[2] VGND VGND VPWR VPWR sky130_fd_sc_hd__diode_2
XFILLER_189_1325 VPWR VGND VPWR VGND sky130_ef_sc_hd__decap_12
XFILLER_115_1268 VGND VGND VPWR VPWR sky130_fd_sc_hd__decap_4
XFILLER_80_1470 VPWR VGND VPWR VGND sky130_ef_sc_hd__decap_12
XFILLER_41_1410 VPWR VGND VPWR VGND sky130_ef_sc_hd__decap_12
XFILLER_45_1590 VPWR VGND VPWR VGND sky130_ef_sc_hd__decap_12
XFILLER_132_1582 VPWR VGND VPWR VGND sky130_ef_sc_hd__decap_12
XFILLER_6_1061 VPWR VGND VPWR VGND sky130_ef_sc_hd__decap_12
XFILLER_41_1454 VPWR VGND VPWR VGND sky130_ef_sc_hd__decap_12
XFILLER_189_1369 VPWR VGND VPWR VGND sky130_ef_sc_hd__decap_12
XFILLER_76_1506 VPWR VGND VPWR VGND sky130_ef_sc_hd__decap_12
XFILLER_41_1498 VPWR VGND VPWR VGND sky130_ef_sc_hd__decap_12
XFILLER_214_233 VPWR VGND VPWR VGND sky130_ef_sc_hd__decap_12
XFILLER_163_1509 VGND VGND VPWR VPWR sky130_fd_sc_hd__decap_3
XFILLER_41_113 VPWR VGND VPWR VGND sky130_ef_sc_hd__decap_12
XFILLER_214_277 VPWR VGND VPWR VGND sky130_ef_sc_hd__decap_12
XFILLER_168_811 VGND VGND VPWR VPWR sky130_fd_sc_hd__fill_1
XFILLER_25_77 VGND VGND VPWR VPWR sky130_fd_sc_hd__decap_3
XFILLER_211_951 VGND VGND VPWR VPWR sky130_fd_sc_hd__fill_1
XFILLER_195_641 VPWR VGND VPWR VGND sky130_ef_sc_hd__decap_12
XFILLER_179_181 VPWR VGND VPWR VGND sky130_ef_sc_hd__decap_12
XFILLER_161_1244 VPWR VGND VPWR VGND sky130_ef_sc_hd__decap_12
XFILLER_204_1539 VGND VGND VPWR VPWR sky130_fd_sc_hd__fill_1
XFILLER_52_1550 VPWR VGND VPWR VGND sky130_ef_sc_hd__decap_12
XFILLER_202_1241 VPWR VGND VPWR VGND sky130_ef_sc_hd__decap_12
XFILLER_195_685 VPWR VGND VPWR VGND sky130_ef_sc_hd__decap_12
XFILLER_13_1534 VPWR VGND VPWR VGND sky130_ef_sc_hd__decap_12
XFILLER_52_1594 VGND VGND VPWR VPWR sky130_fd_sc_hd__decap_8
XTAP_TAPCELL_ROW_213_2820 VGND VPWR sky130_fd_sc_hd__tapvpwrvgnd_1
XFILLER_210_3 VPWR VGND VPWR VGND sky130_ef_sc_hd__decap_12
XFILLER_202_1285 VPWR VGND VPWR VGND sky130_ef_sc_hd__decap_12
XFILLER_196_1329 VPWR VGND VPWR VGND sky130_ef_sc_hd__decap_12
XFILLER_194_195 VGND VGND VPWR VPWR sky130_fd_sc_hd__fill_1
XFILLER_182_357 VGND VGND VPWR VPWR sky130_fd_sc_hd__decap_6
XFILLER_100_1526 VPWR VGND VPWR VGND sky130_ef_sc_hd__decap_12
XTAP_TAPCELL_ROW_92_2_3578 VGND VPWR sky130_fd_sc_hd__tapvpwrvgnd_1
XFILLER_87_1602 VGND VGND VPWR VPWR sky130_fd_sc_hd__decap_3
XFILLER_13_1578 VPWR VGND VPWR VGND sky130_ef_sc_hd__decap_12
XTAP_TAPCELL_ROW_104_2_3654 VGND VPWR sky130_fd_sc_hd__tapvpwrvgnd_1
XTAP_TAPCELL_ROW_186_2053 VGND VPWR sky130_fd_sc_hd__tapvpwrvgnd_1
XTAP_TAPCELL_ROW_186_2042 VGND VPWR sky130_fd_sc_hd__tapvpwrvgnd_1
XTAP_TAPCELL_ROW_186_2031 VGND VPWR sky130_fd_sc_hd__tapvpwrvgnd_1
XTAP_TAPCELL_ROW_72_2_3443 VGND VPWR sky130_fd_sc_hd__tapvpwrvgnd_1
XFILLER_2_776 VGND VGND VPWR VPWR sky130_fd_sc_hd__fill_1
XFILLER_172_1373 VPWR VGND VPWR VGND sky130_ef_sc_hd__decap_12
XFILLER_81_1256 VPWR VGND VPWR VGND sky130_ef_sc_hd__decap_12
XFILLER_2_15 VPWR VGND VPWR VGND sky130_ef_sc_hd__decap_12
XTAP_TAPCELL_ROW_207_2635 VGND VPWR sky130_fd_sc_hd__tapvpwrvgnd_1
XFILLER_1_297 VGND VGND VPWR VPWR sky130_fd_sc_hd__fill_1
XFILLER_213_1381 VPWR VGND VPWR VGND sky130_ef_sc_hd__decap_12
XTAP_TAPCELL_ROW_207_2646 VGND VPWR sky130_fd_sc_hd__tapvpwrvgnd_1
XFILLER_168_1409 VPWR VGND VPWR VGND sky130_ef_sc_hd__decap_12
XFILLER_206_701 VPWR VGND VPWR VGND sky130_ef_sc_hd__decap_12
XTAP_TAPCELL_ROW_199_2425 VGND VPWR sky130_fd_sc_hd__tapvpwrvgnd_1
XTAP_TAPCELL_ROW_199_2414 VGND VPWR sky130_fd_sc_hd__tapvpwrvgnd_1
XTAP_TAPCELL_ROW_199_2403 VGND VPWR sky130_fd_sc_hd__tapvpwrvgnd_1
XFILLER_17_121 VGND VGND VPWR VPWR sky130_fd_sc_hd__decap_3
XFILLER_20_1538 VPWR VGND VPWR VGND sky130_ef_sc_hd__decap_12
XPHY_EDGE_ROW_107_2_Left_539 VGND VGND VPWR VPWR sky130_fd_sc_hd__decap_3
X_527_ net138 _237_ VGND VGND VPWR VPWR _047_ sky130_fd_sc_hd__and2_1
XFILLER_82_83 VGND VGND VPWR VPWR sky130_fd_sc_hd__fill_1
XFILLER_18_1412 VGND VGND VPWR VPWR sky130_fd_sc_hd__fill_1
XFILLER_198_83 VGND VGND VPWR VPWR sky130_fd_sc_hd__fill_1
X_458_ net146 net103 VGND VGND VPWR VPWR _190_ sky130_fd_sc_hd__xor2_1
XFILLER_202_973 VGND VGND VPWR VPWR sky130_fd_sc_hd__decap_6
XFILLER_201_461 VPWR VGND VPWR VGND sky130_ef_sc_hd__decap_12
X_389_ b_addr\[2\] _104_ VGND VGND VPWR VPWR _127_ sky130_fd_sc_hd__nand2_1
XFILLER_179_1505 VGND VGND VPWR VPWR sky130_fd_sc_hd__decap_6
XFILLER_174_825 VPWR VGND VPWR VGND sky130_ef_sc_hd__decap_12
XFILLER_179_1549 VPWR VGND VPWR VGND sky130_ef_sc_hd__decap_12
XFILLER_174_869 VPWR VGND VPWR VGND sky130_ef_sc_hd__decap_12
XFILLER_173_335 VGND VGND VPWR VPWR sky130_fd_sc_hd__fill_1
XTAP_TAPCELL_ROW_171_1621 VGND VPWR sky130_fd_sc_hd__tapvpwrvgnd_1
XTAP_TAPCELL_ROW_171_1610 VGND VPWR sky130_fd_sc_hd__tapvpwrvgnd_1
XANTENNA__505__B1 net138 VGND VGND VPWR VPWR sky130_fd_sc_hd__diode_2
Xoutput105 net105 VGND VGND VPWR VPWR func_rdata[24] sky130_fd_sc_hd__buf_2
Xoutput116 net116 VGND VGND VPWR VPWR func_rdata[5] sky130_fd_sc_hd__buf_2
XFILLER_56_3 VPWR VGND VPWR VGND sky130_ef_sc_hd__decap_12
XFILLER_217_57 VPWR VGND VPWR VGND sky130_ef_sc_hd__decap_12
XFILLER_138_1246 VPWR VGND VPWR VGND sky130_ef_sc_hd__decap_12
XFILLER_99_113 VPWR VGND VPWR VGND sky130_ef_sc_hd__decap_12
XFILLER_5_570 VGND VGND VPWR VPWR sky130_fd_sc_hd__decap_3
XFILLER_9_1602 VGND VGND VPWR VPWR sky130_fd_sc_hd__decap_3
XFILLER_29_1552 VGND VGND VPWR VPWR sky130_fd_sc_hd__fill_1
XTAP_TAPCELL_ROW_169_1550 VGND VPWR sky130_fd_sc_hd__tapvpwrvgnd_1
XPHY_EDGE_ROW_36_2_Right_93 VGND VGND VPWR VPWR sky130_fd_sc_hd__decap_3
XTAP_TAPCELL_ROW_169_1561 VGND VPWR sky130_fd_sc_hd__tapvpwrvgnd_1
XTAP_TAPCELL_ROW_148_2_3941 VGND VPWR sky130_fd_sc_hd__tapvpwrvgnd_1
XTAP_TAPCELL_ROW_165_1447 VGND VPWR sky130_fd_sc_hd__tapvpwrvgnd_1
XTAP_TAPCELL_ROW_165_1436 VGND VPWR sky130_fd_sc_hd__tapvpwrvgnd_1
XFILLER_3_1201 VPWR VGND VPWR VGND sky130_ef_sc_hd__decap_12
XFILLER_209_561 VPWR VGND VPWR VGND sky130_ef_sc_hd__decap_12
XFILLER_186_1509 VPWR VGND VPWR VGND sky130_ef_sc_hd__decap_12
XTAP_TAPCELL_ROW_117_1_1251 VGND VPWR sky130_fd_sc_hd__tapvpwrvgnd_1
XFILLER_3_1245 VPWR VGND VPWR VGND sky130_ef_sc_hd__decap_12
XFILLER_102_27 VGND VGND VPWR VPWR sky130_fd_sc_hd__fill_1
XFILLER_97_1274 VPWR VGND VPWR VGND sky130_ef_sc_hd__decap_12
XFILLER_3_1289 VPWR VGND VPWR VGND sky130_ef_sc_hd__decap_12
XTAP_TAPCELL_ROW_22_1_1062 VGND VPWR sky130_fd_sc_hd__tapvpwrvgnd_1
XFILLER_149_1342 VPWR VGND VPWR VGND sky130_ef_sc_hd__decap_12
XFILLER_58_1258 VPWR VGND VPWR VGND sky130_ef_sc_hd__decap_12
XFILLER_212_737 VPWR VGND VPWR VGND sky130_ef_sc_hd__decap_12
XFILLER_211_225 VPWR VGND VPWR VGND sky130_ef_sc_hd__decap_12
XTAP_TAPCELL_ROW_178_1819 VGND VPWR sky130_fd_sc_hd__tapvpwrvgnd_1
XTAP_TAPCELL_ROW_178_1808 VGND VPWR sky130_fd_sc_hd__tapvpwrvgnd_1
XFILLER_149_1386 VPWR VGND VPWR VGND sky130_ef_sc_hd__decap_12
XANTENNA_fanout150_A net151 VGND VGND VPWR VPWR sky130_fd_sc_hd__diode_2
XFILLER_23_124 VGND VGND VPWR VPWR sky130_fd_sc_hd__decap_3
XFILLER_177_641 VPWR VGND VPWR VGND sky130_ef_sc_hd__decap_12
XFILLER_203_1561 VGND VGND VPWR VPWR sky130_fd_sc_hd__decap_6
XFILLER_177_685 VPWR VGND VPWR VGND sky130_ef_sc_hd__decap_12
XTAP_TAPCELL_ROW_110_1_1238 VGND VPWR sky130_fd_sc_hd__tapvpwrvgnd_1
XFILLER_178_1037 VPWR VGND VPWR VGND sky130_ef_sc_hd__decap_12
XFILLER_176_195 VGND VGND VPWR VPWR sky130_fd_sc_hd__fill_1
XFILLER_164_357 VGND VGND VPWR VPWR sky130_fd_sc_hd__decap_6
XPHY_EDGE_ROW_153_2_Left_585 VGND VGND VPWR VPWR sky130_fd_sc_hd__decap_3
XFILLER_69_1310 VPWR VGND VPWR VGND sky130_ef_sc_hd__decap_12
XFILLER_192_699 VGND VGND VPWR VPWR sky130_fd_sc_hd__fill_1
XFILLER_156_1302 VPWR VGND VPWR VGND sky130_ef_sc_hd__decap_12
XFILLER_121_1272 VGND VGND VPWR VPWR sky130_fd_sc_hd__fill_1
XFILLER_69_1354 VPWR VGND VPWR VGND sky130_ef_sc_hd__decap_12
XFILLER_11_57 VPWR VGND VPWR VGND sky130_ef_sc_hd__decap_12
XFILLER_127_57 VPWR VGND VPWR VGND sky130_ef_sc_hd__decap_12
XFILLER_219_1089 VGND VGND VPWR VPWR sky130_fd_sc_hd__decap_3
XPHY_EDGE_ROW_90_2_Left_522 VGND VGND VPWR VPWR sky130_fd_sc_hd__decap_3
XFILLER_87_39 VPWR VGND VPWR VGND sky130_ef_sc_hd__decap_12
XFILLER_69_1398 VPWR VGND VPWR VGND sky130_ef_sc_hd__decap_12
XTAP_TAPCELL_ROW_37_2_3221 VGND VPWR sky130_fd_sc_hd__tapvpwrvgnd_1
XFILLER_210_1521 VPWR VGND VPWR VGND sky130_ef_sc_hd__decap_12
XFILLER_189_1133 VPWR VGND VPWR VGND sky130_ef_sc_hd__decap_12
XFILLER_210_1565 VPWR VGND VPWR VGND sky130_ef_sc_hd__decap_12
XTAP_TAPCELL_ROW_202_2510 VGND VPWR sky130_fd_sc_hd__tapvpwrvgnd_1
XFILLER_189_1177 VPWR VGND VPWR VGND sky130_ef_sc_hd__decap_12
XFILLER_76_1314 VPWR VGND VPWR VGND sky130_ef_sc_hd__decap_12
XFILLER_215_553 VGND VGND VPWR VPWR sky130_fd_sc_hd__decap_6
XFILLER_160_3 VPWR VGND VPWR VGND sky130_ef_sc_hd__decap_12
XFILLER_36_65 VPWR VGND VPWR VGND sky130_ef_sc_hd__decap_12
XFILLER_215_597 VPWR VGND VPWR VGND sky130_ef_sc_hd__decap_12
XFILLER_188_917 VGND VGND VPWR VPWR sky130_fd_sc_hd__decap_6
XFILLER_187_405 VPWR VGND VPWR VGND sky130_ef_sc_hd__decap_12
XFILLER_163_1317 VPWR VGND VPWR VGND sky130_ef_sc_hd__decap_12
XFILLER_128_1426 VPWR VGND VPWR VGND sky130_ef_sc_hd__decap_12
XFILLER_76_1358 VPWR VGND VPWR VGND sky130_ef_sc_hd__decap_12
XFILLER_187_449 VPWR VGND VPWR VGND sky130_ef_sc_hd__decap_12
X_312_ net22 net144 net133 VGND VGND VPWR VPWR s_wdata\[19\] sky130_fd_sc_hd__a21o_1
XFILLER_52_20 VGND VGND VPWR VPWR sky130_fd_sc_hd__decap_8
XFILLER_208_1483 VGND VGND VPWR VPWR sky130_fd_sc_hd__fill_1
XFILLER_196_961 VPWR VGND VPWR VGND sky130_ef_sc_hd__decap_12
XFILLER_52_53 VPWR VGND VPWR VGND sky130_ef_sc_hd__decap_12
XFILLER_168_53 VPWR VGND VPWR VGND sky130_ef_sc_hd__decap_12
Xinput18 func_wdata[15] VGND VGND VPWR VPWR net18 sky130_fd_sc_hd__clkbuf_1
XFILLER_6_301 VGND VGND VPWR VPWR sky130_fd_sc_hd__decap_6
XFILLER_7_813 VPWR VGND VPWR VGND sky130_ef_sc_hd__decap_12
XFILLER_182_121 VPWR VGND VPWR VGND sky130_ef_sc_hd__decap_12
XFILLER_168_97 VPWR VGND VPWR VGND sky130_ef_sc_hd__decap_12
XFILLER_104_1470 VPWR VGND VPWR VGND sky130_ef_sc_hd__decap_12
XFILLER_87_1410 VPWR VGND VPWR VGND sky130_ef_sc_hd__decap_12
Xinput29 func_wdata[25] VGND VGND VPWR VPWR net29 sky130_fd_sc_hd__clkbuf_1
XFILLER_13_1342 VPWR VGND VPWR VGND sky130_ef_sc_hd__decap_12
XFILLER_202_1093 VPWR VGND VPWR VGND sky130_ef_sc_hd__decap_12
XTAP_TAPCELL_ROW_188_2104 VGND VPWR sky130_fd_sc_hd__tapvpwrvgnd_1
XFILLER_182_165 VPWR VGND VPWR VGND sky130_ef_sc_hd__decap_12
XFILLER_171_839 VGND VGND VPWR VPWR sky130_fd_sc_hd__fill_1
XFILLER_6_345 VPWR VGND VPWR VGND sky130_ef_sc_hd__decap_12
XFILLER_13_1386 VPWR VGND VPWR VGND sky130_ef_sc_hd__decap_12
XFILLER_184_41 VPWR VGND VPWR VGND sky130_ef_sc_hd__decap_12
XFILLER_139_1522 VPWR VGND VPWR VGND sky130_ef_sc_hd__decap_12
XFILLER_100_1356 VGND VGND VPWR VPWR sky130_fd_sc_hd__fill_1
XFILLER_87_1454 VPWR VGND VPWR VGND sky130_ef_sc_hd__decap_12
XFILLER_6_389 VPWR VGND VPWR VGND sky130_ef_sc_hd__decap_12
XFILLER_184_85 VPWR VGND VPWR VGND sky130_ef_sc_hd__decap_12
XFILLER_139_1566 VPWR VGND VPWR VGND sky130_ef_sc_hd__decap_12
XFILLER_87_1498 VPWR VGND VPWR VGND sky130_ef_sc_hd__decap_12
XFILLER_48_1438 VPWR VGND VPWR VGND sky130_ef_sc_hd__decap_12
XTAP_TAPCELL_ROW_209_2708 VGND VPWR sky130_fd_sc_hd__tapvpwrvgnd_1
XFILLER_219_881 VPWR VGND VPWR VGND sky130_ef_sc_hd__decap_12
XFILLER_203_15 VPWR VGND VPWR VGND sky130_ef_sc_hd__decap_12
XFILLER_168_1217 VPWR VGND VPWR VGND sky130_ef_sc_hd__decap_12
XFILLER_4_1521 VPWR VGND VPWR VGND sky130_ef_sc_hd__decap_12
XFILLER_20_1302 VPWR VGND VPWR VGND sky130_ef_sc_hd__decap_12
XFILLER_24_1482 VPWR VGND VPWR VGND sky130_ef_sc_hd__decap_12
XFILLER_206_531 VGND VGND VPWR VPWR sky130_fd_sc_hd__fill_1
XFILLER_98_1550 VPWR VGND VPWR VGND sky130_ef_sc_hd__decap_12
XFILLER_4_1565 VPWR VGND VPWR VGND sky130_ef_sc_hd__decap_12
XFILLER_209_1225 VGND VGND VPWR VPWR sky130_fd_sc_hd__decap_6
XPHY_EDGE_ROW_149_1_Left_368 VGND VGND VPWR VPWR sky130_fd_sc_hd__decap_3
XFILLER_111_1496 VGND VGND VPWR VPWR sky130_fd_sc_hd__fill_1
XFILLER_98_1594 VGND VGND VPWR VPWR sky130_fd_sc_hd__decap_8
XFILLER_94_1414 VPWR VGND VPWR VGND sky130_ef_sc_hd__decap_12
XFILLER_93_93 VPWR VGND VPWR VGND sky130_ef_sc_hd__decap_12
XFILLER_0_1429 VPWR VGND VPWR VGND sky130_ef_sc_hd__decap_12
XFILLER_59_1534 VPWR VGND VPWR VGND sky130_ef_sc_hd__decap_12
XFILLER_146_1526 VPWR VGND VPWR VGND sky130_ef_sc_hd__decap_12
XFILLER_59_1578 VPWR VGND VPWR VGND sky130_ef_sc_hd__decap_12
XFILLER_209_1269 VPWR VGND VPWR VGND sky130_ef_sc_hd__decap_12
XFILLER_18_1220 VPWR VGND VPWR VGND sky130_ef_sc_hd__decap_12
XPHY_EDGE_ROW_86_1_Left_305 VGND VGND VPWR VPWR sky130_fd_sc_hd__decap_3
XFILLER_202_781 VPWR VGND VPWR VGND sky130_ef_sc_hd__decap_12
XFILLER_144_1294 VGND VGND VPWR VPWR sky130_fd_sc_hd__decap_6
XFILLER_105_1256 VPWR VGND VPWR VGND sky130_ef_sc_hd__decap_12
XTAP_TAPCELL_ROW_63_2_3388 VGND VPWR sky130_fd_sc_hd__tapvpwrvgnd_1
XFILLER_179_1313 VPWR VGND VPWR VGND sky130_ef_sc_hd__decap_12
XFILLER_31_1442 VPWR VGND VPWR VGND sky130_ef_sc_hd__decap_12
XFILLER_179_1357 VPWR VGND VPWR VGND sky130_ef_sc_hd__decap_12
XFILLER_174_699 VGND VGND VPWR VPWR sky130_fd_sc_hd__fill_1
XFILLER_170_861 VGND VGND VPWR VPWR sky130_fd_sc_hd__decap_6
XFILLER_66_1538 VPWR VGND VPWR VGND sky130_ef_sc_hd__decap_12
XFILLER_216_1229 VPWR VGND VPWR VGND sky130_ef_sc_hd__decap_12
XTAP_TAPCELL_ROW_167_1509 VGND VPWR sky130_fd_sc_hd__tapvpwrvgnd_1
XFILLER_87_105 VGND VGND VPWR VPWR sky130_fd_sc_hd__decap_6
XFILLER_9_1410 VPWR VGND VPWR VGND sky130_ef_sc_hd__decap_12
XFILLER_151_1232 VPWR VGND VPWR VGND sky130_ef_sc_hd__decap_12
XFILLER_9_1454 VPWR VGND VPWR VGND sky130_ef_sc_hd__decap_12
XFILLER_9_1498 VPWR VGND VPWR VGND sky130_ef_sc_hd__decap_12
XFILLER_25_1268 VGND VGND VPWR VPWR sky130_fd_sc_hd__decap_4
XFILLER_151_1298 VPWR VGND VPWR VGND sky130_ef_sc_hd__decap_12
XFILLER_113_15 VPWR VGND VPWR VGND sky130_ef_sc_hd__decap_12
XFILLER_186_1317 VPWR VGND VPWR VGND sky130_ef_sc_hd__decap_12
XFILLER_42_1582 VPWR VGND VPWR VGND sky130_ef_sc_hd__decap_12
XTAP_TAPCELL_ROW_53_1_1123 VGND VPWR sky130_fd_sc_hd__tapvpwrvgnd_1
XFILLER_209_391 VGND VGND VPWR VPWR sky130_fd_sc_hd__fill_1
XTAP_TAPCELL_ROW_219_3015 VGND VPWR sky130_fd_sc_hd__tapvpwrvgnd_1
XTAP_TAPCELL_ROW_219_3004 VGND VPWR sky130_fd_sc_hd__tapvpwrvgnd_1
XFILLER_212_501 VPWR VGND VPWR VGND sky130_ef_sc_hd__decap_12
XFILLER_169_405 VPWR VGND VPWR VGND sky130_ef_sc_hd__decap_12
XANTENNA_fanout153_X net153 VGND VGND VPWR VPWR sky130_fd_sc_hd__diode_2
XFILLER_212_545 VPWR VGND VPWR VGND sky130_ef_sc_hd__decap_12
XFILLER_184_1085 VGND VGND VPWR VPWR sky130_fd_sc_hd__decap_6
XFILLER_169_449 VPWR VGND VPWR VGND sky130_ef_sc_hd__decap_12
XFILLER_212_589 VPWR VGND VPWR VGND sky130_ef_sc_hd__decap_12
XFILLER_185_909 VPWR VGND VPWR VGND sky130_ef_sc_hd__decap_12
XFILLER_178_961 VPWR VGND VPWR VGND sky130_ef_sc_hd__decap_12
XFILLER_162_1350 VGND VGND VPWR VPWR sky130_fd_sc_hd__decap_6
XFILLER_71_1244 VPWR VGND VPWR VGND sky130_ef_sc_hd__decap_12
XPHY_EDGE_ROW_70_1_Left_289 VGND VGND VPWR VPWR sky130_fd_sc_hd__decap_3
XFILLER_184_419 VGND VGND VPWR VPWR sky130_fd_sc_hd__fill_1
XFILLER_162_1394 VPWR VGND VPWR VGND sky130_ef_sc_hd__decap_12
XFILLER_7_109 VGND VGND VPWR VPWR sky130_fd_sc_hd__decap_3
XFILLER_197_1413 VPWR VGND VPWR VGND sky130_ef_sc_hd__decap_12
XFILLER_193_953 VPWR VGND VPWR VGND sky130_ef_sc_hd__decap_12
XFILLER_164_121 VPWR VGND VPWR VGND sky130_ef_sc_hd__decap_12
XFILLER_123_1378 VGND VGND VPWR VPWR sky130_fd_sc_hd__decap_6
XFILLER_22_56 VGND VGND VPWR VPWR sky130_fd_sc_hd__decap_4
XFILLER_197_1457 VPWR VGND VPWR VGND sky130_ef_sc_hd__decap_12
XFILLER_164_165 VPWR VGND VPWR VGND sky130_ef_sc_hd__decap_12
XFILLER_10_1526 VPWR VGND VPWR VGND sky130_ef_sc_hd__decap_12
XFILLER_180_625 VPWR VGND VPWR VGND sky130_ef_sc_hd__decap_12
XFILLER_98_27 VGND VGND VPWR VPWR sky130_fd_sc_hd__fill_1
XFILLER_4_849 VGND VGND VPWR VPWR sky130_fd_sc_hd__decap_4
XFILLER_3_315 VGND VGND VPWR VPWR sky130_fd_sc_hd__fill_1
XFILLER_191_1001 VGND VGND VPWR VPWR sky130_fd_sc_hd__decap_6
XFILLER_180_669 VPWR VGND VPWR VGND sky130_ef_sc_hd__decap_12
XTAP_TAPCELL_ROW_119_2_3751 VGND VPWR sky130_fd_sc_hd__tapvpwrvgnd_1
XFILLER_3_337 VGND VGND VPWR VPWR sky130_fd_sc_hd__decap_3
XFILLER_191_1045 VPWR VGND VPWR VGND sky130_ef_sc_hd__decap_12
XFILLER_191_1089 VPWR VGND VPWR VGND sky130_ef_sc_hd__decap_12
XFILLER_154_77 VGND VGND VPWR VPWR sky130_fd_sc_hd__decap_6
Xfanout140 _083_ VGND VGND VPWR VPWR net140 sky130_fd_sc_hd__buf_4
Xfanout151 net48 VGND VGND VPWR VPWR net151 sky130_fd_sc_hd__buf_2
XFILLER_130_1338 VPWR VGND VPWR VGND sky130_ef_sc_hd__decap_12
XFILLER_207_317 VPWR VGND VPWR VGND sky130_ef_sc_hd__decap_12
XFILLER_170_65 VPWR VGND VPWR VGND sky130_ef_sc_hd__decap_12
XFILLER_169_1537 VPWR VGND VPWR VGND sky130_ef_sc_hd__decap_12
XTAP_TAPCELL_ROW_112_2_3705 VGND VPWR sky130_fd_sc_hd__tapvpwrvgnd_1
XTAP_TAPCELL_ROW_3_882 VGND VPWR sky130_fd_sc_hd__tapvpwrvgnd_1
XTAP_TAPCELL_ROW_3_871 VGND VPWR sky130_fd_sc_hd__tapvpwrvgnd_1
XFILLER_210_1373 VPWR VGND VPWR VGND sky130_ef_sc_hd__decap_12
XFILLER_215_361 VPWR VGND VPWR VGND sky130_ef_sc_hd__decap_12
XFILLER_103_81 VPWR VGND VPWR VGND sky130_ef_sc_hd__decap_12
XFILLER_206_1409 VPWR VGND VPWR VGND sky130_ef_sc_hd__decap_12
XFILLER_188_725 VPWR VGND VPWR VGND sky130_ef_sc_hd__decap_12
XFILLER_188_769 VPWR VGND VPWR VGND sky130_ef_sc_hd__decap_12
XFILLER_187_279 VGND VGND VPWR VPWR sky130_fd_sc_hd__fill_1
XFILLER_180_1483 VGND VGND VPWR VPWR sky130_fd_sc_hd__fill_1
XFILLER_141_1434 VGND VGND VPWR VPWR sky130_fd_sc_hd__decap_6
XFILLER_183_441 VGND VGND VPWR VPWR sky130_fd_sc_hd__decap_6
XFILLER_141_1478 VPWR VGND VPWR VGND sky130_ef_sc_hd__decap_12
XFILLER_195_51 VGND VGND VPWR VPWR sky130_fd_sc_hd__decap_4
XFILLER_183_485 VPWR VGND VPWR VGND sky130_ef_sc_hd__decap_12
XFILLER_6_175 VPWR VGND VPWR VGND sky130_ef_sc_hd__decap_12
XFILLER_217_1505 VGND VGND VPWR VPWR sky130_fd_sc_hd__decap_6
XFILLER_139_1330 VPWR VGND VPWR VGND sky130_ef_sc_hd__decap_12
XFILLER_6_197 VGND VGND VPWR VPWR sky130_fd_sc_hd__decap_6
XANTENNA__431__A b_addr\[7\] VGND VGND VPWR VPWR sky130_fd_sc_hd__diode_2
XFILLER_48_1246 VPWR VGND VPWR VGND sky130_ef_sc_hd__decap_12
XFILLER_217_1549 VPWR VGND VPWR VGND sky130_ef_sc_hd__decap_12
XFILLER_69_105 VGND VGND VPWR VPWR sky130_fd_sc_hd__decap_6
XFILLER_170_1129 VPWR VGND VPWR VGND sky130_ef_sc_hd__decap_12
XFILLER_152_1574 VGND VGND VPWR VPWR sky130_fd_sc_hd__decap_6
XTAP_TAPCELL_ROW_1_808 VGND VPWR sky130_fd_sc_hd__tapvpwrvgnd_1
XFILLER_19_3 VPWR VGND VPWR VGND sky130_ef_sc_hd__decap_12
XTAP_TAPCELL_ROW_134_1_1286 VGND VPWR sky130_fd_sc_hd__tapvpwrvgnd_1
XTAP_TAPCELL_ROW_1_819 VGND VPWR sky130_fd_sc_hd__tapvpwrvgnd_1
XFILLER_4_1373 VPWR VGND VPWR VGND sky130_ef_sc_hd__decap_12
XFILLER_209_1033 VPWR VGND VPWR VGND sky130_ef_sc_hd__decap_12
XFILLER_207_895 VGND VGND VPWR VPWR sky130_fd_sc_hd__fill_1
XFILLER_94_1244 VGND VGND VPWR VPWR sky130_fd_sc_hd__fill_1
XFILLER_59_1342 VPWR VGND VPWR VGND sky130_ef_sc_hd__decap_12
XFILLER_181_1225 VGND VGND VPWR VPWR sky130_fd_sc_hd__decap_6
XFILLER_146_1356 VGND VGND VPWR VPWR sky130_fd_sc_hd__fill_1
XFILLER_59_1386 VPWR VGND VPWR VGND sky130_ef_sc_hd__decap_12
XFILLER_209_1077 VPWR VGND VPWR VGND sky130_ef_sc_hd__decap_12
XFILLER_181_1269 VPWR VGND VPWR VGND sky130_ef_sc_hd__decap_12
XFILLER_167_909 VPWR VGND VPWR VGND sky130_ef_sc_hd__decap_12
XFILLER_193_205 VPWR VGND VPWR VGND sky130_ef_sc_hd__decap_12
XFILLER_166_419 VGND VGND VPWR VPWR sky130_fd_sc_hd__fill_1
XFILLER_193_249 VPWR VGND VPWR VGND sky130_ef_sc_hd__decap_12
XFILLER_179_1121 VPWR VGND VPWR VGND sky130_ef_sc_hd__decap_12
XFILLER_175_953 VPWR VGND VPWR VGND sky130_ef_sc_hd__decap_12
XFILLER_146_121 VGND VGND VPWR VPWR sky130_fd_sc_hd__decap_6
XFILLER_120_1518 VGND VGND VPWR VPWR sky130_fd_sc_hd__decap_6
XFILLER_190_923 VGND VGND VPWR VPWR sky130_fd_sc_hd__fill_1
XTAP_TAPCELL_ROW_93_2_3583 VGND VPWR sky130_fd_sc_hd__tapvpwrvgnd_1
XFILLER_200_1553 VPWR VGND VPWR VGND sky130_ef_sc_hd__decap_12
XFILLER_175_1007 VGND VGND VPWR VPWR sky130_fd_sc_hd__fill_1
XFILLER_161_113 VPWR VGND VPWR VGND sky130_ef_sc_hd__decap_12
XFILLER_108_15 VPWR VGND VPWR VGND sky130_ef_sc_hd__decap_12
XFILLER_66_1302 VPWR VGND VPWR VGND sky130_ef_sc_hd__decap_12
XANTENNA__576__CLK clknet_3_0_0_clk VGND VGND VPWR VPWR sky130_fd_sc_hd__diode_2
XFILLER_31_1272 VGND VGND VPWR VPWR sky130_fd_sc_hd__fill_1
XFILLER_200_1597 VGND VGND VPWR VPWR sky130_fd_sc_hd__decap_8
XANTENNA__341__A net157 VGND VGND VPWR VPWR sky130_fd_sc_hd__diode_2
XFILLER_192_1365 VGND VGND VPWR VPWR sky130_fd_sc_hd__decap_6
XFILLER_118_1414 VPWR VGND VPWR VGND sky130_ef_sc_hd__decap_12
XFILLER_0_307 VGND VGND VPWR VPWR sky130_fd_sc_hd__fill_1
XFILLER_216_1037 VPWR VGND VPWR VGND sky130_ef_sc_hd__decap_12
XFILLER_157_1496 VGND VGND VPWR VPWR sky130_fd_sc_hd__fill_1
XPHY_EDGE_ROW_9_1_Left_228 VGND VGND VPWR VPWR sky130_fd_sc_hd__decap_3
XFILLER_217_615 VGND VGND VPWR VPWR sky130_fd_sc_hd__fill_1
XFILLER_84_29 VPWR VGND VPWR VGND sky130_ef_sc_hd__decap_12
XFILLER_186_1147 VGND VGND VPWR VPWR sky130_fd_sc_hd__fill_1
XFILLER_213_821 VPWR VGND VPWR VGND sky130_ef_sc_hd__decap_12
XFILLER_204_309 VPWR VGND VPWR VGND sky130_ef_sc_hd__decap_12
XFILLER_129_1510 VPWR VGND VPWR VGND sky130_ef_sc_hd__decap_12
XFILLER_77_1442 VPWR VGND VPWR VGND sky130_ef_sc_hd__decap_12
XFILLER_129_1554 VPWR VGND VPWR VGND sky130_ef_sc_hd__decap_12
XFILLER_73_1328 VGND VGND VPWR VPWR sky130_fd_sc_hd__fill_1
XTAP_TAPCELL_ROW_34_2_3198 VGND VPWR sky130_fd_sc_hd__tapvpwrvgnd_1
XFILLER_38_1426 VPWR VGND VPWR VGND sky130_ef_sc_hd__decap_12
XFILLER_213_865 VPWR VGND VPWR VGND sky130_ef_sc_hd__decap_12
XFILLER_169_279 VGND VGND VPWR VPWR sky130_fd_sc_hd__fill_1
XFILLER_33_55 VGND VGND VPWR VPWR sky130_fd_sc_hd__fill_1
XFILLER_33_77 VGND VGND VPWR VPWR sky130_fd_sc_hd__fill_1
XFILLER_149_55 VGND VGND VPWR VPWR sky130_fd_sc_hd__fill_1
XFILLER_165_441 VGND VGND VPWR VPWR sky130_fd_sc_hd__decap_6
XFILLER_123_3 VPWR VGND VPWR VGND sky130_ef_sc_hd__decap_12
XFILLER_14_1470 VPWR VGND VPWR VGND sky130_ef_sc_hd__decap_12
XFILLER_197_1287 VGND VGND VPWR VPWR sky130_fd_sc_hd__fill_1
XFILLER_193_783 VGND VGND VPWR VPWR sky130_fd_sc_hd__fill_1
XFILLER_181_945 VGND VGND VPWR VPWR sky130_fd_sc_hd__decap_6
XFILLER_180_433 VPWR VGND VPWR VGND sky130_ef_sc_hd__decap_12
XFILLER_165_485 VPWR VGND VPWR VGND sky130_ef_sc_hd__decap_12
XFILLER_101_1440 VGND VGND VPWR VPWR sky130_fd_sc_hd__fill_1
XFILLER_181_989 VPWR VGND VPWR VGND sky130_ef_sc_hd__decap_12
XFILLER_88_1582 VPWR VGND VPWR VGND sky130_ef_sc_hd__decap_12
XFILLER_10_1356 VGND VGND VPWR VPWR sky130_fd_sc_hd__fill_1
XFILLER_49_1522 VPWR VGND VPWR VGND sky130_ef_sc_hd__decap_12
XFILLER_180_477 VPWR VGND VPWR VGND sky130_ef_sc_hd__decap_12
XPHY_EDGE_ROW_116_2_Left_548 VGND VGND VPWR VPWR sky130_fd_sc_hd__decap_3
XFILLER_49_1566 VPWR VGND VPWR VGND sky130_ef_sc_hd__decap_12
XFILLER_171_1449 VGND VGND VPWR VPWR sky130_fd_sc_hd__decap_6
XFILLER_84_1468 VGND VGND VPWR VPWR sky130_fd_sc_hd__fill_1
XFILLER_0_830 VGND VGND VPWR VPWR sky130_fd_sc_hd__decap_3
XANTENNA_input43_A func_wdata[9] VGND VGND VPWR VPWR sky130_fd_sc_hd__diode_2
XFILLER_58_41 VPWR VGND VPWR VGND sky130_ef_sc_hd__decap_12
XFILLER_134_1282 VPWR VGND VPWR VGND sky130_ef_sc_hd__decap_12
XPHY_EDGE_ROW_70_2_Right_127 VGND VGND VPWR VPWR sky130_fd_sc_hd__decap_3
Xhold7 net69 VGND VGND VPWR VPWR net177 sky130_fd_sc_hd__dlygate4sd3_1
XFILLER_58_85 VPWR VGND VPWR VGND sky130_ef_sc_hd__decap_12
XFILLER_208_637 VGND VGND VPWR VPWR sky130_fd_sc_hd__decap_6
XFILLER_207_125 VPWR VGND VPWR VGND sky130_ef_sc_hd__decap_12
XFILLER_169_1301 VPWR VGND VPWR VGND sky130_ef_sc_hd__decap_12
XFILLER_169_1345 VPWR VGND VPWR VGND sky130_ef_sc_hd__decap_12
XFILLER_112_1580 VGND VGND VPWR VPWR sky130_fd_sc_hd__fill_1
XFILLER_1_1513 VPWR VGND VPWR VGND sky130_ef_sc_hd__decap_12
XFILLER_216_681 VPWR VGND VPWR VGND sky130_ef_sc_hd__decap_12
XFILLER_207_169 VPWR VGND VPWR VGND sky130_ef_sc_hd__decap_12
XTAP_TAPCELL_ROW_142_2_3900 VGND VPWR sky130_fd_sc_hd__tapvpwrvgnd_1
XFILLER_21_1496 VGND VGND VPWR VPWR sky130_fd_sc_hd__fill_1
XFILLER_188_533 VPWR VGND VPWR VGND sky130_ef_sc_hd__decap_12
XFILLER_56_1526 VPWR VGND VPWR VGND sky130_ef_sc_hd__decap_12
XFILLER_206_1217 VPWR VGND VPWR VGND sky130_ef_sc_hd__decap_12
XFILLER_200_27 VGND VGND VPWR VPWR sky130_fd_sc_hd__fill_1
Xu_sram.u_mem_167 VGND VGND VPWR VPWR net167 u_sram.u_mem_167/LO sky130_fd_sc_hd__conb_1
XPHY_EDGE_ROW_8_1_Left_439 VGND VGND VPWR VPWR sky130_fd_sc_hd__decap_3
XFILLER_182_1589 VGND VGND VPWR VPWR sky130_fd_sc_hd__decap_6
XFILLER_175_205 VPWR VGND VPWR VGND sky130_ef_sc_hd__decap_12
XFILLER_198_1029 VGND VGND VPWR VPWR sky130_fd_sc_hd__decap_6
XFILLER_191_709 VPWR VGND VPWR VGND sky130_ef_sc_hd__decap_12
XFILLER_175_249 VPWR VGND VPWR VGND sky130_ef_sc_hd__decap_12
XFILLER_141_1220 VPWR VGND VPWR VGND sky130_ef_sc_hd__decap_12
XFILLER_128_121 VGND VGND VPWR VPWR sky130_fd_sc_hd__decap_6
XFILLER_90_83 VGND VGND VPWR VPWR sky130_fd_sc_hd__fill_1
XTAP_TAPCELL_ROW_78_2_3485 VGND VPWR sky130_fd_sc_hd__tapvpwrvgnd_1
XFILLER_15_1256 VPWR VGND VPWR VGND sky130_ef_sc_hd__decap_12
XFILLER_54_1294 VGND VGND VPWR VPWR sky130_fd_sc_hd__decap_6
XFILLER_141_1286 VPWR VGND VPWR VGND sky130_ef_sc_hd__decap_12
XTAP_TAPCELL_ROW_15_1_1048 VGND VPWR sky130_fd_sc_hd__tapvpwrvgnd_1
XFILLER_209_69 VPWR VGND VPWR VGND sky130_ef_sc_hd__decap_12
XFILLER_172_923 VGND VGND VPWR VPWR sky130_fd_sc_hd__fill_1
XFILLER_143_113 VPWR VGND VPWR VGND sky130_ef_sc_hd__decap_12
XFILLER_7_473 VGND VGND VPWR VPWR sky130_fd_sc_hd__decap_3
XFILLER_183_293 VPWR VGND VPWR VGND sky130_ef_sc_hd__decap_12
XFILLER_99_81 VPWR VGND VPWR VGND sky130_ef_sc_hd__decap_12
XFILLER_217_1313 VPWR VGND VPWR VGND sky130_ef_sc_hd__decap_12
XTAP_TAPCELL_ROW_77_1_1171 VGND VPWR sky130_fd_sc_hd__tapvpwrvgnd_1
XFILLER_217_1357 VPWR VGND VPWR VGND sky130_ef_sc_hd__decap_12
XFILLER_174_1073 VPWR VGND VPWR VGND sky130_ef_sc_hd__decap_12
XTAP_TAPCELL_ROW_71_2_3439 VGND VPWR sky130_fd_sc_hd__tapvpwrvgnd_1
XFILLER_61_1232 VPWR VGND VPWR VGND sky130_ef_sc_hd__decap_12
XFILLER_152_1382 VPWR VGND VPWR VGND sky130_ef_sc_hd__decap_12
XFILLER_113_1322 VGND VGND VPWR VPWR sky130_fd_sc_hd__decap_6
XFILLER_187_1401 VPWR VGND VPWR VGND sky130_ef_sc_hd__decap_12
XFILLER_113_1366 VPWR VGND VPWR VGND sky130_ef_sc_hd__decap_12
XFILLER_61_1298 VPWR VGND VPWR VGND sky130_ef_sc_hd__decap_12
XFILLER_199_809 VPWR VGND VPWR VGND sky130_ef_sc_hd__decap_12
XPHY_EDGE_ROW_162_2_Left_594 VGND VGND VPWR VPWR sky130_fd_sc_hd__decap_3
XTAP_TAPCELL_ROW_70_1_1158 VGND VPWR sky130_fd_sc_hd__tapvpwrvgnd_1
XFILLER_210_813 VPWR VGND VPWR VGND sky130_ef_sc_hd__decap_12
XFILLER_181_1033 VPWR VGND VPWR VGND sky130_ef_sc_hd__decap_12
XFILLER_110_27 VGND VGND VPWR VPWR sky130_fd_sc_hd__fill_1
XFILLER_0_1089 VGND VGND VPWR VPWR sky130_fd_sc_hd__decap_3
XFILLER_194_525 VGND VGND VPWR VPWR sky130_fd_sc_hd__decap_6
XFILLER_181_1077 VPWR VGND VPWR VGND sky130_ef_sc_hd__decap_12
XFILLER_72_1350 VGND VGND VPWR VPWR sky130_fd_sc_hd__decap_6
XFILLER_124_1462 VGND VGND VPWR VPWR sky130_fd_sc_hd__decap_6
XFILLER_72_1394 VPWR VGND VPWR VGND sky130_ef_sc_hd__decap_12
XFILLER_198_1541 VPWR VGND VPWR VGND sky130_ef_sc_hd__decap_12
XFILLER_194_569 VPWR VGND VPWR VGND sky130_ef_sc_hd__decap_12
XFILLER_120_1326 VPWR VGND VPWR VGND sky130_ef_sc_hd__decap_12
XFILLER_33_1378 VGND VGND VPWR VPWR sky130_fd_sc_hd__decap_6
XFILLER_175_783 VGND VGND VPWR VPWR sky130_fd_sc_hd__fill_1
XFILLER_119_69 VPWR VGND VPWR VGND sky130_ef_sc_hd__decap_12
XFILLER_194_1427 VGND VGND VPWR VPWR sky130_fd_sc_hd__fill_1
XFILLER_192_1173 VPWR VGND VPWR VGND sky130_ef_sc_hd__decap_12
XFILLER_118_1244 VGND VGND VPWR VPWR sky130_fd_sc_hd__fill_1
XFILLER_135_57 VPWR VGND VPWR VGND sky130_ef_sc_hd__decap_12
XFILLER_95_39 VPWR VGND VPWR VGND sky130_ef_sc_hd__decap_12
XFILLER_83_1490 VGND VGND VPWR VPWR sky130_fd_sc_hd__decap_6
XTAP_TAPCELL_ROW_5_922 VGND VPWR sky130_fd_sc_hd__tapvpwrvgnd_1
XTAP_TAPCELL_ROW_5_933 VGND VPWR sky130_fd_sc_hd__tapvpwrvgnd_1
XFILLER_131_1422 VPWR VGND VPWR VGND sky130_ef_sc_hd__decap_12
XTAP_TAPCELL_ROW_5_944 VGND VPWR sky130_fd_sc_hd__tapvpwrvgnd_1
XFILLER_40_1338 VPWR VGND VPWR VGND sky130_ef_sc_hd__decap_12
XFILLER_218_979 VGND VGND VPWR VPWR sky130_fd_sc_hd__fill_1
XFILLER_131_1466 VPWR VGND VPWR VGND sky130_ef_sc_hd__decap_12
X_560_ net55 u_ctrl.cmp_addr\[6\] net122 VGND VGND VPWR VPWR _254_ sky130_fd_sc_hd__mux2_1
XFILLER_205_629 VPWR VGND VPWR VGND sky130_ef_sc_hd__decap_12
XTAP_TAPCELL_ROW_127_2_3802 VGND VPWR sky130_fd_sc_hd__tapvpwrvgnd_1
XFILLER_71_111 VGND VGND VPWR VPWR sky130_fd_sc_hd__fill_1
XFILLER_204_139 VGND VGND VPWR VPWR sky130_fd_sc_hd__fill_1
XFILLER_77_1272 VGND VGND VPWR VPWR sky130_fd_sc_hd__fill_1
X_491_ net149 _178_ net127 net135 _219_ VGND VGND VPWR VPWR _029_ sky130_fd_sc_hd__o311a_1
XFILLER_38_1223 VPWR VGND VPWR VGND sky130_ef_sc_hd__decap_12
XFILLER_213_673 VPWR VGND VPWR VGND sky130_ef_sc_hd__decap_12
XFILLER_207_1537 VPWR VGND VPWR VGND sky130_ef_sc_hd__decap_12
XFILLER_164_1253 VGND VGND VPWR VPWR sky130_fd_sc_hd__decap_6
XFILLER_44_65 VPWR VGND VPWR VGND sky130_ef_sc_hd__decap_12
XFILLER_200_301 VGND VGND VPWR VPWR sky130_fd_sc_hd__decap_6
XFILLER_185_503 VGND VGND VPWR VPWR sky130_fd_sc_hd__fill_1
XFILLER_164_1297 VPWR VGND VPWR VGND sky130_ef_sc_hd__decap_12
XFILLER_129_1384 VGND VGND VPWR VPWR sky130_fd_sc_hd__fill_1
XFILLER_90_1450 VPWR VGND VPWR VGND sky130_ef_sc_hd__decap_12
XTAP_TAPCELL_ROW_64_2_3393 VGND VPWR sky130_fd_sc_hd__tapvpwrvgnd_1
XFILLER_200_345 VPWR VGND VPWR VGND sky130_ef_sc_hd__decap_12
XFILLER_197_385 VGND VGND VPWR VPWR sky130_fd_sc_hd__decap_6
XTAP_TAPCELL_ROW_195_2291 VGND VPWR sky130_fd_sc_hd__tapvpwrvgnd_1
XFILLER_51_1434 VGND VGND VPWR VPWR sky130_fd_sc_hd__decap_6
XFILLER_200_389 VPWR VGND VPWR VGND sky130_ef_sc_hd__decap_12
XTAP_TAPCELL_ROW_191_2177 VGND VPWR sky130_fd_sc_hd__tapvpwrvgnd_1
XFILLER_173_709 VPWR VGND VPWR VGND sky130_ef_sc_hd__decap_12
XFILLER_142_1562 VPWR VGND VPWR VGND sky130_ef_sc_hd__decap_12
XFILLER_90_1494 VPWR VGND VPWR VGND sky130_ef_sc_hd__decap_12
XFILLER_51_1478 VPWR VGND VPWR VGND sky130_ef_sc_hd__decap_12
XFILLER_60_53 VPWR VGND VPWR VGND sky130_ef_sc_hd__decap_12
XTAP_TAPCELL_ROW_216_2895 VGND VPWR sky130_fd_sc_hd__tapvpwrvgnd_1
XTAP_TAPCELL_ROW_216_2884 VGND VPWR sky130_fd_sc_hd__tapvpwrvgnd_1
XFILLER_201_1169 VGND VGND VPWR VPWR sky130_fd_sc_hd__decap_6
XTAP_TAPCELL_ROW_191_2188 VGND VPWR sky130_fd_sc_hd__tapvpwrvgnd_1
XFILLER_176_53 VPWR VGND VPWR VGND sky130_ef_sc_hd__decap_12
XFILLER_125_113 VPWR VGND VPWR VGND sky130_ef_sc_hd__decap_12
XFILLER_103_1546 VGND VGND VPWR VPWR sky130_fd_sc_hd__decap_6
XFILLER_60_97 VPWR VGND VPWR VGND sky130_ef_sc_hd__decap_12
XFILLER_181_753 VPWR VGND VPWR VGND sky130_ef_sc_hd__decap_12
XFILLER_176_97 VPWR VGND VPWR VGND sky130_ef_sc_hd__decap_12
XFILLER_165_293 VPWR VGND VPWR VGND sky130_ef_sc_hd__decap_12
XFILLER_5_15 VPWR VGND VPWR VGND sky130_ef_sc_hd__decap_12
XFILLER_4_421 VGND VGND VPWR VPWR sky130_fd_sc_hd__fill_1
XFILLER_181_797 VPWR VGND VPWR VGND sky130_ef_sc_hd__decap_12
XFILLER_136_1300 VGND VGND VPWR VPWR sky130_fd_sc_hd__fill_1
XFILLER_84_1232 VPWR VGND VPWR VGND sky130_ef_sc_hd__decap_12
XFILLER_5_977 VPWR VGND VPWR VGND sky130_ef_sc_hd__decap_12
XFILLER_49_1330 VPWR VGND VPWR VGND sky130_ef_sc_hd__decap_12
XFILLER_192_41 VPWR VGND VPWR VGND sky130_ef_sc_hd__decap_12
XFILLER_171_1213 VPWR VGND VPWR VGND sky130_ef_sc_hd__decap_12
XPHY_EDGE_ROW_158_1_Left_377 VGND VGND VPWR VPWR sky130_fd_sc_hd__decap_3
XFILLER_69_51 VGND VGND VPWR VPWR sky130_fd_sc_hd__decap_4
XPHY_EDGE_ROW_194_Right_39 VGND VGND VPWR VPWR sky130_fd_sc_hd__decap_3
XFILLER_192_85 VPWR VGND VPWR VGND sky130_ef_sc_hd__decap_12
XFILLER_175_1393 VGND VGND VPWR VPWR sky130_fd_sc_hd__decap_6
XFILLER_171_1257 VPWR VGND VPWR VGND sky130_ef_sc_hd__decap_12
XPHY_EDGE_ROW_95_1_Left_314 VGND VGND VPWR VPWR sky130_fd_sc_hd__decap_3
XFILLER_0_682 VGND VGND VPWR VPWR sky130_fd_sc_hd__decap_4
XFILLER_208_401 VPWR VGND VPWR VGND sky130_ef_sc_hd__decap_12
XFILLER_110_1506 VPWR VGND VPWR VGND sky130_ef_sc_hd__decap_12
XFILLER_62_1574 VGND VGND VPWR VPWR sky130_fd_sc_hd__decap_6
XFILLER_208_445 VPWR VGND VPWR VGND sky130_ef_sc_hd__decap_12
XPHY_EDGE_ROW_71_2_Right_128 VGND VGND VPWR VPWR sky130_fd_sc_hd__decap_3
XFILLER_211_15 VPWR VGND VPWR VGND sky130_ef_sc_hd__decap_12
XFILLER_208_489 VPWR VGND VPWR VGND sky130_ef_sc_hd__decap_12
XFILLER_169_1175 VGND VGND VPWR VPWR sky130_fd_sc_hd__fill_1
XFILLER_1_1343 VGND VGND VPWR VPWR sky130_fd_sc_hd__fill_1
XTAP_TAPCELL_ROW_180_1881 VGND VPWR sky130_fd_sc_hd__tapvpwrvgnd_1
XTAP_TAPCELL_ROW_180_1870 VGND VPWR sky130_fd_sc_hd__tapvpwrvgnd_1
XANTENNA__378__A1 b_addr\[0\] VGND VGND VPWR VPWR sky130_fd_sc_hd__diode_2
XFILLER_210_109 VPWR VGND VPWR VGND sky130_ef_sc_hd__decap_12
XFILLER_189_853 VPWR VGND VPWR VGND sky130_ef_sc_hd__decap_12
XFILLER_182_1353 VPWR VGND VPWR VGND sky130_ef_sc_hd__decap_12
XFILLER_147_1440 VGND VGND VPWR VPWR sky130_fd_sc_hd__fill_1
XFILLER_56_1356 VGND VGND VPWR VPWR sky130_fd_sc_hd__fill_1
XFILLER_203_161 VGND VGND VPWR VPWR sky130_fd_sc_hd__decap_6
XFILLER_189_897 VPWR VGND VPWR VGND sky130_ef_sc_hd__decap_12
XFILLER_188_363 VGND VGND VPWR VPWR sky130_fd_sc_hd__fill_1
XFILLER_182_1397 VPWR VGND VPWR VGND sky130_ef_sc_hd__decap_12
XFILLER_176_525 VGND VGND VPWR VPWR sky130_fd_sc_hd__decap_6
XFILLER_108_1468 VGND VGND VPWR VPWR sky130_fd_sc_hd__fill_1
XFILLER_86_3 VPWR VGND VPWR VGND sky130_ef_sc_hd__decap_12
XFILLER_191_517 VPWR VGND VPWR VGND sky130_ef_sc_hd__decap_12
XFILLER_176_569 VPWR VGND VPWR VGND sky130_ef_sc_hd__decap_12
XFILLER_121_1602 VGND VGND VPWR VPWR sky130_fd_sc_hd__decap_3
XFILLER_30_1518 VGND VGND VPWR VPWR sky130_fd_sc_hd__decap_6
XTAP_TAPCELL_ROW_46_1_1109 VGND VPWR sky130_fd_sc_hd__tapvpwrvgnd_1
XTAP_TAPCELL_ROW_174_1685 VGND VPWR sky130_fd_sc_hd__tapvpwrvgnd_1
XTAP_TAPCELL_ROW_174_1696 VGND VPWR sky130_fd_sc_hd__tapvpwrvgnd_1
XFILLER_7_281 VGND VGND VPWR VPWR sky130_fd_sc_hd__fill_1
XFILLER_131_105 VGND VGND VPWR VPWR sky130_fd_sc_hd__decap_6
XFILLER_217_1121 VPWR VGND VPWR VGND sky130_ef_sc_hd__decap_12
XFILLER_158_1580 VGND VGND VPWR VPWR sky130_fd_sc_hd__fill_1
XFILLER_28_1414 VPWR VGND VPWR VGND sky130_ef_sc_hd__decap_12
XFILLER_213_1007 VGND VGND VPWR VPWR sky130_fd_sc_hd__fill_1
XFILLER_193_1493 VPWR VGND VPWR VGND sky130_ef_sc_hd__decap_12
XTAP_TAPCELL_ROW_133_2_3845 VGND VPWR sky130_fd_sc_hd__tapvpwrvgnd_1
XFILLER_67_1496 VGND VGND VPWR VPWR sky130_fd_sc_hd__fill_1
XFILLER_218_209 VPWR VGND VPWR VGND sky130_ef_sc_hd__decap_12
XFILLER_105_27 VPWR VGND VPWR VGND sky130_ef_sc_hd__decap_12
XFILLER_187_1231 VGND VGND VPWR VPWR sky130_fd_sc_hd__fill_1
XTAP_TAPCELL_ROW_113_2_3710 VGND VPWR sky130_fd_sc_hd__tapvpwrvgnd_1
XFILLER_2_1129 VPWR VGND VPWR VGND sky130_ef_sc_hd__decap_12
XFILLER_199_617 VPWR VGND VPWR VGND sky130_ef_sc_hd__decap_12
XFILLER_121_15 VPWR VGND VPWR VGND sky130_ef_sc_hd__decap_12
XFILLER_53_111 VGND VGND VPWR VPWR sky130_fd_sc_hd__fill_1
XFILLER_74_1412 VGND VGND VPWR VPWR sky130_fd_sc_hd__fill_1
XFILLER_39_1510 VPWR VGND VPWR VGND sky130_ef_sc_hd__decap_12
XFILLER_39_1554 VPWR VGND VPWR VGND sky130_ef_sc_hd__decap_12
XFILLER_201_81 VPWR VGND VPWR VGND sky130_ef_sc_hd__decap_12
XFILLER_167_503 VGND VGND VPWR VPWR sky130_fd_sc_hd__fill_1
XFILLER_126_1524 VGND VGND VPWR VPWR sky130_fd_sc_hd__fill_1
XTAP_TAPCELL_ROW_49_2_3295 VGND VPWR sky130_fd_sc_hd__tapvpwrvgnd_1
XFILLER_210_643 VGND VGND VPWR VPWR sky130_fd_sc_hd__fill_1
XFILLER_194_333 VPWR VGND VPWR VGND sky130_ef_sc_hd__decap_12
XFILLER_179_385 VGND VGND VPWR VPWR sky130_fd_sc_hd__decap_6
XFILLER_195_889 VGND VGND VPWR VPWR sky130_fd_sc_hd__decap_6
XFILLER_124_1270 VPWR VGND VPWR VGND sky130_ef_sc_hd__decap_12
XFILLER_194_377 VPWR VGND VPWR VGND sky130_ef_sc_hd__decap_12
XFILLER_198_1371 VGND VGND VPWR VPWR sky130_fd_sc_hd__fill_1
XFILLER_163_753 VGND VGND VPWR VPWR sky130_fd_sc_hd__decap_3
XFILLER_159_1322 VGND VGND VPWR VPWR sky130_fd_sc_hd__decap_6
XFILLER_107_113 VPWR VGND VPWR VGND sky130_ef_sc_hd__decap_12
XFILLER_11_1440 VGND VGND VPWR VPWR sky130_fd_sc_hd__fill_1
XTAP_TAPCELL_ROW_42_2_3249 VGND VPWR sky130_fd_sc_hd__tapvpwrvgnd_1
XFILLER_163_797 VPWR VGND VPWR VGND sky130_ef_sc_hd__decap_12
XFILLER_159_1366 VPWR VGND VPWR VGND sky130_ef_sc_hd__decap_12
XFILLER_85_1552 VGND VGND VPWR VPWR sky130_fd_sc_hd__fill_1
XFILLER_172_1533 VGND VGND VPWR VPWR sky130_fd_sc_hd__decap_6
XFILLER_2_969 VGND VGND VPWR VPWR sky130_fd_sc_hd__decap_8
XFILLER_1_446 VGND VGND VPWR VPWR sky130_fd_sc_hd__fill_2
XFILLER_172_1577 VPWR VGND VPWR VGND sky130_ef_sc_hd__decap_12
XFILLER_190_3 VPWR VGND VPWR VGND sky130_ef_sc_hd__decap_12
XFILLER_188_1017 VPWR VGND VPWR VGND sky130_ef_sc_hd__decap_12
XFILLER_162_77 VGND VGND VPWR VPWR sky130_fd_sc_hd__decap_6
XFILLER_44_1282 VPWR VGND VPWR VGND sky130_ef_sc_hd__decap_12
XFILLER_206_905 VPWR VGND VPWR VGND sky130_ef_sc_hd__decap_12
XFILLER_131_1274 VPWR VGND VPWR VGND sky130_ef_sc_hd__decap_12
X_612_ clknet_3_5_0_clk _046_ VGND VGND VPWR VPWR net69 sky130_fd_sc_hd__dfxtp_1
XFILLER_55_20 VPWR VGND VPWR VGND sky130_ef_sc_hd__decap_12
XTAP_TAPCELL_ROW_205_2574 VGND VPWR sky130_fd_sc_hd__tapvpwrvgnd_1
XFILLER_166_1315 VGND VGND VPWR VPWR sky130_fd_sc_hd__fill_1
XFILLER_22_1580 VGND VGND VPWR VPWR sky130_fd_sc_hd__fill_1
XTAP_TAPCELL_ROW_39_1_1096 VGND VPWR sky130_fd_sc_hd__tapvpwrvgnd_1
XFILLER_206_949 VPWR VGND VPWR VGND sky130_ef_sc_hd__decap_12
XTAP_TAPCELL_ROW_205_2596 VGND VPWR sky130_fd_sc_hd__tapvpwrvgnd_1
XTAP_TAPCELL_ROW_205_2585 VGND VPWR sky130_fd_sc_hd__tapvpwrvgnd_1
XFILLER_189_105 VGND VGND VPWR VPWR sky130_fd_sc_hd__decap_6
XFILLER_79_1378 VGND VGND VPWR VPWR sky130_fd_sc_hd__decap_6
X_543_ net150 _198_ net129 net137 _245_ VGND VGND VPWR VPWR _055_ sky130_fd_sc_hd__o311a_1
XFILLER_207_1301 VPWR VGND VPWR VGND sky130_ef_sc_hd__decap_12
XTAP_TAPCELL_ROW_197_2364 VGND VPWR sky130_fd_sc_hd__tapvpwrvgnd_1
XTAP_TAPCELL_ROW_197_2353 VGND VPWR sky130_fd_sc_hd__tapvpwrvgnd_1
XTAP_TAPCELL_ROW_197_2342 VGND VPWR sky130_fd_sc_hd__tapvpwrvgnd_1
XFILLER_189_149 VPWR VGND VPWR VGND sky130_ef_sc_hd__decap_12
XFILLER_144_1602 VGND VGND VPWR VPWR sky130_fd_sc_hd__decap_3
X_474_ _173_ _187_ _198_ _200_ VGND VGND VPWR VPWR _206_ sky130_fd_sc_hd__or4_1
XFILLER_214_993 VPWR VGND VPWR VGND sky130_ef_sc_hd__decap_12
XFILLER_207_1345 VPWR VGND VPWR VGND sky130_ef_sc_hd__decap_12
XTAP_TAPCELL_ROW_193_2239 VGND VPWR sky130_fd_sc_hd__tapvpwrvgnd_1
XTAP_TAPCELL_ROW_193_2228 VGND VPWR sky130_fd_sc_hd__tapvpwrvgnd_1
XFILLER_164_1061 VPWR VGND VPWR VGND sky130_ef_sc_hd__decap_12
XFILLER_111_81 VPWR VGND VPWR VGND sky130_ef_sc_hd__decap_12
XTAP_TAPCELL_ROW_218_2946 VGND VPWR sky130_fd_sc_hd__tapvpwrvgnd_1
XFILLER_199_1113 VGND VGND VPWR VPWR sky130_fd_sc_hd__decap_6
XFILLER_197_193 VPWR VGND VPWR VGND sky130_ef_sc_hd__decap_12
XTAP_TAPCELL_ROW_218_2957 VGND VPWR sky130_fd_sc_hd__tapvpwrvgnd_1
XFILLER_201_665 VGND VGND VPWR VPWR sky130_fd_sc_hd__decap_6
XFILLER_200_153 VPWR VGND VPWR VGND sky130_ef_sc_hd__decap_12
XFILLER_186_867 VGND VGND VPWR VPWR sky130_fd_sc_hd__fill_1
XFILLER_103_1310 VPWR VGND VPWR VGND sky130_ef_sc_hd__decap_12
XFILLER_51_1220 VPWR VGND VPWR VGND sky130_ef_sc_hd__decap_12
XFILLER_200_197 VPWR VGND VPWR VGND sky130_ef_sc_hd__decap_12
XFILLER_199_1157 VPWR VGND VPWR VGND sky130_ef_sc_hd__decap_12
XFILLER_173_517 VPWR VGND VPWR VGND sky130_ef_sc_hd__decap_12
XFILLER_142_1370 VPWR VGND VPWR VGND sky130_ef_sc_hd__decap_12
XFILLER_107_1490 VGND VGND VPWR VPWR sky130_fd_sc_hd__decap_6
XFILLER_103_1354 VPWR VGND VPWR VGND sky130_ef_sc_hd__decap_12
XFILLER_51_1286 VPWR VGND VPWR VGND sky130_ef_sc_hd__decap_12
XFILLER_181_561 VPWR VGND VPWR VGND sky130_ef_sc_hd__decap_12
XFILLER_177_1455 VGND VGND VPWR VPWR sky130_fd_sc_hd__fill_1
XFILLER_138_1406 VGND VGND VPWR VPWR sky130_fd_sc_hd__decap_6
XFILLER_103_1398 VPWR VGND VPWR VGND sky130_ef_sc_hd__decap_12
XFILLER_86_1338 VPWR VGND VPWR VGND sky130_ef_sc_hd__decap_12
XFILLER_5_774 VGND VGND VPWR VPWR sky130_fd_sc_hd__decap_3
XFILLER_218_1441 VPWR VGND VPWR VGND sky130_ef_sc_hd__decap_12
XFILLER_206_15 VPWR VGND VPWR VGND sky130_ef_sc_hd__decap_12
XTAP_TAPCELL_ROW_118_2_3747 VGND VPWR sky130_fd_sc_hd__tapvpwrvgnd_1
XFILLER_113_105 VGND VGND VPWR VPWR sky130_fd_sc_hd__decap_6
XFILLER_5_785 VPWR VGND VPWR VGND sky130_ef_sc_hd__decap_12
XFILLER_218_1485 VPWR VGND VPWR VGND sky130_ef_sc_hd__decap_12
XFILLER_171_1021 VPWR VGND VPWR VGND sky130_ef_sc_hd__decap_12
XFILLER_171_1065 VPWR VGND VPWR VGND sky130_ef_sc_hd__decap_12
XTAP_TAPCELL_ROW_86_2_3536 VGND VPWR sky130_fd_sc_hd__tapvpwrvgnd_1
XFILLER_209_721 VGND VGND VPWR VPWR sky130_fd_sc_hd__decap_6
XFILLER_7_1541 VPWR VGND VPWR VGND sky130_ef_sc_hd__decap_12
XFILLER_23_1322 VGND VGND VPWR VPWR sky130_fd_sc_hd__decap_6
XFILLER_62_1382 VPWR VGND VPWR VGND sky130_ef_sc_hd__decap_12
XFILLER_212_1073 VPWR VGND VPWR VGND sky130_ef_sc_hd__decap_12
XTAP_TAPCELL_ROW_182_1932 VGND VPWR sky130_fd_sc_hd__tapvpwrvgnd_1
XTAP_TAPCELL_ROW_182_1921 VGND VPWR sky130_fd_sc_hd__tapvpwrvgnd_1
XFILLER_114_1450 VPWR VGND VPWR VGND sky130_ef_sc_hd__decap_12
XFILLER_110_1314 VPWR VGND VPWR VGND sky130_ef_sc_hd__decap_12
XFILLER_23_1366 VPWR VGND VPWR VGND sky130_ef_sc_hd__decap_12
XFILLER_209_765 VPWR VGND VPWR VGND sky130_ef_sc_hd__decap_12
XFILLER_208_253 VPWR VGND VPWR VGND sky130_ef_sc_hd__decap_12
XTAP_TAPCELL_ROW_163_1364 VGND VPWR sky130_fd_sc_hd__tapvpwrvgnd_1
XTAP_TAPCELL_ROW_163_1353 VGND VPWR sky130_fd_sc_hd__tapvpwrvgnd_1
XFILLER_114_1494 VPWR VGND VPWR VGND sky130_ef_sc_hd__decap_12
XFILLER_97_1434 VGND VGND VPWR VPWR sky130_fd_sc_hd__decap_6
XPHY_EDGE_ROW_72_2_Right_129 VGND VGND VPWR VPWR sky130_fd_sc_hd__decap_3
XFILLER_3_1449 VGND VGND VPWR VPWR sky130_fd_sc_hd__decap_6
XFILLER_188_1595 VGND VGND VPWR VPWR sky130_fd_sc_hd__fill_1
XTAP_TAPCELL_ROW_163_1397 VGND VPWR sky130_fd_sc_hd__tapvpwrvgnd_1
XTAP_TAPCELL_ROW_163_1386 VGND VPWR sky130_fd_sc_hd__tapvpwrvgnd_1
XTAP_TAPCELL_ROW_163_1375 VGND VPWR sky130_fd_sc_hd__tapvpwrvgnd_1
XFILLER_149_1546 VGND VGND VPWR VPWR sky130_fd_sc_hd__decap_6
XFILLER_110_1358 VPWR VGND VPWR VGND sky130_ef_sc_hd__decap_12
XFILLER_97_1478 VPWR VGND VPWR VGND sky130_ef_sc_hd__decap_12
XFILLER_211_429 VPWR VGND VPWR VGND sky130_ef_sc_hd__decap_12
XFILLER_182_1161 VPWR VGND VPWR VGND sky130_ef_sc_hd__decap_12
XFILLER_108_1232 VPWR VGND VPWR VGND sky130_ef_sc_hd__decap_12
XANTENNA_clkbuf_0_clk_X clknet_0_clk VGND VGND VPWR VPWR sky130_fd_sc_hd__diode_2
XFILLER_177_889 VGND VGND VPWR VPWR sky130_fd_sc_hd__decap_6
XTAP_TAPCELL_ROW_176_1769 VGND VPWR sky130_fd_sc_hd__tapvpwrvgnd_1
XTAP_TAPCELL_ROW_176_1758 VGND VPWR sky130_fd_sc_hd__tapvpwrvgnd_1
XFILLER_176_333 VPWR VGND VPWR VGND sky130_ef_sc_hd__decap_12
XTAP_TAPCELL_ROW_176_1747 VGND VPWR sky130_fd_sc_hd__tapvpwrvgnd_1
XFILLER_121_1410 VPWR VGND VPWR VGND sky130_ef_sc_hd__decap_12
XFILLER_34_1462 VGND VGND VPWR VPWR sky130_fd_sc_hd__decap_6
XFILLER_192_837 VPWR VGND VPWR VGND sky130_ef_sc_hd__decap_12
XFILLER_176_377 VPWR VGND VPWR VGND sky130_ef_sc_hd__decap_12
XFILLER_160_1470 VPWR VGND VPWR VGND sky130_ef_sc_hd__decap_12
XFILLER_125_1590 VPWR VGND VPWR VGND sky130_ef_sc_hd__decap_12
XFILLER_30_1326 VPWR VGND VPWR VGND sky130_ef_sc_hd__decap_12
XFILLER_195_1511 VGND VGND VPWR VPWR sky130_fd_sc_hd__fill_1
XFILLER_121_1454 VPWR VGND VPWR VGND sky130_ef_sc_hd__decap_12
XFILLER_219_1205 VPWR VGND VPWR VGND sky130_ef_sc_hd__decap_12
XFILLER_156_1506 VPWR VGND VPWR VGND sky130_ef_sc_hd__decap_12
XFILLER_121_1498 VPWR VGND VPWR VGND sky130_ef_sc_hd__decap_12
XFILLER_116_15 VPWR VGND VPWR VGND sky130_ef_sc_hd__decap_12
XFILLER_28_1244 VGND VGND VPWR VPWR sky130_fd_sc_hd__fill_1
XFILLER_8_1338 VPWR VGND VPWR VGND sky130_ef_sc_hd__decap_12
XFILLER_219_529 VGND VGND VPWR VPWR sky130_fd_sc_hd__decap_3
XFILLER_41_1422 VPWR VGND VPWR VGND sky130_ef_sc_hd__decap_12
XFILLER_189_1337 VGND VGND VPWR VPWR sky130_fd_sc_hd__decap_6
XFILLER_132_1550 VPWR VGND VPWR VGND sky130_ef_sc_hd__decap_12
XFILLER_80_1482 VPWR VGND VPWR VGND sky130_ef_sc_hd__decap_12
XFILLER_6_1073 VPWR VGND VPWR VGND sky130_ef_sc_hd__decap_12
XFILLER_132_1594 VGND VGND VPWR VPWR sky130_fd_sc_hd__decap_8
XFILLER_41_1466 VPWR VGND VPWR VGND sky130_ef_sc_hd__decap_12
XFILLER_92_29 VPWR VGND VPWR VGND sky130_ef_sc_hd__decap_12
XFILLER_76_1518 VGND VGND VPWR VPWR sky130_fd_sc_hd__decap_6
XFILLER_214_245 VGND VGND VPWR VPWR sky130_fd_sc_hd__decap_6
XFILLER_199_447 VGND VGND VPWR VPWR sky130_fd_sc_hd__fill_1
XFILLER_74_1220 VPWR VGND VPWR VGND sky130_ef_sc_hd__decap_12
XFILLER_25_23 VGND VGND VPWR VPWR sky130_fd_sc_hd__fill_1
XFILLER_214_289 VPWR VGND VPWR VGND sky130_ef_sc_hd__decap_12
XFILLER_187_609 VGND VGND VPWR VPWR sky130_fd_sc_hd__decap_6
XFILLER_41_125 VGND VGND VPWR VPWR sky130_fd_sc_hd__fill_2
XFILLER_165_1381 VPWR VGND VPWR VGND sky130_ef_sc_hd__decap_12
XPHY_EDGE_ROW_125_2_Left_557 VGND VGND VPWR VPWR sky130_fd_sc_hd__decap_3
XFILLER_39_1384 VGND VGND VPWR VPWR sky130_fd_sc_hd__fill_1
XFILLER_195_653 VPWR VGND VPWR VGND sky130_ef_sc_hd__decap_12
XFILLER_194_141 VPWR VGND VPWR VGND sky130_ef_sc_hd__decap_12
XFILLER_179_193 VPWR VGND VPWR VGND sky130_ef_sc_hd__decap_12
XFILLER_168_867 VGND VGND VPWR VPWR sky130_fd_sc_hd__fill_1
XFILLER_161_1256 VPWR VGND VPWR VGND sky130_ef_sc_hd__decap_12
XTAP_TAPCELL_ROW_79_2_3490 VGND VPWR sky130_fd_sc_hd__tapvpwrvgnd_1
XFILLER_202_1253 VGND VGND VPWR VPWR sky130_fd_sc_hd__decap_6
XFILLER_195_697 VPWR VGND VPWR VGND sky130_ef_sc_hd__decap_12
XFILLER_41_55 VGND VGND VPWR VPWR sky130_fd_sc_hd__fill_1
XFILLER_52_1562 VPWR VGND VPWR VGND sky130_ef_sc_hd__decap_12
XTAP_TAPCELL_ROW_213_2821 VGND VPWR sky130_fd_sc_hd__tapvpwrvgnd_1
XTAP_TAPCELL_ROW_213_2810 VGND VPWR sky130_fd_sc_hd__tapvpwrvgnd_1
XFILLER_157_55 VGND VGND VPWR VPWR sky130_fd_sc_hd__fill_1
XTAP_TAPCELL_ROW_92_2_3579 VGND VPWR sky130_fd_sc_hd__tapvpwrvgnd_1
XFILLER_13_1546 VGND VGND VPWR VPWR sky130_fd_sc_hd__decap_6
XFILLER_202_1297 VPWR VGND VPWR VGND sky130_ef_sc_hd__decap_12
XFILLER_203_3 VPWR VGND VPWR VGND sky130_ef_sc_hd__decap_12
XFILLER_163_561 VPWR VGND VPWR VGND sky130_ef_sc_hd__decap_12
XTAP_TAPCELL_ROW_104_2_3655 VGND VPWR sky130_fd_sc_hd__tapvpwrvgnd_1
XFILLER_100_1538 VPWR VGND VPWR VGND sky130_ef_sc_hd__decap_12
XFILLER_46_1300 VGND VGND VPWR VPWR sky130_fd_sc_hd__fill_1
XTAP_TAPCELL_ROW_186_2043 VGND VPWR sky130_fd_sc_hd__tapvpwrvgnd_1
XTAP_TAPCELL_ROW_186_2032 VGND VPWR sky130_fd_sc_hd__tapvpwrvgnd_1
XTAP_TAPCELL_ROW_72_2_3444 VGND VPWR sky130_fd_sc_hd__tapvpwrvgnd_1
XTAP_TAPCELL_ROW_186_2054 VGND VPWR sky130_fd_sc_hd__tapvpwrvgnd_1
XFILLER_172_1341 VPWR VGND VPWR VGND sky130_ef_sc_hd__decap_12
XFILLER_1_276 VGND VGND VPWR VPWR sky130_fd_sc_hd__decap_4
XFILLER_172_1385 VPWR VGND VPWR VGND sky130_ef_sc_hd__decap_12
XFILLER_81_1268 VGND VGND VPWR VPWR sky130_fd_sc_hd__decap_4
XFILLER_2_27 VGND VGND VPWR VPWR sky130_fd_sc_hd__fill_1
XTAP_TAPCELL_ROW_207_2647 VGND VPWR sky130_fd_sc_hd__tapvpwrvgnd_1
XTAP_TAPCELL_ROW_207_2636 VGND VPWR sky130_fd_sc_hd__tapvpwrvgnd_1
XFILLER_66_41 VPWR VGND VPWR VGND sky130_ef_sc_hd__decap_12
XFILLER_20_1506 VPWR VGND VPWR VGND sky130_ef_sc_hd__decap_12
XFILLER_213_1393 VGND VGND VPWR VPWR sky130_fd_sc_hd__decap_6
XFILLER_206_713 VPWR VGND VPWR VGND sky130_ef_sc_hd__decap_12
XTAP_TAPCELL_ROW_199_2415 VGND VPWR sky130_fd_sc_hd__tapvpwrvgnd_1
XTAP_TAPCELL_ROW_199_2404 VGND VPWR sky130_fd_sc_hd__tapvpwrvgnd_1
XFILLER_66_85 VPWR VGND VPWR VGND sky130_ef_sc_hd__decap_12
XFILLER_17_111 VGND VGND VPWR VPWR sky130_fd_sc_hd__fill_1
XFILLER_205_223 VGND VGND VPWR VPWR sky130_fd_sc_hd__fill_1
XFILLER_206_757 VPWR VGND VPWR VGND sky130_ef_sc_hd__decap_12
X_526_ net70 _182_ net125 VGND VGND VPWR VPWR _237_ sky130_fd_sc_hd__mux2_1
XPHY_EDGE_ROW_57_2_Left_489 VGND VGND VPWR VPWR sky130_fd_sc_hd__decap_3
XFILLER_57_1440 VGND VGND VPWR VPWR sky130_fd_sc_hd__fill_1
XFILLER_183_1481 VPWR VGND VPWR VGND sky130_ef_sc_hd__decap_12
XFILLER_109_1552 VGND VGND VPWR VPWR sky130_fd_sc_hd__fill_1
X_457_ net147 net111 VGND VGND VPWR VPWR _189_ sky130_fd_sc_hd__xor2_1
XFILLER_207_1175 VGND VGND VPWR VPWR sky130_fd_sc_hd__fill_1
XFILLER_201_473 VPWR VGND VPWR VGND sky130_ef_sc_hd__decap_12
XFILLER_18_1468 VGND VGND VPWR VPWR sky130_fd_sc_hd__fill_1
X_388_ _125_ _126_ net156 VGND VGND VPWR VPWR _019_ sky130_fd_sc_hd__o21a_1
XFILLER_174_837 VPWR VGND VPWR VGND sky130_ef_sc_hd__decap_12
XTAP_TAPCELL_ROW_171_1600 VGND VPWR sky130_fd_sc_hd__tapvpwrvgnd_1
XFILLER_31_1602 VGND VGND VPWR VPWR sky130_fd_sc_hd__decap_3
XTAP_TAPCELL_ROW_171_1622 VGND VPWR sky130_fd_sc_hd__tapvpwrvgnd_1
XTAP_TAPCELL_ROW_171_1611 VGND VPWR sky130_fd_sc_hd__tapvpwrvgnd_1
XFILLER_182_881 VPWR VGND VPWR VGND sky130_ef_sc_hd__decap_12
Xoutput106 net106 VGND VGND VPWR VPWR func_rdata[25] sky130_fd_sc_hd__buf_2
XFILLER_99_125 VGND VGND VPWR VPWR sky130_fd_sc_hd__fill_2
Xoutput117 net117 VGND VGND VPWR VPWR func_rdata[6] sky130_fd_sc_hd__buf_2
XFILLER_217_69 VPWR VGND VPWR VGND sky130_ef_sc_hd__decap_12
XFILLER_181_391 VGND VGND VPWR VPWR sky130_fd_sc_hd__fill_1
XFILLER_138_1258 VPWR VGND VPWR VGND sky130_ef_sc_hd__decap_12
XFILLER_68_1580 VGND VGND VPWR VPWR sky130_fd_sc_hd__fill_1
XFILLER_190_1441 VPWR VGND VPWR VGND sky130_ef_sc_hd__decap_12
XTAP_TAPCELL_ROW_169_1551 VGND VPWR sky130_fd_sc_hd__tapvpwrvgnd_1
XFILLER_190_1485 VPWR VGND VPWR VGND sky130_ef_sc_hd__decap_12
XTAP_TAPCELL_ROW_169_1562 VGND VPWR sky130_fd_sc_hd__tapvpwrvgnd_1
XTAP_TAPCELL_ROW_148_2_3942 VGND VPWR sky130_fd_sc_hd__tapvpwrvgnd_1
XTAP_TAPCELL_ROW_165_1448 VGND VPWR sky130_fd_sc_hd__tapvpwrvgnd_1
XTAP_TAPCELL_ROW_165_1437 VGND VPWR sky130_fd_sc_hd__tapvpwrvgnd_1
XFILLER_209_573 VPWR VGND VPWR VGND sky130_ef_sc_hd__decap_12
XTAP_TAPCELL_ROW_117_1_1252 VGND VPWR sky130_fd_sc_hd__tapvpwrvgnd_1
XFILLER_97_1220 VPWR VGND VPWR VGND sky130_ef_sc_hd__decap_12
XFILLER_3_1213 VPWR VGND VPWR VGND sky130_ef_sc_hd__decap_12
XFILLER_149_1310 VPWR VGND VPWR VGND sky130_ef_sc_hd__decap_12
XFILLER_3_1257 VPWR VGND VPWR VGND sky130_ef_sc_hd__decap_12
XFILLER_149_1354 VPWR VGND VPWR VGND sky130_ef_sc_hd__decap_12
XFILLER_97_1286 VPWR VGND VPWR VGND sky130_ef_sc_hd__decap_12
XFILLER_212_749 VGND VGND VPWR VPWR sky130_fd_sc_hd__decap_6
XTAP_TAPCELL_ROW_178_1809 VGND VPWR sky130_fd_sc_hd__tapvpwrvgnd_1
XFILLER_169_609 VGND VGND VPWR VPWR sky130_fd_sc_hd__decap_6
XFILLER_149_1398 VPWR VGND VPWR VGND sky130_ef_sc_hd__decap_12
XPHY_EDGE_ROW_110_1_Left_329 VGND VGND VPWR VPWR sky130_fd_sc_hd__decap_3
XFILLER_211_237 VPWR VGND VPWR VGND sky130_ef_sc_hd__decap_12
XANTENNA_fanout143_A net144 VGND VGND VPWR VPWR sky130_fd_sc_hd__diode_2
XFILLER_36_1524 VGND VGND VPWR VPWR sky130_fd_sc_hd__fill_1
XFILLER_177_653 VPWR VGND VPWR VGND sky130_ef_sc_hd__decap_12
XFILLER_176_141 VPWR VGND VPWR VGND sky130_ef_sc_hd__decap_12
XFILLER_192_601 VPWR VGND VPWR VGND sky130_ef_sc_hd__decap_12
XFILLER_178_1005 VPWR VGND VPWR VGND sky130_ef_sc_hd__decap_12
XFILLER_177_697 VPWR VGND VPWR VGND sky130_ef_sc_hd__decap_12
XFILLER_34_1270 VPWR VGND VPWR VGND sky130_ef_sc_hd__decap_12
XFILLER_192_645 VPWR VGND VPWR VGND sky130_ef_sc_hd__decap_12
XFILLER_191_111 VGND VGND VPWR VPWR sky130_fd_sc_hd__fill_1
XFILLER_178_1049 VPWR VGND VPWR VGND sky130_ef_sc_hd__decap_12
XFILLER_69_1322 VGND VGND VPWR VPWR sky130_fd_sc_hd__decap_6
XFILLER_156_1314 VPWR VGND VPWR VGND sky130_ef_sc_hd__decap_12
XFILLER_69_1366 VPWR VGND VPWR VGND sky130_ef_sc_hd__decap_12
XFILLER_11_69 VPWR VGND VPWR VGND sky130_ef_sc_hd__decap_12
XTAP_TAPCELL_ROW_57_2_3346 VGND VPWR sky130_fd_sc_hd__tapvpwrvgnd_1
XFILLER_156_1358 VPWR VGND VPWR VGND sky130_ef_sc_hd__decap_12
XFILLER_127_69 VPWR VGND VPWR VGND sky130_ef_sc_hd__decap_12
XFILLER_219_337 VPWR VGND VPWR VGND sky130_ef_sc_hd__decap_12
XFILLER_189_1101 VPWR VGND VPWR VGND sky130_ef_sc_hd__decap_12
XFILLER_143_57 VPWR VGND VPWR VGND sky130_ef_sc_hd__decap_12
XFILLER_210_1533 VGND VGND VPWR VPWR sky130_fd_sc_hd__decap_6
XFILLER_189_1145 VPWR VGND VPWR VGND sky130_ef_sc_hd__decap_12
XFILLER_210_1577 VPWR VGND VPWR VGND sky130_ef_sc_hd__decap_12
XTAP_TAPCELL_ROW_202_2511 VGND VPWR sky130_fd_sc_hd__tapvpwrvgnd_1
XTAP_TAPCELL_ROW_202_2500 VGND VPWR sky130_fd_sc_hd__tapvpwrvgnd_1
XFILLER_189_1189 VPWR VGND VPWR VGND sky130_ef_sc_hd__decap_12
XFILLER_185_1009 VPWR VGND VPWR VGND sky130_ef_sc_hd__decap_12
XFILLER_41_1274 VPWR VGND VPWR VGND sky130_ef_sc_hd__decap_12
XFILLER_76_1326 VPWR VGND VPWR VGND sky130_ef_sc_hd__decap_12
XFILLER_36_77 VGND VGND VPWR VPWR sky130_fd_sc_hd__decap_6
XFILLER_203_727 VGND VGND VPWR VPWR sky130_fd_sc_hd__fill_1
XFILLER_187_417 VPWR VGND VPWR VGND sky130_ef_sc_hd__decap_12
XFILLER_163_1329 VPWR VGND VPWR VGND sky130_ef_sc_hd__decap_12
XFILLER_153_3 VPWR VGND VPWR VGND sky130_ef_sc_hd__decap_12
XFILLER_128_1438 VPWR VGND VPWR VGND sky130_ef_sc_hd__decap_12
XFILLER_54_1602 VGND VGND VPWR VPWR sky130_fd_sc_hd__decap_3
X_311_ net21 net144 net133 VGND VGND VPWR VPWR s_wdata\[18\] sky130_fd_sc_hd__a21o_1
XFILLER_204_1315 VGND VGND VPWR VPWR sky130_fd_sc_hd__fill_1
XFILLER_196_973 VGND VGND VPWR VPWR sky130_fd_sc_hd__decap_6
XFILLER_52_65 VPWR VGND VPWR VGND sky130_ef_sc_hd__decap_12
XFILLER_195_461 VPWR VGND VPWR VGND sky130_ef_sc_hd__decap_12
XFILLER_168_65 VPWR VGND VPWR VGND sky130_ef_sc_hd__decap_12
Xinput19 func_wdata[16] VGND VGND VPWR VPWR net19 sky130_fd_sc_hd__clkbuf_1
XFILLER_7_825 VGND VGND VPWR VPWR sky130_fd_sc_hd__fill_2
XFILLER_13_1310 VPWR VGND VPWR VGND sky130_ef_sc_hd__decap_12
XFILLER_52_98 VPWR VGND VPWR VGND sky130_ef_sc_hd__decap_12
XFILLER_202_1061 VPWR VGND VPWR VGND sky130_ef_sc_hd__decap_12
XFILLER_196_1105 VPWR VGND VPWR VGND sky130_ef_sc_hd__decap_12
XFILLER_182_133 VGND VGND VPWR VPWR sky130_fd_sc_hd__decap_6
XFILLER_17_1490 VGND VGND VPWR VPWR sky130_fd_sc_hd__decap_6
XFILLER_52_1370 VPWR VGND VPWR VGND sky130_ef_sc_hd__decap_12
XFILLER_196_1149 VPWR VGND VPWR VGND sky130_ef_sc_hd__decap_12
XFILLER_104_1482 VPWR VGND VPWR VGND sky130_ef_sc_hd__decap_12
XFILLER_100_1302 VPWR VGND VPWR VGND sky130_ef_sc_hd__decap_12
XFILLER_87_1422 VPWR VGND VPWR VGND sky130_ef_sc_hd__decap_12
XANTENNA__499__B1 net138 VGND VGND VPWR VPWR sky130_fd_sc_hd__diode_2
XFILLER_6_357 VGND VGND VPWR VPWR sky130_fd_sc_hd__decap_6
XFILLER_7_869 VPWR VGND VPWR VGND sky130_ef_sc_hd__decap_12
XFILLER_13_1354 VPWR VGND VPWR VGND sky130_ef_sc_hd__decap_12
XTAP_TAPCELL_ROW_188_2105 VGND VPWR sky130_fd_sc_hd__tapvpwrvgnd_1
XFILLER_184_53 VPWR VGND VPWR VGND sky130_ef_sc_hd__decap_12
XFILLER_182_177 VPWR VGND VPWR VGND sky130_ef_sc_hd__decap_12
XFILLER_164_881 VPWR VGND VPWR VGND sky130_ef_sc_hd__decap_12
XFILLER_139_1534 VPWR VGND VPWR VGND sky130_ef_sc_hd__decap_12
XFILLER_87_1466 VPWR VGND VPWR VGND sky130_ef_sc_hd__decap_12
XFILLER_13_1398 VPWR VGND VPWR VGND sky130_ef_sc_hd__decap_12
XFILLER_48_1406 VGND VGND VPWR VPWR sky130_fd_sc_hd__decap_6
XFILLER_184_97 VPWR VGND VPWR VGND sky130_ef_sc_hd__decap_12
XFILLER_139_1578 VPWR VGND VPWR VGND sky130_ef_sc_hd__decap_12
XTAP_TAPCELL_ROW_209_2709 VGND VPWR sky130_fd_sc_hd__tapvpwrvgnd_1
XTAP_TAPCELL_ROW_134_2_3850 VGND VPWR sky130_fd_sc_hd__tapvpwrvgnd_1
XFILLER_2_563 VGND VGND VPWR VPWR sky130_fd_sc_hd__decap_8
XFILLER_215_1455 VGND VGND VPWR VPWR sky130_fd_sc_hd__fill_1
XFILLER_77_51 VGND VGND VPWR VPWR sky130_fd_sc_hd__decap_4
XFILLER_203_27 VPWR VGND VPWR VGND sky130_ef_sc_hd__decap_12
XFILLER_4_1533 VGND VGND VPWR VPWR sky130_fd_sc_hd__decap_6
XFILLER_20_1314 VPWR VGND VPWR VGND sky130_ef_sc_hd__decap_12
XFILLER_24_1450 VPWR VGND VPWR VGND sky130_ef_sc_hd__decap_12
XFILLER_219_893 VGND VGND VPWR VPWR sky130_fd_sc_hd__decap_3
XFILLER_168_1229 VPWR VGND VPWR VGND sky130_ef_sc_hd__decap_12
XFILLER_111_1442 VPWR VGND VPWR VGND sky130_ef_sc_hd__decap_12
XFILLER_98_1562 VPWR VGND VPWR VGND sky130_ef_sc_hd__decap_12
XFILLER_4_1577 VPWR VGND VPWR VGND sky130_ef_sc_hd__decap_12
XFILLER_24_1494 VPWR VGND VPWR VGND sky130_ef_sc_hd__decap_12
XANTENNA__429__A b_addr\[6\] VGND VGND VPWR VPWR sky130_fd_sc_hd__diode_2
XFILLER_94_1426 VPWR VGND VPWR VGND sky130_ef_sc_hd__decap_12
XFILLER_20_1358 VPWR VGND VPWR VGND sky130_ef_sc_hd__decap_12
XFILLER_59_1546 VGND VGND VPWR VPWR sky130_fd_sc_hd__decap_6
XFILLER_206_587 VGND VGND VPWR VPWR sky130_fd_sc_hd__fill_1
XFILLER_146_1538 VPWR VGND VPWR VGND sky130_ef_sc_hd__decap_12
X_509_ net149 _200_ net127 net135 _228_ VGND VGND VPWR VPWR _038_ sky130_fd_sc_hd__o311a_1
XFILLER_18_1232 VPWR VGND VPWR VGND sky130_ef_sc_hd__decap_12
XFILLER_187_951 VGND VGND VPWR VPWR sky130_fd_sc_hd__fill_1
XFILLER_202_793 VPWR VGND VPWR VGND sky130_ef_sc_hd__decap_12
XFILLER_201_281 VPWR VGND VPWR VGND sky130_ef_sc_hd__decap_12
XFILLER_174_601 VPWR VGND VPWR VGND sky130_ef_sc_hd__decap_12
XTAP_TAPCELL_ROW_63_2_3389 VGND VPWR sky130_fd_sc_hd__tapvpwrvgnd_1
XFILLER_31_1410 VPWR VGND VPWR VGND sky130_ef_sc_hd__decap_12
XFILLER_179_1325 VPWR VGND VPWR VGND sky130_ef_sc_hd__decap_12
XFILLER_174_645 VPWR VGND VPWR VGND sky130_ef_sc_hd__decap_12
XFILLER_173_111 VGND VGND VPWR VPWR sky130_fd_sc_hd__fill_1
XFILLER_105_1268 VGND VGND VPWR VPWR sky130_fd_sc_hd__decap_4
XFILLER_70_1470 VPWR VGND VPWR VGND sky130_ef_sc_hd__decap_12
XFILLER_35_1590 VPWR VGND VPWR VGND sky130_ef_sc_hd__decap_12
XFILLER_179_1369 VPWR VGND VPWR VGND sky130_ef_sc_hd__decap_12
XFILLER_122_1582 VPWR VGND VPWR VGND sky130_ef_sc_hd__decap_12
XFILLER_31_1454 VPWR VGND VPWR VGND sky130_ef_sc_hd__decap_12
XFILLER_66_1506 VPWR VGND VPWR VGND sky130_ef_sc_hd__decap_12
XFILLER_31_1498 VPWR VGND VPWR VGND sky130_ef_sc_hd__decap_12
XFILLER_9_1422 VPWR VGND VPWR VGND sky130_ef_sc_hd__decap_12
XTAP_TAPCELL_ROW_23_2_3130 VGND VPWR sky130_fd_sc_hd__tapvpwrvgnd_1
XFILLER_9_1466 VPWR VGND VPWR VGND sky130_ef_sc_hd__decap_12
XFILLER_151_1244 VPWR VGND VPWR VGND sky130_ef_sc_hd__decap_12
XFILLER_3_81 VPWR VGND VPWR VGND sky130_ef_sc_hd__decap_12
XFILLER_216_307 VGND VGND VPWR VPWR sky130_fd_sc_hd__fill_1
XTAP_TAPCELL_ROW_148_1_1313 VGND VPWR sky130_fd_sc_hd__tapvpwrvgnd_1
XFILLER_113_27 VPWR VGND VPWR VGND sky130_ef_sc_hd__decap_12
XFILLER_3_1021 VPWR VGND VPWR VGND sky130_ef_sc_hd__decap_12
XFILLER_42_1550 VPWR VGND VPWR VGND sky130_ef_sc_hd__decap_12
XFILLER_186_1329 VPWR VGND VPWR VGND sky130_ef_sc_hd__decap_12
XFILLER_77_1602 VGND VGND VPWR VPWR sky130_fd_sc_hd__decap_3
XANTENNA__339__A net157 VGND VGND VPWR VPWR sky130_fd_sc_hd__diode_2
XFILLER_42_1594 VGND VGND VPWR VPWR sky130_fd_sc_hd__decap_8
XFILLER_3_1065 VPWR VGND VPWR VGND sky130_ef_sc_hd__decap_12
XTAP_TAPCELL_ROW_53_1_1124 VGND VPWR sky130_fd_sc_hd__tapvpwrvgnd_1
XTAP_TAPCELL_ROW_219_3016 VGND VPWR sky130_fd_sc_hd__tapvpwrvgnd_1
XTAP_TAPCELL_ROW_219_3005 VGND VPWR sky130_fd_sc_hd__tapvpwrvgnd_1
XFILLER_212_513 VPWR VGND VPWR VGND sky130_ef_sc_hd__decap_12
XFILLER_212_557 VPWR VGND VPWR VGND sky130_ef_sc_hd__decap_12
XFILLER_169_417 VPWR VGND VPWR VGND sky130_ef_sc_hd__decap_12
XFILLER_193_921 VPWR VGND VPWR VGND sky130_ef_sc_hd__decap_12
XFILLER_178_973 VGND VGND VPWR VPWR sky130_fd_sc_hd__decap_6
XFILLER_177_461 VPWR VGND VPWR VGND sky130_ef_sc_hd__decap_12
XFILLER_71_1256 VPWR VGND VPWR VGND sky130_ef_sc_hd__decap_12
XFILLER_197_1425 VPWR VGND VPWR VGND sky130_ef_sc_hd__decap_12
XFILLER_193_965 VPWR VGND VPWR VGND sky130_ef_sc_hd__decap_12
XFILLER_22_46 VGND VGND VPWR VPWR sky130_fd_sc_hd__fill_1
XFILLER_203_1381 VPWR VGND VPWR VGND sky130_ef_sc_hd__decap_12
XFILLER_197_1469 VPWR VGND VPWR VGND sky130_ef_sc_hd__decap_12
XFILLER_192_475 VGND VGND VPWR VPWR sky130_fd_sc_hd__fill_1
XFILLER_164_133 VGND VGND VPWR VPWR sky130_fd_sc_hd__decap_6
XFILLER_180_637 VGND VGND VPWR VPWR sky130_fd_sc_hd__decap_6
XFILLER_164_177 VPWR VGND VPWR VGND sky130_ef_sc_hd__decap_12
XFILLER_10_1538 VPWR VGND VPWR VGND sky130_ef_sc_hd__decap_12
XTAP_TAPCELL_ROW_119_2_3752 VGND VPWR sky130_fd_sc_hd__tapvpwrvgnd_1
XPHY_EDGE_ROW_5_Left_225 VGND VGND VPWR VPWR sky130_fd_sc_hd__decap_3
XFILLER_191_1057 VGND VGND VPWR VPWR sky130_fd_sc_hd__decap_6
XTAP_TAPCELL_ROW_87_2_3541 VGND VPWR sky130_fd_sc_hd__tapvpwrvgnd_1
Xfanout130 _212_ VGND VGND VPWR VPWR net130 sky130_fd_sc_hd__clkbuf_2
XANTENNA_clkbuf_3_6_0_clk_X clknet_3_6_0_clk VGND VGND VPWR VPWR sky130_fd_sc_hd__diode_2
Xfanout141 _083_ VGND VGND VPWR VPWR net141 sky130_fd_sc_hd__buf_2
Xfanout152 net153 VGND VGND VPWR VPWR net152 sky130_fd_sc_hd__buf_2
XFILLER_169_1505 VGND VGND VPWR VPWR sky130_fd_sc_hd__decap_6
XFILLER_210_1341 VPWR VGND VPWR VGND sky130_ef_sc_hd__decap_12
XFILLER_207_329 VGND VGND VPWR VPWR sky130_fd_sc_hd__decap_6
XFILLER_169_1549 VPWR VGND VPWR VGND sky130_ef_sc_hd__decap_12
XTAP_TAPCELL_ROW_112_2_3706 VGND VPWR sky130_fd_sc_hd__tapvpwrvgnd_1
XTAP_TAPCELL_ROW_3_872 VGND VPWR sky130_fd_sc_hd__tapvpwrvgnd_1
XFILLER_210_1385 VPWR VGND VPWR VGND sky130_ef_sc_hd__decap_12
XFILLER_170_77 VGND VGND VPWR VPWR sky130_fd_sc_hd__decap_6
XTAP_TAPCELL_ROW_3_883 VGND VPWR sky130_fd_sc_hd__tapvpwrvgnd_1
XFILLER_215_373 VPWR VGND VPWR VGND sky130_ef_sc_hd__decap_12
XFILLER_103_93 VPWR VGND VPWR VGND sky130_ef_sc_hd__decap_12
XFILLER_188_737 VPWR VGND VPWR VGND sky130_ef_sc_hd__decap_12
XFILLER_187_225 VPWR VGND VPWR VGND sky130_ef_sc_hd__decap_12
XFILLER_128_1246 VPWR VGND VPWR VGND sky130_ef_sc_hd__decap_12
XFILLER_169_951 VGND VGND VPWR VPWR sky130_fd_sc_hd__fill_1
XFILLER_8_15 VPWR VGND VPWR VGND sky130_ef_sc_hd__decap_12
XFILLER_19_1552 VGND VGND VPWR VPWR sky130_fd_sc_hd__fill_1
XFILLER_196_781 VPWR VGND VPWR VGND sky130_ef_sc_hd__decap_12
XFILLER_155_111 VGND VGND VPWR VPWR sky130_fd_sc_hd__fill_1
XFILLER_8_59 VGND VGND VPWR VPWR sky130_fd_sc_hd__fill_1
XFILLER_176_1509 VPWR VGND VPWR VGND sky130_ef_sc_hd__decap_12
XFILLER_171_615 VGND VGND VPWR VPWR sky130_fd_sc_hd__fill_1
XFILLER_183_497 VGND VGND VPWR VPWR sky130_fd_sc_hd__decap_6
XFILLER_139_1342 VPWR VGND VPWR VGND sky130_ef_sc_hd__decap_12
XFILLER_87_1274 VPWR VGND VPWR VGND sky130_ef_sc_hd__decap_12
XFILLER_6_187 VGND VGND VPWR VPWR sky130_fd_sc_hd__decap_8
XFILLER_139_1386 VPWR VGND VPWR VGND sky130_ef_sc_hd__decap_12
XFILLER_48_1258 VPWR VGND VPWR VGND sky130_ef_sc_hd__decap_12
XPHY_EDGE_ROW_120_1_Right_706 VGND VGND VPWR VPWR sky130_fd_sc_hd__decap_3
XFILLER_88_83 VGND VGND VPWR VPWR sky130_fd_sc_hd__fill_1
XFILLER_214_15 VPWR VGND VPWR VGND sky130_ef_sc_hd__decap_12
XFILLER_84_109 VPWR VGND VPWR VGND sky130_ef_sc_hd__decap_12
XTAP_TAPCELL_ROW_1_809 VGND VPWR sky130_fd_sc_hd__tapvpwrvgnd_1
XFILLER_4_1341 VPWR VGND VPWR VGND sky130_ef_sc_hd__decap_12
XFILLER_207_841 VPWR VGND VPWR VGND sky130_ef_sc_hd__decap_12
XFILLER_168_1037 VPWR VGND VPWR VGND sky130_ef_sc_hd__decap_12
XFILLER_111_1272 VGND VGND VPWR VPWR sky130_fd_sc_hd__fill_1
XFILLER_98_1370 VPWR VGND VPWR VGND sky130_ef_sc_hd__decap_12
XFILLER_4_1385 VPWR VGND VPWR VGND sky130_ef_sc_hd__decap_12
XFILLER_0_1205 VPWR VGND VPWR VGND sky130_ef_sc_hd__decap_12
XFILLER_59_1310 VPWR VGND VPWR VGND sky130_ef_sc_hd__decap_12
XFILLER_209_1001 VGND VGND VPWR VPWR sky130_fd_sc_hd__decap_6
XFILLER_146_1302 VPWR VGND VPWR VGND sky130_ef_sc_hd__decap_12
XPHY_EDGE_ROW_17_2_Right_74 VGND VGND VPWR VPWR sky130_fd_sc_hd__decap_3
XFILLER_59_1354 VPWR VGND VPWR VGND sky130_ef_sc_hd__decap_12
XFILLER_209_1045 VPWR VGND VPWR VGND sky130_ef_sc_hd__decap_12
XFILLER_59_1398 VPWR VGND VPWR VGND sky130_ef_sc_hd__decap_12
XFILLER_209_1089 VPWR VGND VPWR VGND sky130_ef_sc_hd__decap_12
XFILLER_193_217 VGND VGND VPWR VPWR sky130_fd_sc_hd__decap_6
XFILLER_175_921 VPWR VGND VPWR VGND sky130_ef_sc_hd__decap_12
XFILLER_200_1521 VPWR VGND VPWR VGND sky130_ef_sc_hd__decap_12
XFILLER_179_1133 VPWR VGND VPWR VGND sky130_ef_sc_hd__decap_12
XFILLER_175_965 VPWR VGND VPWR VGND sky130_ef_sc_hd__decap_12
XTAP_TAPCELL_ROW_93_2_3584 VGND VPWR sky130_fd_sc_hd__tapvpwrvgnd_1
XFILLER_200_1565 VPWR VGND VPWR VGND sky130_ef_sc_hd__decap_12
XFILLER_179_1177 VPWR VGND VPWR VGND sky130_ef_sc_hd__decap_12
XFILLER_174_475 VGND VGND VPWR VPWR sky130_fd_sc_hd__fill_1
XTAP_TAPCELL_ROW_105_2_3660 VGND VPWR sky130_fd_sc_hd__tapvpwrvgnd_1
XFILLER_190_979 VGND VGND VPWR VPWR sky130_fd_sc_hd__fill_1
XFILLER_161_125 VGND VGND VPWR VPWR sky130_fd_sc_hd__fill_2
XFILLER_157_1442 VPWR VGND VPWR VGND sky130_ef_sc_hd__decap_12
XFILLER_108_27 VGND VGND VPWR VPWR sky130_fd_sc_hd__fill_1
XFILLER_66_1314 VPWR VGND VPWR VGND sky130_ef_sc_hd__decap_12
XFILLER_216_1005 VPWR VGND VPWR VGND sky130_ef_sc_hd__decap_12
XFILLER_118_1426 VPWR VGND VPWR VGND sky130_ef_sc_hd__decap_12
XFILLER_66_1358 VPWR VGND VPWR VGND sky130_ef_sc_hd__decap_12
XFILLER_0_319 VGND VGND VPWR VPWR sky130_fd_sc_hd__decap_3
XFILLER_216_1049 VPWR VGND VPWR VGND sky130_ef_sc_hd__decap_12
XFILLER_170_681 VPWR VGND VPWR VGND sky130_ef_sc_hd__decap_12
XFILLER_153_1328 VGND VGND VPWR VPWR sky130_fd_sc_hd__fill_1
XPHY_EDGE_ROW_134_2_Left_566 VGND VGND VPWR VPWR sky130_fd_sc_hd__decap_3
XFILLER_124_15 VPWR VGND VPWR VGND sky130_ef_sc_hd__decap_12
XFILLER_9_1274 VPWR VGND VPWR VGND sky130_ef_sc_hd__decap_12
XFILLER_77_1410 VPWR VGND VPWR VGND sky130_ef_sc_hd__decap_12
XPHY_EDGE_ROW_71_2_Left_503 VGND VGND VPWR VPWR sky130_fd_sc_hd__decap_3
XFILLER_129_1522 VPWR VGND VPWR VGND sky130_ef_sc_hd__decap_12
XFILLER_77_1454 VPWR VGND VPWR VGND sky130_ef_sc_hd__decap_12
XFILLER_17_57 VGND VGND VPWR VPWR sky130_fd_sc_hd__decap_4
XFILLER_17_79 VPWR VGND VPWR VGND sky130_ef_sc_hd__decap_12
XFILLER_213_833 VGND VGND VPWR VPWR sky130_fd_sc_hd__decap_6
XFILLER_212_321 VPWR VGND VPWR VGND sky130_ef_sc_hd__decap_12
XFILLER_129_1566 VPWR VGND VPWR VGND sky130_ef_sc_hd__decap_12
XFILLER_77_1498 VPWR VGND VPWR VGND sky130_ef_sc_hd__decap_12
XTAP_TAPCELL_ROW_34_2_3199 VGND VPWR sky130_fd_sc_hd__tapvpwrvgnd_1
XFILLER_38_1438 VPWR VGND VPWR VGND sky130_ef_sc_hd__decap_12
XFILLER_213_877 VPWR VGND VPWR VGND sky130_ef_sc_hd__decap_12
XFILLER_212_365 VPWR VGND VPWR VGND sky130_ef_sc_hd__decap_12
XFILLER_169_225 VPWR VGND VPWR VGND sky130_ef_sc_hd__decap_12
XFILLER_185_729 VPWR VGND VPWR VGND sky130_ef_sc_hd__decap_12
XFILLER_178_781 VPWR VGND VPWR VGND sky130_ef_sc_hd__decap_12
XFILLER_137_111 VGND VGND VPWR VPWR sky130_fd_sc_hd__fill_1
XFILLER_197_1233 VPWR VGND VPWR VGND sky130_ef_sc_hd__decap_12
XFILLER_180_401 VPWR VGND VPWR VGND sky130_ef_sc_hd__decap_12
XFILLER_165_497 VGND VGND VPWR VPWR sky130_fd_sc_hd__decap_6
XFILLER_116_3 VPWR VGND VPWR VGND sky130_ef_sc_hd__decap_12
XFILLER_88_1550 VPWR VGND VPWR VGND sky130_ef_sc_hd__decap_12
XFILLER_4_603 VPWR VGND VPWR VGND sky130_ef_sc_hd__decap_12
XFILLER_10_1302 VPWR VGND VPWR VGND sky130_ef_sc_hd__decap_12
XFILLER_14_1482 VPWR VGND VPWR VGND sky130_ef_sc_hd__decap_12
XFILLER_193_1119 VGND VGND VPWR VPWR sky130_fd_sc_hd__fill_1
XFILLER_180_445 VPWR VGND VPWR VGND sky130_ef_sc_hd__decap_12
XFILLER_165_55 VGND VGND VPWR VPWR sky130_fd_sc_hd__fill_1
XFILLER_84_1414 VPWR VGND VPWR VGND sky130_ef_sc_hd__decap_12
XFILLER_3_113 VGND VGND VPWR VPWR sky130_fd_sc_hd__decap_6
XFILLER_49_1534 VPWR VGND VPWR VGND sky130_ef_sc_hd__decap_12
XFILLER_180_489 VPWR VGND VPWR VGND sky130_ef_sc_hd__decap_12
XTAP_TAPCELL_ROW_140_1_1297 VGND VPWR sky130_fd_sc_hd__tapvpwrvgnd_1
XFILLER_136_1526 VPWR VGND VPWR VGND sky130_ef_sc_hd__decap_12
XFILLER_101_1496 VGND VGND VPWR VPWR sky130_fd_sc_hd__fill_1
XFILLER_88_1594 VGND VGND VPWR VPWR sky130_fd_sc_hd__decap_8
XFILLER_4_669 VGND VGND VPWR VPWR sky130_fd_sc_hd__decap_8
XFILLER_49_1578 VPWR VGND VPWR VGND sky130_ef_sc_hd__decap_12
XPHY_EDGE_ROW_66_2_Left_498 VGND VGND VPWR VPWR sky130_fd_sc_hd__decap_3
XFILLER_66_109 VPWR VGND VPWR VGND sky130_ef_sc_hd__decap_12
XFILLER_58_53 VPWR VGND VPWR VGND sky130_ef_sc_hd__decap_12
XANTENNA_input36_A func_wdata[31] VGND VGND VPWR VPWR sky130_fd_sc_hd__diode_2
XFILLER_0_886 VGND VGND VPWR VPWR sky130_fd_sc_hd__decap_3
Xhold8 net85 VGND VGND VPWR VPWR net178 sky130_fd_sc_hd__dlygate4sd3_1
XFILLER_58_97 VPWR VGND VPWR VGND sky130_ef_sc_hd__decap_12
XFILLER_169_1313 VPWR VGND VPWR VGND sky130_ef_sc_hd__decap_12
XFILLER_134_1294 VGND VGND VPWR VPWR sky130_fd_sc_hd__decap_6
XFILLER_207_137 VPWR VGND VPWR VGND sky130_ef_sc_hd__decap_12
XFILLER_169_1357 VPWR VGND VPWR VGND sky130_ef_sc_hd__decap_12
XFILLER_95_1510 VPWR VGND VPWR VGND sky130_ef_sc_hd__decap_12
XFILLER_74_41 VPWR VGND VPWR VGND sky130_ef_sc_hd__decap_12
XFILLER_1_1525 VPWR VGND VPWR VGND sky130_ef_sc_hd__decap_12
XFILLER_21_1442 VPWR VGND VPWR VGND sky130_ef_sc_hd__decap_12
XFILLER_204_811 VGND VGND VPWR VPWR sky130_fd_sc_hd__fill_1
XTAP_TAPCELL_ROW_142_2_3901 VGND VPWR sky130_fd_sc_hd__tapvpwrvgnd_1
XFILLER_95_1554 VPWR VGND VPWR VGND sky130_ef_sc_hd__decap_12
XFILLER_74_85 VPWR VGND VPWR VGND sky130_ef_sc_hd__decap_12
XFILLER_1_1569 VPWR VGND VPWR VGND sky130_ef_sc_hd__decap_12
XFILLER_216_693 VGND VGND VPWR VPWR sky130_fd_sc_hd__decap_6
XFILLER_215_181 VPWR VGND VPWR VGND sky130_ef_sc_hd__decap_12
XFILLER_188_501 VPWR VGND VPWR VGND sky130_ef_sc_hd__decap_12
XFILLER_56_1538 VPWR VGND VPWR VGND sky130_ef_sc_hd__decap_12
XFILLER_206_1229 VPWR VGND VPWR VGND sky130_ef_sc_hd__decap_12
XFILLER_188_545 VPWR VGND VPWR VGND sky130_ef_sc_hd__decap_12
Xu_sram.u_mem_168 VGND VGND VPWR VPWR net168 u_sram.u_mem_168/LO sky130_fd_sc_hd__conb_1
XFILLER_188_589 VPWR VGND VPWR VGND sky130_ef_sc_hd__decap_12
XFILLER_175_217 VGND VGND VPWR VPWR sky130_fd_sc_hd__decap_6
XFILLER_141_1232 VPWR VGND VPWR VGND sky130_ef_sc_hd__decap_12
XTAP_TAPCELL_ROW_78_2_3486 VGND VPWR sky130_fd_sc_hd__tapvpwrvgnd_1
XFILLER_209_15 VPWR VGND VPWR VGND sky130_ef_sc_hd__decap_12
XFILLER_190_209 VPWR VGND VPWR VGND sky130_ef_sc_hd__decap_12
XFILLER_15_1268 VGND VGND VPWR VPWR sky130_fd_sc_hd__decap_4
XFILLER_183_261 VPWR VGND VPWR VGND sky130_ef_sc_hd__decap_12
XFILLER_176_1317 VPWR VGND VPWR VGND sky130_ef_sc_hd__decap_12
XFILLER_141_1298 VPWR VGND VPWR VGND sky130_ef_sc_hd__decap_12
XFILLER_32_1582 VPWR VGND VPWR VGND sky130_ef_sc_hd__decap_12
XFILLER_172_979 VGND VGND VPWR VPWR sky130_fd_sc_hd__fill_1
XFILLER_143_125 VGND VGND VPWR VPWR sky130_fd_sc_hd__fill_2
XFILLER_217_1325 VPWR VGND VPWR VGND sky130_ef_sc_hd__decap_12
XFILLER_99_93 VPWR VGND VPWR VGND sky130_ef_sc_hd__decap_12
XTAP_TAPCELL_ROW_77_1_1172 VGND VPWR sky130_fd_sc_hd__tapvpwrvgnd_1
XFILLER_217_1369 VPWR VGND VPWR VGND sky130_ef_sc_hd__decap_12
XFILLER_174_1085 VGND VGND VPWR VPWR sky130_fd_sc_hd__decap_6
XFILLER_31_3 VPWR VGND VPWR VGND sky130_ef_sc_hd__decap_12
XPHY_EDGE_ROW_121_1_Right_707 VGND VGND VPWR VPWR sky130_fd_sc_hd__decap_3
XFILLER_152_1350 VGND VGND VPWR VPWR sky130_fd_sc_hd__decap_6
XFILLER_61_1244 VPWR VGND VPWR VGND sky130_ef_sc_hd__decap_12
XFILLER_187_1413 VPWR VGND VPWR VGND sky130_ef_sc_hd__decap_12
XFILLER_152_1394 VPWR VGND VPWR VGND sky130_ef_sc_hd__decap_12
XFILLER_187_1457 VPWR VGND VPWR VGND sky130_ef_sc_hd__decap_12
XFILLER_113_1378 VGND VGND VPWR VPWR sky130_fd_sc_hd__decap_6
XFILLER_207_671 VGND VGND VPWR VPWR sky130_fd_sc_hd__fill_1
XFILLER_198_309 VPWR VGND VPWR VGND sky130_ef_sc_hd__decap_12
XFILLER_181_1001 VGND VGND VPWR VPWR sky130_fd_sc_hd__decap_6
XFILLER_181_1045 VPWR VGND VPWR VGND sky130_ef_sc_hd__decap_12
XFILLER_210_825 VPWR VGND VPWR VGND sky130_ef_sc_hd__decap_12
XFILLER_167_729 VPWR VGND VPWR VGND sky130_ef_sc_hd__decap_12
XFILLER_210_869 VPWR VGND VPWR VGND sky130_ef_sc_hd__decap_12
XFILLER_181_1089 VPWR VGND VPWR VGND sky130_ef_sc_hd__decap_12
XFILLER_119_111 VGND VGND VPWR VPWR sky130_fd_sc_hd__fill_1
XFILLER_119_15 VPWR VGND VPWR VGND sky130_ef_sc_hd__decap_12
XFILLER_198_1553 VPWR VGND VPWR VGND sky130_ef_sc_hd__decap_12
XFILLER_120_1338 VPWR VGND VPWR VGND sky130_ef_sc_hd__decap_12
XFILLER_200_1373 VPWR VGND VPWR VGND sky130_ef_sc_hd__decap_12
XFILLER_198_1597 VGND VGND VPWR VPWR sky130_fd_sc_hd__decap_8
XFILLER_192_1141 VGND VGND VPWR VPWR sky130_fd_sc_hd__decap_6
XFILLER_1_617 VGND VGND VPWR VPWR sky130_fd_sc_hd__decap_6
XFILLER_157_1272 VGND VGND VPWR VPWR sky130_fd_sc_hd__fill_1
XFILLER_192_1185 VPWR VGND VPWR VGND sky130_ef_sc_hd__decap_12
XFILLER_135_69 VPWR VGND VPWR VGND sky130_ef_sc_hd__decap_12
XTAP_TAPCELL_ROW_5_923 VGND VPWR sky130_fd_sc_hd__tapvpwrvgnd_1
XTAP_TAPCELL_ROW_5_934 VGND VPWR sky130_fd_sc_hd__tapvpwrvgnd_1
XTAP_TAPCELL_ROW_5_945 VGND VPWR sky130_fd_sc_hd__tapvpwrvgnd_1
XFILLER_48_109 VPWR VGND VPWR VGND sky130_ef_sc_hd__decap_12
XFILLER_218_925 VPWR VGND VPWR VGND sky130_ef_sc_hd__decap_12
XFILLER_170_1483 VGND VGND VPWR VPWR sky130_fd_sc_hd__fill_1
XFILLER_131_1434 VGND VGND VPWR VPWR sky130_fd_sc_hd__decap_6
XFILLER_151_57 VPWR VGND VPWR VGND sky130_ef_sc_hd__decap_12
XFILLER_131_1478 VPWR VGND VPWR VGND sky130_ef_sc_hd__decap_12
XTAP_TAPCELL_ROW_127_2_3803 VGND VPWR sky130_fd_sc_hd__tapvpwrvgnd_1
XFILLER_207_1505 VGND VGND VPWR VPWR sky130_fd_sc_hd__decap_6
XFILLER_129_1330 VPWR VGND VPWR VGND sky130_ef_sc_hd__decap_12
X_490_ net82 net121 VGND VGND VPWR VPWR _219_ sky130_fd_sc_hd__or2_1
XANTENNA__527__A net138 VGND VGND VPWR VPWR sky130_fd_sc_hd__diode_2
XTAP_TAPCELL_ROW_21_1_1059 VGND VPWR sky130_fd_sc_hd__tapvpwrvgnd_1
XFILLER_213_641 VPWR VGND VPWR VGND sky130_ef_sc_hd__decap_12
XFILLER_38_1246 VPWR VGND VPWR VGND sky130_ef_sc_hd__decap_12
XFILLER_38_1235 VGND VGND VPWR VPWR sky130_fd_sc_hd__decap_8
XFILLER_44_77 VGND VGND VPWR VPWR sky130_fd_sc_hd__decap_6
XFILLER_213_685 VPWR VGND VPWR VGND sky130_ef_sc_hd__decap_12
XFILLER_207_1549 VPWR VGND VPWR VGND sky130_ef_sc_hd__decap_12
XTAP_TAPCELL_ROW_64_2_3394 VGND VPWR sky130_fd_sc_hd__tapvpwrvgnd_1
XFILLER_212_195 VGND VGND VPWR VPWR sky130_fd_sc_hd__fill_1
XFILLER_200_357 VGND VGND VPWR VPWR sky130_fd_sc_hd__decap_6
XTAP_TAPCELL_ROW_195_2292 VGND VPWR sky130_fd_sc_hd__tapvpwrvgnd_1
XFILLER_90_1462 VGND VGND VPWR VPWR sky130_fd_sc_hd__decap_6
XTAP_TAPCELL_ROW_191_2178 VGND VPWR sky130_fd_sc_hd__tapvpwrvgnd_1
XFILLER_185_559 VGND VGND VPWR VPWR sky130_fd_sc_hd__fill_1
XFILLER_142_1574 VGND VGND VPWR VPWR sky130_fd_sc_hd__decap_6
XFILLER_100_83 VGND VGND VPWR VPWR sky130_fd_sc_hd__fill_1
XFILLER_60_65 VPWR VGND VPWR VGND sky130_ef_sc_hd__decap_12
XTAP_TAPCELL_ROW_216_2885 VGND VPWR sky130_fd_sc_hd__tapvpwrvgnd_1
XTAP_TAPCELL_ROW_191_2189 VGND VPWR sky130_fd_sc_hd__tapvpwrvgnd_1
XFILLER_181_721 VGND VGND VPWR VPWR sky130_fd_sc_hd__decap_6
XFILLER_176_65 VPWR VGND VPWR VGND sky130_ef_sc_hd__decap_12
XFILLER_172_209 VPWR VGND VPWR VGND sky130_ef_sc_hd__decap_12
XFILLER_165_261 VPWR VGND VPWR VGND sky130_ef_sc_hd__decap_12
XTAP_TAPCELL_ROW_216_2896 VGND VPWR sky130_fd_sc_hd__tapvpwrvgnd_1
XFILLER_197_1063 VGND VGND VPWR VPWR sky130_fd_sc_hd__fill_1
XFILLER_181_765 VPWR VGND VPWR VGND sky130_ef_sc_hd__decap_12
XFILLER_125_125 VGND VGND VPWR VPWR sky130_fd_sc_hd__fill_2
XFILLER_5_27 VPWR VGND VPWR VGND sky130_ef_sc_hd__decap_12
XFILLER_180_253 VPWR VGND VPWR VGND sky130_ef_sc_hd__decap_12
XFILLER_109_81 VPWR VGND VPWR VGND sky130_ef_sc_hd__decap_12
XFILLER_4_477 VPWR VGND VPWR VGND sky130_ef_sc_hd__decap_12
XFILLER_4_455 VGND VGND VPWR VPWR sky130_fd_sc_hd__fill_2
XFILLER_5_989 VPWR VGND VPWR VGND sky130_ef_sc_hd__decap_12
XFILLER_49_1342 VPWR VGND VPWR VGND sky130_ef_sc_hd__decap_12
XFILLER_84_1244 VGND VGND VPWR VPWR sky130_fd_sc_hd__fill_1
XANTENNA__311__A2 net144 VGND VGND VPWR VPWR sky130_fd_sc_hd__diode_2
XFILLER_49_1386 VPWR VGND VPWR VGND sky130_ef_sc_hd__decap_12
XFILLER_214_1509 VPWR VGND VPWR VGND sky130_ef_sc_hd__decap_12
XFILLER_192_53 VPWR VGND VPWR VGND sky130_ef_sc_hd__decap_12
XFILLER_171_1225 VGND VGND VPWR VPWR sky130_fd_sc_hd__decap_6
XFILLER_136_1356 VGND VGND VPWR VPWR sky130_fd_sc_hd__fill_1
XFILLER_192_97 VPWR VGND VPWR VGND sky130_ef_sc_hd__decap_12
XFILLER_171_1269 VPWR VGND VPWR VGND sky130_ef_sc_hd__decap_12
XFILLER_0_650 VGND VGND VPWR VPWR sky130_fd_sc_hd__fill_1
XFILLER_0_661 VGND VGND VPWR VPWR sky130_fd_sc_hd__decap_4
XFILLER_208_413 VGND VGND VPWR VPWR sky130_fd_sc_hd__decap_6
XFILLER_85_51 VGND VGND VPWR VPWR sky130_fd_sc_hd__decap_4
XFILLER_208_457 VPWR VGND VPWR VGND sky130_ef_sc_hd__decap_12
XFILLER_169_1121 VPWR VGND VPWR VGND sky130_ef_sc_hd__decap_12
XFILLER_110_1518 VGND VGND VPWR VPWR sky130_fd_sc_hd__decap_6
XFILLER_211_27 VPWR VGND VPWR VGND sky130_ef_sc_hd__decap_12
XTAP_TAPCELL_ROW_180_1860 VGND VPWR sky130_fd_sc_hd__tapvpwrvgnd_1
XFILLER_165_1007 VGND VGND VPWR VPWR sky130_fd_sc_hd__fill_1
XFILLER_21_1272 VGND VGND VPWR VPWR sky130_fd_sc_hd__fill_1
XANTENNA_clkload1_A clknet_3_1_0_clk VGND VGND VPWR VPWR sky130_fd_sc_hd__diode_2
XFILLER_189_821 VPWR VGND VPWR VGND sky130_ef_sc_hd__decap_12
XTAP_TAPCELL_ROW_180_1882 VGND VPWR sky130_fd_sc_hd__tapvpwrvgnd_1
XTAP_TAPCELL_ROW_180_1871 VGND VPWR sky130_fd_sc_hd__tapvpwrvgnd_1
XANTENNA__437__A net147 VGND VGND VPWR VPWR sky130_fd_sc_hd__diode_2
XFILLER_56_1302 VPWR VGND VPWR VGND sky130_ef_sc_hd__decap_12
XFILLER_189_865 VPWR VGND VPWR VGND sky130_ef_sc_hd__decap_12
XFILLER_108_1414 VPWR VGND VPWR VGND sky130_ef_sc_hd__decap_12
XFILLER_95_1384 VGND VGND VPWR VPWR sky130_fd_sc_hd__fill_1
XFILLER_1_1399 VGND VGND VPWR VPWR sky130_fd_sc_hd__fill_1
XFILLER_206_1037 VPWR VGND VPWR VGND sky130_ef_sc_hd__decap_12
XFILLER_182_1365 VGND VGND VPWR VPWR sky130_fd_sc_hd__decap_6
XFILLER_147_1496 VGND VGND VPWR VPWR sky130_fd_sc_hd__fill_1
XFILLER_79_3 VPWR VGND VPWR VGND sky130_ef_sc_hd__decap_12
XFILLER_191_529 VPWR VGND VPWR VGND sky130_ef_sc_hd__decap_12
XFILLER_184_581 VGND VGND VPWR VPWR sky130_fd_sc_hd__decap_6
XTAP_TAPCELL_ROW_174_1686 VGND VPWR sky130_fd_sc_hd__tapvpwrvgnd_1
XFILLER_163_209 VPWR VGND VPWR VGND sky130_ef_sc_hd__decap_12
XTAP_TAPCELL_ROW_174_1697 VGND VPWR sky130_fd_sc_hd__tapvpwrvgnd_1
XFILLER_176_1147 VGND VGND VPWR VPWR sky130_fd_sc_hd__fill_1
XFILLER_119_1510 VPWR VGND VPWR VGND sky130_ef_sc_hd__decap_12
XFILLER_67_1442 VPWR VGND VPWR VGND sky130_ef_sc_hd__decap_12
XFILLER_217_1133 VPWR VGND VPWR VGND sky130_ef_sc_hd__decap_12
XFILLER_154_1412 VGND VGND VPWR VPWR sky130_fd_sc_hd__fill_1
XFILLER_28_1426 VPWR VGND VPWR VGND sky130_ef_sc_hd__decap_12
XFILLER_217_1177 VPWR VGND VPWR VGND sky130_ef_sc_hd__decap_12
XFILLER_119_1554 VPWR VGND VPWR VGND sky130_ef_sc_hd__decap_12
XFILLER_63_1328 VGND VGND VPWR VPWR sky130_fd_sc_hd__fill_1
XFILLER_105_39 VPWR VGND VPWR VGND sky130_ef_sc_hd__decap_12
XPHY_EDGE_ROW_122_1_Right_708 VGND VGND VPWR VPWR sky130_fd_sc_hd__decap_3
XTAP_TAPCELL_ROW_113_2_3711 VGND VPWR sky130_fd_sc_hd__tapvpwrvgnd_1
XFILLER_199_629 VPWR VGND VPWR VGND sky130_ef_sc_hd__decap_12
XFILLER_187_1287 VGND VGND VPWR VPWR sky130_fd_sc_hd__fill_1
XFILLER_121_27 VPWR VGND VPWR VGND sky130_ef_sc_hd__decap_12
XFILLER_39_1522 VPWR VGND VPWR VGND sky130_ef_sc_hd__decap_12
XFILLER_198_139 VGND VGND VPWR VPWR sky130_fd_sc_hd__fill_1
XFILLER_78_1582 VPWR VGND VPWR VGND sky130_ef_sc_hd__decap_12
XANTENNA__347__A net157 VGND VGND VPWR VPWR sky130_fd_sc_hd__diode_2
XFILLER_74_1468 VGND VGND VPWR VPWR sky130_fd_sc_hd__fill_1
XFILLER_39_1566 VPWR VGND VPWR VGND sky130_ef_sc_hd__decap_12
XTAP_TAPCELL_ROW_49_2_3296 VGND VPWR sky130_fd_sc_hd__tapvpwrvgnd_1
XFILLER_201_93 VPWR VGND VPWR VGND sky130_ef_sc_hd__decap_12
XFILLER_194_301 VGND VGND VPWR VPWR sky130_fd_sc_hd__decap_6
XFILLER_14_58 VGND VGND VPWR VPWR sky130_fd_sc_hd__decap_8
XFILLER_194_345 VPWR VGND VPWR VGND sky130_ef_sc_hd__decap_12
XFILLER_167_559 VGND VGND VPWR VPWR sky130_fd_sc_hd__fill_1
XFILLER_210_699 VGND VGND VPWR VPWR sky130_fd_sc_hd__fill_1
XFILLER_194_389 VPWR VGND VPWR VGND sky130_ef_sc_hd__decap_12
XFILLER_124_1282 VPWR VGND VPWR VGND sky130_ef_sc_hd__decap_12
XFILLER_194_1203 VGND VGND VPWR VPWR sky130_fd_sc_hd__fill_1
XFILLER_107_125 VGND VGND VPWR VPWR sky130_fd_sc_hd__fill_2
XFILLER_159_1378 VGND VGND VPWR VPWR sky130_fd_sc_hd__decap_6
XFILLER_102_1580 VGND VGND VPWR VPWR sky130_fd_sc_hd__fill_1
XTAP_TAPCELL_ROW_211_2760 VGND VPWR sky130_fd_sc_hd__tapvpwrvgnd_1
XFILLER_11_1496 VGND VGND VPWR VPWR sky130_fd_sc_hd__fill_1
XFILLER_46_1526 VPWR VGND VPWR VGND sky130_ef_sc_hd__decap_12
XFILLER_172_1589 VGND VGND VPWR VPWR sky130_fd_sc_hd__decap_6
XFILLER_39_55 VGND VGND VPWR VPWR sky130_fd_sc_hd__fill_1
XFILLER_131_1220 VPWR VGND VPWR VGND sky130_ef_sc_hd__decap_12
XANTENNA__589__CLK clknet_3_0_0_clk VGND VGND VPWR VPWR sky130_fd_sc_hd__diode_2
XFILLER_218_755 VGND VGND VPWR VPWR sky130_fd_sc_hd__fill_1
XFILLER_188_1029 VGND VGND VPWR VPWR sky130_fd_sc_hd__decap_6
XFILLER_183_3 VPWR VGND VPWR VGND sky130_ef_sc_hd__decap_12
X_611_ clknet_3_6_0_clk _045_ VGND VGND VPWR VPWR net67 sky130_fd_sc_hd__dfxtp_1
XFILLER_44_1294 VGND VGND VPWR VPWR sky130_fd_sc_hd__decap_6
XFILLER_206_917 VGND VGND VPWR VPWR sky130_fd_sc_hd__decap_6
XFILLER_205_405 VPWR VGND VPWR VGND sky130_ef_sc_hd__decap_12
XFILLER_131_1286 VPWR VGND VPWR VGND sky130_ef_sc_hd__decap_12
XFILLER_55_32 VPWR VGND VPWR VGND sky130_ef_sc_hd__decap_12
XTAP_TAPCELL_ROW_205_2586 VGND VPWR sky130_fd_sc_hd__tapvpwrvgnd_1
XFILLER_205_449 VPWR VGND VPWR VGND sky130_ef_sc_hd__decap_12
XTAP_TAPCELL_ROW_205_2575 VGND VPWR sky130_fd_sc_hd__tapvpwrvgnd_1
X_542_ net78 net124 VGND VGND VPWR VPWR _245_ sky130_fd_sc_hd__or2_1
XFILLER_214_961 VPWR VGND VPWR VGND sky130_ef_sc_hd__decap_12
XFILLER_207_1313 VPWR VGND VPWR VGND sky130_ef_sc_hd__decap_12
XTAP_TAPCELL_ROW_197_2365 VGND VPWR sky130_fd_sc_hd__tapvpwrvgnd_1
XTAP_TAPCELL_ROW_197_2354 VGND VPWR sky130_fd_sc_hd__tapvpwrvgnd_1
XTAP_TAPCELL_ROW_197_2343 VGND VPWR sky130_fd_sc_hd__tapvpwrvgnd_1
XFILLER_92_1524 VGND VGND VPWR VPWR sky130_fd_sc_hd__fill_1
X_473_ _172_ _183_ VGND VGND VPWR VPWR _205_ sky130_fd_sc_hd__nand2_1
XTAP_TAPCELL_ROW_193_2229 VGND VPWR sky130_fd_sc_hd__tapvpwrvgnd_1
XFILLER_186_813 VPWR VGND VPWR VGND sky130_ef_sc_hd__decap_12
XFILLER_207_1357 VPWR VGND VPWR VGND sky130_ef_sc_hd__decap_12
XFILLER_200_121 VPWR VGND VPWR VGND sky130_ef_sc_hd__decap_12
XFILLER_197_161 VGND VGND VPWR VPWR sky130_fd_sc_hd__decap_6
XFILLER_164_1073 VPWR VGND VPWR VGND sky130_ef_sc_hd__decap_12
XFILLER_111_93 VPWR VGND VPWR VGND sky130_ef_sc_hd__decap_12
XTAP_TAPCELL_ROW_218_2958 VGND VPWR sky130_fd_sc_hd__tapvpwrvgnd_1
XTAP_TAPCELL_ROW_218_2947 VGND VPWR sky130_fd_sc_hd__tapvpwrvgnd_1
XFILLER_200_165 VPWR VGND VPWR VGND sky130_ef_sc_hd__decap_12
XFILLER_90_1270 VPWR VGND VPWR VGND sky130_ef_sc_hd__decap_12
XFILLER_51_1232 VPWR VGND VPWR VGND sky130_ef_sc_hd__decap_12
XFILLER_199_1169 VGND VGND VPWR VPWR sky130_fd_sc_hd__decap_6
XFILLER_177_1401 VPWR VGND VPWR VGND sky130_ef_sc_hd__decap_12
XFILLER_173_529 VPWR VGND VPWR VGND sky130_ef_sc_hd__decap_12
XFILLER_142_1382 VPWR VGND VPWR VGND sky130_ef_sc_hd__decap_12
XFILLER_103_1322 VGND VGND VPWR VPWR sky130_fd_sc_hd__decap_6
XFILLER_166_581 VGND VGND VPWR VPWR sky130_fd_sc_hd__decap_6
XFILLER_103_1366 VPWR VGND VPWR VGND sky130_ef_sc_hd__decap_12
XFILLER_51_1298 VPWR VGND VPWR VGND sky130_ef_sc_hd__decap_12
XFILLER_181_573 VPWR VGND VPWR VGND sky130_ef_sc_hd__decap_12
XFILLER_4_241 VGND VGND VPWR VPWR sky130_fd_sc_hd__decap_8
XFILLER_5_797 VGND VGND VPWR VPWR sky130_fd_sc_hd__decap_4
XPHY_EDGE_ROW_26_2_Right_83 VGND VGND VPWR VPWR sky130_fd_sc_hd__decap_3
XFILLER_218_1453 VPWR VGND VPWR VGND sky130_ef_sc_hd__decap_12
XFILLER_214_1317 VPWR VGND VPWR VGND sky130_ef_sc_hd__decap_12
XFILLER_206_27 VGND VGND VPWR VPWR sky130_fd_sc_hd__fill_1
XTAP_TAPCELL_ROW_118_2_3748 VGND VPWR sky130_fd_sc_hd__tapvpwrvgnd_1
XFILLER_218_1497 VPWR VGND VPWR VGND sky130_ef_sc_hd__decap_12
XFILLER_171_1033 VPWR VGND VPWR VGND sky130_ef_sc_hd__decap_12
XTAP_TAPCELL_ROW_86_2_3537 VGND VPWR sky130_fd_sc_hd__tapvpwrvgnd_1
XFILLER_171_1077 VPWR VGND VPWR VGND sky130_ef_sc_hd__decap_12
XFILLER_96_83 VGND VGND VPWR VPWR sky130_fd_sc_hd__fill_1
XFILLER_0_480 VGND VGND VPWR VPWR sky130_fd_sc_hd__fill_1
XFILLER_7_1553 VPWR VGND VPWR VGND sky130_ef_sc_hd__decap_12
XFILLER_62_1350 VGND VGND VPWR VPWR sky130_fd_sc_hd__decap_6
XFILLER_208_221 VPWR VGND VPWR VGND sky130_ef_sc_hd__decap_12
XTAP_TAPCELL_ROW_182_1933 VGND VPWR sky130_fd_sc_hd__tapvpwrvgnd_1
XTAP_TAPCELL_ROW_182_1922 VGND VPWR sky130_fd_sc_hd__tapvpwrvgnd_1
XTAP_TAPCELL_ROW_167_1490 VGND VPWR sky130_fd_sc_hd__tapvpwrvgnd_1
XFILLER_114_1462 VGND VGND VPWR VPWR sky130_fd_sc_hd__decap_6
XFILLER_7_1597 VGND VGND VPWR VPWR sky130_fd_sc_hd__decap_8
XFILLER_62_1394 VPWR VGND VPWR VGND sky130_ef_sc_hd__decap_12
XFILLER_212_1085 VGND VGND VPWR VPWR sky130_fd_sc_hd__decap_6
XFILLER_209_777 VGND VGND VPWR VPWR sky130_fd_sc_hd__decap_6
XFILLER_208_265 VPWR VGND VPWR VGND sky130_ef_sc_hd__decap_12
XFILLER_188_1541 VPWR VGND VPWR VGND sky130_ef_sc_hd__decap_12
XTAP_TAPCELL_ROW_163_1365 VGND VPWR sky130_fd_sc_hd__tapvpwrvgnd_1
XTAP_TAPCELL_ROW_163_1354 VGND VPWR sky130_fd_sc_hd__tapvpwrvgnd_1
XTAP_TAPCELL_ROW_163_1343 VGND VPWR sky130_fd_sc_hd__tapvpwrvgnd_1
XFILLER_110_1326 VPWR VGND VPWR VGND sky130_ef_sc_hd__decap_12
XFILLER_23_1378 VGND VGND VPWR VPWR sky130_fd_sc_hd__decap_6
XFILLER_184_1427 VGND VGND VPWR VPWR sky130_fd_sc_hd__fill_1
XTAP_TAPCELL_ROW_163_1398 VGND VPWR sky130_fd_sc_hd__tapvpwrvgnd_1
XTAP_TAPCELL_ROW_163_1387 VGND VPWR sky130_fd_sc_hd__tapvpwrvgnd_1
XTAP_TAPCELL_ROW_163_1376 VGND VPWR sky130_fd_sc_hd__tapvpwrvgnd_1
XFILLER_189_673 VPWR VGND VPWR VGND sky130_ef_sc_hd__decap_12
XFILLER_182_1173 VPWR VGND VPWR VGND sky130_ef_sc_hd__decap_12
XFILLER_176_301 VGND VGND VPWR VPWR sky130_fd_sc_hd__decap_6
XFILLER_108_1244 VGND VGND VPWR VPWR sky130_fd_sc_hd__fill_1
XFILLER_192_805 VGND VGND VPWR VPWR sky130_fd_sc_hd__decap_6
XTAP_TAPCELL_ROW_176_1759 VGND VPWR sky130_fd_sc_hd__tapvpwrvgnd_1
XTAP_TAPCELL_ROW_176_1748 VGND VPWR sky130_fd_sc_hd__tapvpwrvgnd_1
XFILLER_176_345 VPWR VGND VPWR VGND sky130_ef_sc_hd__decap_12
XFILLER_73_1490 VGND VGND VPWR VPWR sky130_fd_sc_hd__decap_6
XFILLER_192_849 VPWR VGND VPWR VGND sky130_ef_sc_hd__decap_12
XFILLER_176_389 VPWR VGND VPWR VGND sky130_ef_sc_hd__decap_12
XFILLER_160_1482 VPWR VGND VPWR VGND sky130_ef_sc_hd__decap_12
XPHY_EDGE_ROW_143_2_Left_575 VGND VGND VPWR VPWR sky130_fd_sc_hd__decap_3
XFILLER_121_1422 VPWR VGND VPWR VGND sky130_ef_sc_hd__decap_12
Xclkbuf_3_7_0_clk clknet_0_clk VGND VGND VPWR VPWR clknet_3_7_0_clk sky130_fd_sc_hd__clkbuf_8
XFILLER_191_337 VPWR VGND VPWR VGND sky130_ef_sc_hd__decap_12
XFILLER_121_1466 VPWR VGND VPWR VGND sky130_ef_sc_hd__decap_12
XFILLER_30_1338 VPWR VGND VPWR VGND sky130_ef_sc_hd__decap_12
XFILLER_219_1217 VPWR VGND VPWR VGND sky130_ef_sc_hd__decap_12
XFILLER_195_1567 VGND VGND VPWR VPWR sky130_fd_sc_hd__fill_1
XFILLER_156_1518 VGND VGND VPWR VPWR sky130_fd_sc_hd__decap_6
XPHY_EDGE_ROW_80_2_Left_512 VGND VGND VPWR VPWR sky130_fd_sc_hd__decap_3
XFILLER_6_81 VGND VGND VPWR VPWR sky130_fd_sc_hd__decap_3
XFILLER_154_1220 VPWR VGND VPWR VGND sky130_ef_sc_hd__decap_12
XFILLER_116_27 VGND VGND VPWR VPWR sky130_fd_sc_hd__fill_1
XFILLER_67_1272 VGND VGND VPWR VPWR sky130_fd_sc_hd__fill_1
XFILLER_119_1384 VGND VGND VPWR VPWR sky130_fd_sc_hd__fill_1
XFILLER_80_1450 VPWR VGND VPWR VGND sky130_ef_sc_hd__decap_12
XFILLER_132_1562 VPWR VGND VPWR VGND sky130_ef_sc_hd__decap_12
XFILLER_132_15 VPWR VGND VPWR VGND sky130_ef_sc_hd__decap_12
XPHY_EDGE_ROW_123_1_Right_709 VGND VGND VPWR VPWR sky130_fd_sc_hd__decap_3
XFILLER_80_1494 VPWR VGND VPWR VGND sky130_ef_sc_hd__decap_12
XFILLER_41_1434 VGND VGND VPWR VPWR sky130_fd_sc_hd__decap_6
XFILLER_6_1085 VGND VGND VPWR VPWR sky130_fd_sc_hd__decap_6
XFILLER_41_1478 VPWR VGND VPWR VGND sky130_ef_sc_hd__decap_12
XFILLER_203_909 VPWR VGND VPWR VGND sky130_ef_sc_hd__decap_12
XFILLER_39_1330 VPWR VGND VPWR VGND sky130_ef_sc_hd__decap_12
XFILLER_202_419 VGND VGND VPWR VPWR sky130_fd_sc_hd__fill_1
XTAP_TAPCELL_ROW_200_2450 VGND VPWR sky130_fd_sc_hd__tapvpwrvgnd_1
XFILLER_186_109 VPWR VGND VPWR VGND sky130_ef_sc_hd__decap_12
XFILLER_168_813 VPWR VGND VPWR VGND sky130_ef_sc_hd__decap_12
XFILLER_126_1300 VGND VGND VPWR VPWR sky130_fd_sc_hd__fill_1
XFILLER_74_1232 VPWR VGND VPWR VGND sky130_ef_sc_hd__decap_12
XANTENNA_u_sram.u_mem_dout0[11] net91 VGND VGND VPWR VPWR sky130_fd_sc_hd__diode_2
XFILLER_25_57 VPWR VGND VPWR VGND sky130_ef_sc_hd__decap_12
XFILLER_211_953 VPWR VGND VPWR VGND sky130_ef_sc_hd__decap_12
XFILLER_179_161 VGND VGND VPWR VPWR sky130_fd_sc_hd__decap_6
XFILLER_165_1393 VGND VGND VPWR VPWR sky130_fd_sc_hd__decap_6
XFILLER_195_665 VGND VGND VPWR VPWR sky130_fd_sc_hd__decap_6
XFILLER_161_1268 VGND VGND VPWR VPWR sky130_fd_sc_hd__decap_4
XFILLER_91_1590 VPWR VGND VPWR VGND sky130_ef_sc_hd__decap_12
XTAP_TAPCELL_ROW_79_2_3491 VGND VPWR sky130_fd_sc_hd__tapvpwrvgnd_1
XTAP_TAPCELL_ROW_213_2800 VGND VPWR sky130_fd_sc_hd__tapvpwrvgnd_1
XFILLER_196_1309 VGND VGND VPWR VPWR sky130_fd_sc_hd__decap_6
XFILLER_194_153 VPWR VGND VPWR VGND sky130_ef_sc_hd__decap_12
XANTENNA__524__B net125 VGND VGND VPWR VPWR sky130_fd_sc_hd__diode_2
XFILLER_52_1574 VGND VGND VPWR VPWR sky130_fd_sc_hd__decap_6
XTAP_TAPCELL_ROW_213_2822 VGND VPWR sky130_fd_sc_hd__tapvpwrvgnd_1
XTAP_TAPCELL_ROW_213_2811 VGND VPWR sky130_fd_sc_hd__tapvpwrvgnd_1
XFILLER_194_197 VPWR VGND VPWR VGND sky130_ef_sc_hd__decap_12
XFILLER_100_1506 VPWR VGND VPWR VGND sky130_ef_sc_hd__decap_12
XFILLER_163_573 VPWR VGND VPWR VGND sky130_ef_sc_hd__decap_12
XTAP_TAPCELL_ROW_104_2_3656 VGND VPWR sky130_fd_sc_hd__tapvpwrvgnd_1
XTAP_TAPCELL_ROW_91_1_1200 VGND VPWR sky130_fd_sc_hd__tapvpwrvgnd_1
XFILLER_2_701 VGND VGND VPWR VPWR sky130_fd_sc_hd__decap_6
XTAP_TAPCELL_ROW_186_2044 VGND VPWR sky130_fd_sc_hd__tapvpwrvgnd_1
XTAP_TAPCELL_ROW_186_2033 VGND VPWR sky130_fd_sc_hd__tapvpwrvgnd_1
XFILLER_137_1440 VGND VGND VPWR VPWR sky130_fd_sc_hd__fill_1
XTAP_TAPCELL_ROW_72_2_3445 VGND VPWR sky130_fd_sc_hd__tapvpwrvgnd_1
XFILLER_2_767 VGND VGND VPWR VPWR sky130_fd_sc_hd__fill_1
XFILLER_9_3 VPWR VGND VPWR VGND sky130_ef_sc_hd__decap_12
XTAP_TAPCELL_ROW_186_2055 VGND VPWR sky130_fd_sc_hd__tapvpwrvgnd_1
XFILLER_173_55 VGND VGND VPWR VPWR sky130_fd_sc_hd__fill_1
XFILLER_172_1353 VPWR VGND VPWR VGND sky130_ef_sc_hd__decap_12
XFILLER_110_109 VPWR VGND VPWR VGND sky130_ef_sc_hd__decap_12
XFILLER_46_1356 VGND VGND VPWR VPWR sky130_fd_sc_hd__fill_1
XTAP_TAPCELL_ROW_207_2626 VGND VPWR sky130_fd_sc_hd__tapvpwrvgnd_1
XFILLER_172_1397 VPWR VGND VPWR VGND sky130_ef_sc_hd__decap_12
XTAP_TAPCELL_ROW_207_2648 VGND VPWR sky130_fd_sc_hd__tapvpwrvgnd_1
XTAP_TAPCELL_ROW_207_2637 VGND VPWR sky130_fd_sc_hd__tapvpwrvgnd_1
XFILLER_111_1602 VGND VGND VPWR VPWR sky130_fd_sc_hd__decap_3
XFILLER_66_53 VPWR VGND VPWR VGND sky130_ef_sc_hd__decap_12
XTAP_TAPCELL_ROW_199_2416 VGND VPWR sky130_fd_sc_hd__tapvpwrvgnd_1
XTAP_TAPCELL_ROW_199_2405 VGND VPWR sky130_fd_sc_hd__tapvpwrvgnd_1
XFILLER_66_97 VPWR VGND VPWR VGND sky130_ef_sc_hd__decap_12
XFILLER_20_1518 VGND VGND VPWR VPWR sky130_fd_sc_hd__decap_6
XFILLER_206_725 VPWR VGND VPWR VGND sky130_ef_sc_hd__decap_12
XPHY_EDGE_ROW_139_1_Left_358 VGND VGND VPWR VPWR sky130_fd_sc_hd__decap_3
XFILLER_206_769 VPWR VGND VPWR VGND sky130_ef_sc_hd__decap_12
XFILLER_82_41 VPWR VGND VPWR VGND sky130_ef_sc_hd__decap_12
XFILLER_2_1483 VGND VGND VPWR VPWR sky130_fd_sc_hd__fill_1
X_525_ net151 _184_ net130 net138 _236_ VGND VGND VPWR VPWR _046_ sky130_fd_sc_hd__o311a_1
XFILLER_207_1121 VPWR VGND VPWR VGND sky130_ef_sc_hd__decap_12
XFILLER_205_279 VGND VGND VPWR VPWR sky130_fd_sc_hd__fill_1
XFILLER_198_41 VPWR VGND VPWR VGND sky130_ef_sc_hd__decap_12
XFILLER_148_1580 VGND VGND VPWR VPWR sky130_fd_sc_hd__fill_1
XFILLER_18_1414 VPWR VGND VPWR VGND sky130_ef_sc_hd__decap_12
XFILLER_183_1493 VPWR VGND VPWR VGND sky130_ef_sc_hd__decap_12
XFILLER_82_85 VPWR VGND VPWR VGND sky130_ef_sc_hd__decap_12
X_456_ net146 net95 VGND VGND VPWR VPWR _188_ sky130_fd_sc_hd__xor2_1
XFILLER_57_1496 VGND VGND VPWR VPWR sky130_fd_sc_hd__fill_1
XFILLER_203_1007 VGND VGND VPWR VPWR sky130_fd_sc_hd__fill_1
XFILLER_201_441 VGND VGND VPWR VPWR sky130_fd_sc_hd__decap_6
XFILLER_198_85 VPWR VGND VPWR VGND sky130_ef_sc_hd__decap_12
XFILLER_186_643 VGND VGND VPWR VPWR sky130_fd_sc_hd__fill_1
XFILLER_174_805 VGND VGND VPWR VPWR sky130_fd_sc_hd__decap_6
X_387_ b_addr\[1\] _102_ VGND VGND VPWR VPWR _126_ sky130_fd_sc_hd__and2_1
XFILLER_201_485 VPWR VGND VPWR VGND sky130_ef_sc_hd__decap_12
XFILLER_174_849 VPWR VGND VPWR VGND sky130_ef_sc_hd__decap_12
XFILLER_173_337 VPWR VGND VPWR VGND sky130_ef_sc_hd__decap_12
XTAP_TAPCELL_ROW_171_1623 VGND VPWR sky130_fd_sc_hd__tapvpwrvgnd_1
XTAP_TAPCELL_ROW_171_1612 VGND VPWR sky130_fd_sc_hd__tapvpwrvgnd_1
XTAP_TAPCELL_ROW_171_1601 VGND VPWR sky130_fd_sc_hd__tapvpwrvgnd_1
XFILLER_217_15 VPWR VGND VPWR VGND sky130_ef_sc_hd__decap_12
XFILLER_177_1231 VGND VGND VPWR VPWR sky130_fd_sc_hd__fill_1
Xoutput107 net107 VGND VGND VPWR VPWR func_rdata[26] sky130_fd_sc_hd__buf_2
XFILLER_182_893 VPWR VGND VPWR VGND sky130_ef_sc_hd__decap_12
Xoutput118 net118 VGND VGND VPWR VPWR func_rdata[7] sky130_fd_sc_hd__buf_2
XFILLER_5_561 VGND VGND VPWR VPWR sky130_fd_sc_hd__fill_1
XFILLER_29_1510 VPWR VGND VPWR VGND sky130_ef_sc_hd__decap_12
XFILLER_64_1412 VGND VGND VPWR VPWR sky130_fd_sc_hd__fill_1
XFILLER_218_1261 VPWR VGND VPWR VGND sky130_ef_sc_hd__decap_12
XFILLER_190_1453 VPWR VGND VPWR VGND sky130_ef_sc_hd__decap_12
XFILLER_116_1524 VGND VGND VPWR VPWR sky130_fd_sc_hd__fill_1
XFILLER_29_1554 VPWR VGND VPWR VGND sky130_ef_sc_hd__decap_12
XFILLER_214_1147 VGND VGND VPWR VPWR sky130_fd_sc_hd__fill_1
XFILLER_190_1497 VPWR VGND VPWR VGND sky130_ef_sc_hd__decap_12
XTAP_TAPCELL_ROW_169_1563 VGND VPWR sky130_fd_sc_hd__tapvpwrvgnd_1
XTAP_TAPCELL_ROW_169_1552 VGND VPWR sky130_fd_sc_hd__tapvpwrvgnd_1
XTAP_TAPCELL_ROW_148_2_3943 VGND VPWR sky130_fd_sc_hd__tapvpwrvgnd_1
XTAP_TAPCELL_ROW_165_1449 VGND VPWR sky130_fd_sc_hd__tapvpwrvgnd_1
XTAP_TAPCELL_ROW_165_1438 VGND VPWR sky130_fd_sc_hd__tapvpwrvgnd_1
XFILLER_209_541 VPWR VGND VPWR VGND sky130_ef_sc_hd__decap_12
XFILLER_114_1270 VPWR VGND VPWR VGND sky130_ef_sc_hd__decap_12
XFILLER_3_1225 VGND VGND VPWR VPWR sky130_fd_sc_hd__decap_6
XFILLER_209_585 VPWR VGND VPWR VGND sky130_ef_sc_hd__decap_12
XFILLER_188_1371 VGND VGND VPWR VPWR sky130_fd_sc_hd__fill_1
XFILLER_149_1322 VGND VGND VPWR VPWR sky130_fd_sc_hd__decap_6
XFILLER_97_1232 VPWR VGND VPWR VGND sky130_ef_sc_hd__decap_12
XFILLER_3_1269 VPWR VGND VPWR VGND sky130_ef_sc_hd__decap_12
XFILLER_149_1366 VPWR VGND VPWR VGND sky130_ef_sc_hd__decap_12
XFILLER_102_29 VPWR VGND VPWR VGND sky130_ef_sc_hd__decap_12
XFILLER_97_1298 VPWR VGND VPWR VGND sky130_ef_sc_hd__decap_12
XFILLER_23_104 VGND VGND VPWR VPWR sky130_fd_sc_hd__decap_8
XFILLER_211_205 VPWR VGND VPWR VGND sky130_ef_sc_hd__decap_12
XFILLER_75_1552 VGND VGND VPWR VPWR sky130_fd_sc_hd__fill_1
XFILLER_211_249 VPWR VGND VPWR VGND sky130_ef_sc_hd__decap_12
XFILLER_168_109 VPWR VGND VPWR VGND sky130_ef_sc_hd__decap_12
XPHY_EDGE_ROW_60_1_Left_279 VGND VGND VPWR VPWR sky130_fd_sc_hd__decap_3
XFILLER_177_665 VGND VGND VPWR VPWR sky130_fd_sc_hd__decap_6
XFILLER_192_613 VPWR VGND VPWR VGND sky130_ef_sc_hd__decap_12
XFILLER_176_153 VPWR VGND VPWR VGND sky130_ef_sc_hd__decap_12
XANTENNA_fanout136_A net139 VGND VGND VPWR VPWR sky130_fd_sc_hd__diode_2
XFILLER_192_657 VPWR VGND VPWR VGND sky130_ef_sc_hd__decap_12
XFILLER_178_1017 VPWR VGND VPWR VGND sky130_ef_sc_hd__decap_12
XFILLER_176_197 VPWR VGND VPWR VGND sky130_ef_sc_hd__decap_12
XFILLER_11_15 VPWR VGND VPWR VGND sky130_ef_sc_hd__decap_12
XFILLER_34_1282 VPWR VGND VPWR VGND sky130_ef_sc_hd__decap_12
XFILLER_191_167 VGND VGND VPWR VPWR sky130_fd_sc_hd__fill_1
XFILLER_127_15 VPWR VGND VPWR VGND sky130_ef_sc_hd__decap_12
XFILLER_121_1274 VPWR VGND VPWR VGND sky130_ef_sc_hd__decap_12
XFILLER_156_1326 VPWR VGND VPWR VGND sky130_ef_sc_hd__decap_12
XFILLER_69_1378 VGND VGND VPWR VPWR sky130_fd_sc_hd__decap_6
XFILLER_12_1580 VGND VGND VPWR VPWR sky130_fd_sc_hd__fill_1
XTAP_TAPCELL_ROW_57_2_3347 VGND VPWR sky130_fd_sc_hd__tapvpwrvgnd_1
XFILLER_207_81 VPWR VGND VPWR VGND sky130_ef_sc_hd__decap_12
XFILLER_134_1602 VGND VGND VPWR VPWR sky130_fd_sc_hd__decap_3
XFILLER_219_305 VGND VGND VPWR VPWR sky130_fd_sc_hd__decap_3
XFILLER_219_349 VPWR VGND VPWR VGND sky130_ef_sc_hd__decap_12
XFILLER_189_1113 VGND VGND VPWR VPWR sky130_fd_sc_hd__decap_6
XFILLER_143_69 VPWR VGND VPWR VGND sky130_ef_sc_hd__decap_12
XFILLER_41_1220 VPWR VGND VPWR VGND sky130_ef_sc_hd__decap_12
XFILLER_189_1157 VPWR VGND VPWR VGND sky130_ef_sc_hd__decap_12
XFILLER_132_1370 VPWR VGND VPWR VGND sky130_ef_sc_hd__decap_12
XTAP_TAPCELL_ROW_202_2501 VGND VPWR sky130_fd_sc_hd__tapvpwrvgnd_1
XFILLER_41_1286 VPWR VGND VPWR VGND sky130_ef_sc_hd__decap_12
XFILLER_210_1589 VGND VGND VPWR VPWR sky130_fd_sc_hd__decap_6
XFILLER_199_223 VGND VGND VPWR VPWR sky130_fd_sc_hd__fill_1
XFILLER_167_1455 VGND VGND VPWR VPWR sky130_fd_sc_hd__fill_1
XFILLER_128_1406 VGND VGND VPWR VPWR sky130_fd_sc_hd__decap_6
XFILLER_76_1338 VPWR VGND VPWR VGND sky130_ef_sc_hd__decap_12
XANTENNA__627__CLK clknet_3_2_0_clk VGND VGND VPWR VPWR sky130_fd_sc_hd__diode_2
X_310_ net20 net144 net133 VGND VGND VPWR VPWR s_wdata\[17\] sky130_fd_sc_hd__a21o_1
XFILLER_208_1441 VPWR VGND VPWR VGND sky130_ef_sc_hd__decap_12
XFILLER_187_429 VPWR VGND VPWR VGND sky130_ef_sc_hd__decap_12
XFILLER_208_1485 VPWR VGND VPWR VGND sky130_ef_sc_hd__decap_12
XFILLER_168_643 VGND VGND VPWR VPWR sky130_fd_sc_hd__fill_1
XFILLER_146_3 VPWR VGND VPWR VGND sky130_ef_sc_hd__decap_12
XANTENNA_clkbuf_3_2_0_clk_X clknet_3_2_0_clk VGND VGND VPWR VPWR sky130_fd_sc_hd__diode_2
XFILLER_211_783 VGND VGND VPWR VPWR sky130_fd_sc_hd__fill_1
XFILLER_195_473 VPWR VGND VPWR VGND sky130_ef_sc_hd__decap_12
XFILLER_52_77 VGND VGND VPWR VPWR sky130_fd_sc_hd__decap_6
XFILLER_196_1117 VPWR VGND VPWR VGND sky130_ef_sc_hd__decap_12
XFILLER_168_77 VGND VGND VPWR VPWR sky130_fd_sc_hd__decap_6
XFILLER_104_1450 VPWR VGND VPWR VGND sky130_ef_sc_hd__decap_12
XFILLER_13_1322 VGND VGND VPWR VPWR sky130_fd_sc_hd__decap_6
XFILLER_52_1382 VPWR VGND VPWR VGND sky130_ef_sc_hd__decap_12
XFILLER_202_1073 VPWR VGND VPWR VGND sky130_ef_sc_hd__decap_12
XFILLER_170_307 VGND VGND VPWR VPWR sky130_fd_sc_hd__fill_1
XFILLER_104_1494 VPWR VGND VPWR VGND sky130_ef_sc_hd__decap_12
XFILLER_100_1314 VPWR VGND VPWR VGND sky130_ef_sc_hd__decap_12
XFILLER_87_1434 VGND VGND VPWR VPWR sky130_fd_sc_hd__decap_6
XANTENNA__499__A1 net151 VGND VGND VPWR VPWR sky130_fd_sc_hd__diode_2
XFILLER_13_1366 VPWR VGND VPWR VGND sky130_ef_sc_hd__decap_12
XTAP_TAPCELL_ROW_188_2106 VGND VPWR sky130_fd_sc_hd__tapvpwrvgnd_1
XFILLER_182_189 VGND VGND VPWR VPWR sky130_fd_sc_hd__decap_6
XFILLER_164_893 VPWR VGND VPWR VGND sky130_ef_sc_hd__decap_12
XFILLER_100_1358 VPWR VGND VPWR VGND sky130_ef_sc_hd__decap_12
XFILLER_184_65 VPWR VGND VPWR VGND sky130_ef_sc_hd__decap_12
XFILLER_178_1595 VGND VGND VPWR VPWR sky130_fd_sc_hd__fill_1
XFILLER_139_1546 VGND VGND VPWR VPWR sky130_fd_sc_hd__decap_6
XTAP_TAPCELL_ROW_123_1_1263 VGND VPWR sky130_fd_sc_hd__tapvpwrvgnd_1
XFILLER_87_1478 VPWR VGND VPWR VGND sky130_ef_sc_hd__decap_12
XFILLER_219_1581 VPWR VGND VPWR VGND sky130_ef_sc_hd__decap_12
XFILLER_215_1401 VPWR VGND VPWR VGND sky130_ef_sc_hd__decap_12
XTAP_TAPCELL_ROW_134_2_3851 VGND VPWR sky130_fd_sc_hd__tapvpwrvgnd_1
XFILLER_117_81 VPWR VGND VPWR VGND sky130_ef_sc_hd__decap_12
XFILLER_172_1161 VPWR VGND VPWR VGND sky130_ef_sc_hd__decap_12
XFILLER_150_1470 VPWR VGND VPWR VGND sky130_ef_sc_hd__decap_12
XFILLER_115_1590 VPWR VGND VPWR VGND sky130_ef_sc_hd__decap_12
XFILLER_111_1410 VPWR VGND VPWR VGND sky130_ef_sc_hd__decap_12
XFILLER_24_1462 VGND VGND VPWR VPWR sky130_fd_sc_hd__decap_6
XFILLER_203_39 VPWR VGND VPWR VGND sky130_ef_sc_hd__decap_12
XFILLER_185_1511 VGND VGND VPWR VPWR sky130_fd_sc_hd__fill_1
XFILLER_111_1454 VPWR VGND VPWR VGND sky130_ef_sc_hd__decap_12
XFILLER_93_51 VGND VGND VPWR VPWR sky130_fd_sc_hd__decap_4
XFILLER_20_1326 VPWR VGND VPWR VGND sky130_ef_sc_hd__decap_12
XFILLER_206_533 VPWR VGND VPWR VGND sky130_ef_sc_hd__decap_12
XFILLER_111_1498 VPWR VGND VPWR VGND sky130_ef_sc_hd__decap_12
XFILLER_98_1574 VGND VGND VPWR VPWR sky130_fd_sc_hd__decap_6
XFILLER_94_1438 VPWR VGND VPWR VGND sky130_ef_sc_hd__decap_12
XFILLER_4_1589 VGND VGND VPWR VPWR sky130_fd_sc_hd__decap_6
XFILLER_146_1506 VPWR VGND VPWR VGND sky130_ef_sc_hd__decap_12
XPHY_EDGE_ROW_188_Left_407 VGND VGND VPWR VPWR sky130_fd_sc_hd__decap_3
X_508_ net60 net126 VGND VGND VPWR VPWR _228_ sky130_fd_sc_hd__or2_1
X_439_ net148 net105 VGND VGND VPWR VPWR _171_ sky130_fd_sc_hd__xor2_1
XFILLER_18_1244 VGND VGND VPWR VPWR sky130_fd_sc_hd__fill_1
XFILLER_174_613 VPWR VGND VPWR VGND sky130_ef_sc_hd__decap_12
XFILLER_201_293 VPWR VGND VPWR VGND sky130_ef_sc_hd__decap_12
XFILLER_179_1337 VGND VGND VPWR VPWR sky130_fd_sc_hd__decap_6
XFILLER_122_1550 VPWR VGND VPWR VGND sky130_ef_sc_hd__decap_12
XFILLER_70_1482 VPWR VGND VPWR VGND sky130_ef_sc_hd__decap_12
XFILLER_31_1422 VPWR VGND VPWR VGND sky130_ef_sc_hd__decap_12
XFILLER_174_657 VPWR VGND VPWR VGND sky130_ef_sc_hd__decap_12
XFILLER_31_1466 VPWR VGND VPWR VGND sky130_ef_sc_hd__decap_12
XTAP_TAPCELL_ROW_43_2_3255 VGND VPWR sky130_fd_sc_hd__tapvpwrvgnd_1
XFILLER_61_3 VPWR VGND VPWR VGND sky130_ef_sc_hd__decap_12
XFILLER_173_167 VGND VGND VPWR VPWR sky130_fd_sc_hd__fill_1
XFILLER_157_1602 VGND VGND VPWR VPWR sky130_fd_sc_hd__decap_3
XFILLER_122_1594 VGND VGND VPWR VPWR sky130_fd_sc_hd__decap_8
XFILLER_66_1518 VGND VGND VPWR VPWR sky130_fd_sc_hd__decap_6
XFILLER_6_881 VPWR VGND VPWR VGND sky130_ef_sc_hd__decap_12
XPHY_EDGE_ROW_197_Left_416 VGND VGND VPWR VPWR sky130_fd_sc_hd__decap_3
XFILLER_5_391 VGND VGND VPWR VPWR sky130_fd_sc_hd__fill_1
XFILLER_64_1220 VPWR VGND VPWR VGND sky130_ef_sc_hd__decap_12
XFILLER_218_1091 VGND VGND VPWR VPWR sky130_fd_sc_hd__fill_1
XFILLER_190_1261 VPWR VGND VPWR VGND sky130_ef_sc_hd__decap_12
XFILLER_9_1434 VGND VGND VPWR VPWR sky130_fd_sc_hd__decap_6
XFILLER_29_1384 VGND VGND VPWR VPWR sky130_fd_sc_hd__fill_1
XFILLER_151_1256 VPWR VGND VPWR VGND sky130_ef_sc_hd__decap_12
XFILLER_9_1478 VPWR VGND VPWR VGND sky130_ef_sc_hd__decap_12
XFILLER_217_809 VPWR VGND VPWR VGND sky130_ef_sc_hd__decap_12
XFILLER_3_93 VPWR VGND VPWR VGND sky130_ef_sc_hd__decap_12
XFILLER_42_1562 VPWR VGND VPWR VGND sky130_ef_sc_hd__decap_12
XTAP_TAPCELL_ROW_148_1_1314 VGND VPWR sky130_fd_sc_hd__tapvpwrvgnd_1
XFILLER_113_39 VPWR VGND VPWR VGND sky130_ef_sc_hd__decap_12
XFILLER_3_1033 VPWR VGND VPWR VGND sky130_ef_sc_hd__decap_12
XFILLER_209_393 VPWR VGND VPWR VGND sky130_ef_sc_hd__decap_12
XFILLER_3_1077 VPWR VGND VPWR VGND sky130_ef_sc_hd__decap_12
XTAP_TAPCELL_ROW_219_3017 VGND VPWR sky130_fd_sc_hd__tapvpwrvgnd_1
XTAP_TAPCELL_ROW_219_3006 VGND VPWR sky130_fd_sc_hd__tapvpwrvgnd_1
XFILLER_212_525 VGND VGND VPWR VPWR sky130_fd_sc_hd__decap_6
XFILLER_197_727 VGND VGND VPWR VPWR sky130_fd_sc_hd__fill_1
XFILLER_169_429 VPWR VGND VPWR VGND sky130_ef_sc_hd__decap_12
XFILLER_36_1300 VGND VGND VPWR VPWR sky130_fd_sc_hd__fill_1
XFILLER_212_569 VPWR VGND VPWR VGND sky130_ef_sc_hd__decap_12
XFILLER_177_473 VPWR VGND VPWR VGND sky130_ef_sc_hd__decap_12
XFILLER_71_1268 VGND VGND VPWR VPWR sky130_fd_sc_hd__decap_4
XANTENNA_fanout139_X net139 VGND VGND VPWR VPWR sky130_fd_sc_hd__diode_2
XFILLER_193_933 VPWR VGND VPWR VGND sky130_ef_sc_hd__decap_12
XFILLER_192_421 VPWR VGND VPWR VGND sky130_ef_sc_hd__decap_12
XFILLER_203_1393 VGND VGND VPWR VPWR sky130_fd_sc_hd__decap_6
XFILLER_197_1437 VPWR VGND VPWR VGND sky130_ef_sc_hd__decap_12
XFILLER_193_977 VPWR VGND VPWR VGND sky130_ef_sc_hd__decap_12
XFILLER_10_1506 VPWR VGND VPWR VGND sky130_ef_sc_hd__decap_12
XFILLER_164_189 VGND VGND VPWR VPWR sky130_fd_sc_hd__decap_6
XFILLER_98_29 VPWR VGND VPWR VGND sky130_ef_sc_hd__decap_12
XTAP_TAPCELL_ROW_119_2_3753 VGND VPWR sky130_fd_sc_hd__tapvpwrvgnd_1
XPHY_EDGE_ROW_106_2_Left_538 VGND VGND VPWR VPWR sky130_fd_sc_hd__decap_3
XFILLER_47_1440 VGND VGND VPWR VPWR sky130_fd_sc_hd__fill_1
XFILLER_173_1481 VPWR VGND VPWR VGND sky130_ef_sc_hd__decap_12
XTAP_TAPCELL_ROW_87_2_3542 VGND VPWR sky130_fd_sc_hd__tapvpwrvgnd_1
Xfanout131 _087_ VGND VGND VPWR VPWR net131 sky130_fd_sc_hd__buf_2
XFILLER_219_113 VPWR VGND VPWR VGND sky130_ef_sc_hd__decap_12
Xfanout142 net144 VGND VGND VPWR VPWR net142 sky130_fd_sc_hd__buf_2
Xfanout153 net154 VGND VGND VPWR VPWR net153 sky130_fd_sc_hd__clkbuf_2
XFILLER_21_1602 VGND VGND VPWR VPWR sky130_fd_sc_hd__decap_3
XFILLER_47_55 VGND VGND VPWR VPWR sky130_fd_sc_hd__fill_1
XFILLER_210_1353 VPWR VGND VPWR VGND sky130_ef_sc_hd__decap_12
XTAP_TAPCELL_ROW_112_2_3707 VGND VPWR sky130_fd_sc_hd__tapvpwrvgnd_1
XTAP_TAPCELL_ROW_3_873 VGND VPWR sky130_fd_sc_hd__tapvpwrvgnd_1
XFILLER_210_1397 VPWR VGND VPWR VGND sky130_ef_sc_hd__decap_12
XTAP_TAPCELL_ROW_3_884 VGND VPWR sky130_fd_sc_hd__tapvpwrvgnd_1
XFILLER_203_503 VGND VGND VPWR VPWR sky130_fd_sc_hd__fill_1
XFILLER_215_385 VGND VGND VPWR VPWR sky130_fd_sc_hd__decap_6
XFILLER_188_749 VGND VGND VPWR VPWR sky130_fd_sc_hd__decap_6
XFILLER_163_1105 VPWR VGND VPWR VGND sky130_ef_sc_hd__decap_12
XFILLER_128_1258 VPWR VGND VPWR VGND sky130_ef_sc_hd__decap_12
XFILLER_58_1580 VGND VGND VPWR VPWR sky130_fd_sc_hd__fill_1
XFILLER_187_237 VPWR VGND VPWR VGND sky130_ef_sc_hd__decap_12
XFILLER_180_1441 VPWR VGND VPWR VGND sky130_ef_sc_hd__decap_12
XFILLER_163_1149 VPWR VGND VPWR VGND sky130_ef_sc_hd__decap_12
XPHY_EDGE_ROW_35_2_Right_92 VGND VGND VPWR VPWR sky130_fd_sc_hd__decap_3
XPHY_EDGE_ROW_210_Left_429 VGND VGND VPWR VPWR sky130_fd_sc_hd__decap_3
XFILLER_8_27 VGND VGND VPWR VPWR sky130_fd_sc_hd__fill_1
XFILLER_196_793 VPWR VGND VPWR VGND sky130_ef_sc_hd__decap_12
XFILLER_195_281 VPWR VGND VPWR VGND sky130_ef_sc_hd__decap_12
XFILLER_180_1485 VPWR VGND VPWR VGND sky130_ef_sc_hd__decap_12
XFILLER_6_111 VPWR VGND VPWR VGND sky130_ef_sc_hd__decap_12
XFILLER_7_645 VPWR VGND VPWR VGND sky130_ef_sc_hd__decap_12
XTAP_TAPCELL_ROW_28_2_3157 VGND VPWR sky130_fd_sc_hd__tapvpwrvgnd_1
XFILLER_139_1310 VPWR VGND VPWR VGND sky130_ef_sc_hd__decap_12
XFILLER_87_1220 VPWR VGND VPWR VGND sky130_ef_sc_hd__decap_12
XFILLER_139_1354 VPWR VGND VPWR VGND sky130_ef_sc_hd__decap_12
XFILLER_87_1286 VPWR VGND VPWR VGND sky130_ef_sc_hd__decap_12
XFILLER_215_1231 VGND VGND VPWR VPWR sky130_fd_sc_hd__fill_1
XFILLER_139_1398 VPWR VGND VPWR VGND sky130_ef_sc_hd__decap_12
XFILLER_2_383 VGND VGND VPWR VPWR sky130_fd_sc_hd__fill_1
XFILLER_26_1524 VGND VGND VPWR VPWR sky130_fd_sc_hd__fill_1
XFILLER_214_27 VGND VGND VPWR VPWR sky130_fd_sc_hd__fill_1
XFILLER_191_1581 VPWR VGND VPWR VGND sky130_ef_sc_hd__decap_12
XFILLER_168_1005 VPWR VGND VPWR VGND sky130_ef_sc_hd__decap_12
XPHY_EDGE_ROW_152_2_Left_584 VGND VGND VPWR VPWR sky130_fd_sc_hd__decap_3
XFILLER_92_121 VGND VGND VPWR VPWR sky130_fd_sc_hd__decap_6
XFILLER_4_1353 VPWR VGND VPWR VGND sky130_ef_sc_hd__decap_12
XFILLER_24_1270 VPWR VGND VPWR VGND sky130_ef_sc_hd__decap_12
XFILLER_207_853 VPWR VGND VPWR VGND sky130_ef_sc_hd__decap_12
XFILLER_168_1049 VPWR VGND VPWR VGND sky130_ef_sc_hd__decap_12
XFILLER_0_1217 VPWR VGND VPWR VGND sky130_ef_sc_hd__decap_12
XFILLER_59_1322 VGND VGND VPWR VPWR sky130_fd_sc_hd__decap_6
XFILLER_207_897 VPWR VGND VPWR VGND sky130_ef_sc_hd__decap_12
XFILLER_206_363 VGND VGND VPWR VPWR sky130_fd_sc_hd__fill_1
XFILLER_146_1314 VPWR VGND VPWR VGND sky130_ef_sc_hd__decap_12
XFILLER_98_1382 VPWR VGND VPWR VGND sky130_ef_sc_hd__decap_12
XFILLER_94_1246 VPWR VGND VPWR VGND sky130_ef_sc_hd__decap_12
XFILLER_4_1397 VPWR VGND VPWR VGND sky130_ef_sc_hd__decap_12
XFILLER_59_1366 VPWR VGND VPWR VGND sky130_ef_sc_hd__decap_12
XFILLER_209_1057 VGND VGND VPWR VPWR sky130_fd_sc_hd__decap_6
XFILLER_179_727 VGND VGND VPWR VPWR sky130_fd_sc_hd__fill_1
XFILLER_146_1358 VPWR VGND VPWR VGND sky130_ef_sc_hd__decap_12
XFILLER_179_1101 VPWR VGND VPWR VGND sky130_ef_sc_hd__decap_12
XFILLER_175_933 VPWR VGND VPWR VGND sky130_ef_sc_hd__decap_12
XFILLER_174_421 VPWR VGND VPWR VGND sky130_ef_sc_hd__decap_12
XFILLER_200_1533 VGND VGND VPWR VPWR sky130_fd_sc_hd__decap_6
XFILLER_179_1145 VPWR VGND VPWR VGND sky130_ef_sc_hd__decap_12
XFILLER_175_977 VPWR VGND VPWR VGND sky130_ef_sc_hd__decap_12
XTAP_TAPCELL_ROW_93_2_3585 VGND VPWR sky130_fd_sc_hd__tapvpwrvgnd_1
XFILLER_190_925 VPWR VGND VPWR VGND sky130_ef_sc_hd__decap_12
XFILLER_175_1009 VPWR VGND VPWR VGND sky130_ef_sc_hd__decap_12
XTAP_TAPCELL_ROW_105_2_3661 VGND VPWR sky130_fd_sc_hd__tapvpwrvgnd_1
XFILLER_31_1274 VPWR VGND VPWR VGND sky130_ef_sc_hd__decap_12
XFILLER_200_1577 VPWR VGND VPWR VGND sky130_ef_sc_hd__decap_12
XFILLER_179_1189 VPWR VGND VPWR VGND sky130_ef_sc_hd__decap_12
XFILLER_157_1410 VPWR VGND VPWR VGND sky130_ef_sc_hd__decap_12
XFILLER_66_1326 VPWR VGND VPWR VGND sky130_ef_sc_hd__decap_12
XANTENNA__332__A0 b_addr\[7\] VGND VGND VPWR VPWR sky130_fd_sc_hd__diode_2
XFILLER_216_1017 VPWR VGND VPWR VGND sky130_ef_sc_hd__decap_12
XFILLER_157_1454 VPWR VGND VPWR VGND sky130_ef_sc_hd__decap_12
XTAP_TAPCELL_ROW_73_2_3450 VGND VPWR sky130_fd_sc_hd__tapvpwrvgnd_1
XFILLER_170_693 VGND VGND VPWR VPWR sky130_fd_sc_hd__decap_6
XFILLER_157_1498 VPWR VGND VPWR VGND sky130_ef_sc_hd__decap_12
XFILLER_118_1438 VPWR VGND VPWR VGND sky130_ef_sc_hd__decap_12
XFILLER_9_1220 VPWR VGND VPWR VGND sky130_ef_sc_hd__decap_12
XFILLER_44_1602 VGND VGND VPWR VPWR sky130_fd_sc_hd__decap_3
XFILLER_124_27 VGND VGND VPWR VPWR sky130_fd_sc_hd__fill_1
XFILLER_190_1091 VGND VGND VPWR VPWR sky130_fd_sc_hd__fill_1
XFILLER_9_1286 VPWR VGND VPWR VGND sky130_ef_sc_hd__decap_12
XFILLER_217_617 VPWR VGND VPWR VGND sky130_ef_sc_hd__decap_12
XFILLER_186_1105 VPWR VGND VPWR VGND sky130_ef_sc_hd__decap_12
XFILLER_42_1370 VPWR VGND VPWR VGND sky130_ef_sc_hd__decap_12
XFILLER_186_1149 VPWR VGND VPWR VGND sky130_ef_sc_hd__decap_12
XFILLER_140_15 VPWR VGND VPWR VGND sky130_ef_sc_hd__decap_12
XFILLER_77_1422 VPWR VGND VPWR VGND sky130_ef_sc_hd__decap_12
XFILLER_38_1406 VGND VGND VPWR VPWR sky130_fd_sc_hd__decap_6
XFILLER_129_1534 VPWR VGND VPWR VGND sky130_ef_sc_hd__decap_12
XFILLER_77_1466 VPWR VGND VPWR VGND sky130_ef_sc_hd__decap_12
XFILLER_213_889 VGND VGND VPWR VPWR sky130_fd_sc_hd__decap_6
XFILLER_212_333 VPWR VGND VPWR VGND sky130_ef_sc_hd__decap_12
XFILLER_169_237 VPWR VGND VPWR VGND sky130_ef_sc_hd__decap_12
XFILLER_129_1578 VPWR VGND VPWR VGND sky130_ef_sc_hd__decap_12
XFILLER_212_377 VPWR VGND VPWR VGND sky130_ef_sc_hd__decap_12
XFILLER_33_57 VPWR VGND VPWR VGND sky130_ef_sc_hd__decap_12
XFILLER_205_1455 VGND VGND VPWR VPWR sky130_fd_sc_hd__fill_1
XFILLER_197_1201 VPWR VGND VPWR VGND sky130_ef_sc_hd__decap_12
XFILLER_178_793 VPWR VGND VPWR VGND sky130_ef_sc_hd__decap_12
XFILLER_177_281 VPWR VGND VPWR VGND sky130_ef_sc_hd__decap_12
XFILLER_149_57 VPWR VGND VPWR VGND sky130_ef_sc_hd__decap_12
XFILLER_193_741 VPWR VGND VPWR VGND sky130_ef_sc_hd__decap_12
XFILLER_14_1450 VPWR VGND VPWR VGND sky130_ef_sc_hd__decap_12
XFILLER_197_1245 VPWR VGND VPWR VGND sky130_ef_sc_hd__decap_12
XFILLER_193_785 VPWR VGND VPWR VGND sky130_ef_sc_hd__decap_12
XFILLER_192_251 VGND VGND VPWR VPWR sky130_fd_sc_hd__fill_1
XFILLER_180_413 VGND VGND VPWR VPWR sky130_fd_sc_hd__decap_6
XFILLER_101_1442 VPWR VGND VPWR VGND sky130_ef_sc_hd__decap_12
XFILLER_4_615 VGND VGND VPWR VPWR sky130_fd_sc_hd__decap_6
XFILLER_10_1314 VPWR VGND VPWR VGND sky130_ef_sc_hd__decap_12
XFILLER_14_1494 VPWR VGND VPWR VGND sky130_ef_sc_hd__decap_12
XFILLER_197_1289 VPWR VGND VPWR VGND sky130_ef_sc_hd__decap_12
XFILLER_180_457 VPWR VGND VPWR VGND sky130_ef_sc_hd__decap_12
XPHY_EDGE_ROW_148_1_Left_367 VGND VGND VPWR VPWR sky130_fd_sc_hd__decap_3
XFILLER_109_3 VPWR VGND VPWR VGND sky130_ef_sc_hd__decap_12
XFILLER_88_1562 VPWR VGND VPWR VGND sky130_ef_sc_hd__decap_12
XFILLER_3_125 VPWR VGND VPWR VGND sky130_ef_sc_hd__decap_12
XFILLER_10_1358 VPWR VGND VPWR VGND sky130_ef_sc_hd__decap_12
XTAP_TAPCELL_ROW_140_1_1298 VGND VPWR sky130_fd_sc_hd__tapvpwrvgnd_1
XFILLER_84_1426 VPWR VGND VPWR VGND sky130_ef_sc_hd__decap_12
XFILLER_49_1546 VGND VGND VPWR VPWR sky130_fd_sc_hd__decap_6
XFILLER_136_1538 VPWR VGND VPWR VGND sky130_ef_sc_hd__decap_12
XPHY_EDGE_ROW_85_1_Left_304 VGND VGND VPWR VPWR sky130_fd_sc_hd__decap_3
XFILLER_0_865 VGND VGND VPWR VPWR sky130_fd_sc_hd__decap_3
XFILLER_58_65 VPWR VGND VPWR VGND sky130_ef_sc_hd__decap_12
XFILLER_216_1595 VGND VGND VPWR VPWR sky130_fd_sc_hd__fill_1
XFILLER_181_55 VGND VGND VPWR VPWR sky130_fd_sc_hd__fill_1
Xhold9 net71 VGND VGND VPWR VPWR net179 sky130_fd_sc_hd__dlygate4sd3_1
XFILLER_207_105 VGND VGND VPWR VPWR sky130_fd_sc_hd__decap_6
XFILLER_74_121 VGND VGND VPWR VPWR sky130_fd_sc_hd__decap_6
XANTENNA_input29_A func_wdata[25] VGND VGND VPWR VPWR sky130_fd_sc_hd__diode_2
XFILLER_21_1410 VPWR VGND VPWR VGND sky130_ef_sc_hd__decap_12
XFILLER_25_1590 VPWR VGND VPWR VGND sky130_ef_sc_hd__decap_12
XFILLER_60_1470 VPWR VGND VPWR VGND sky130_ef_sc_hd__decap_12
XFILLER_210_1161 VPWR VGND VPWR VGND sky130_ef_sc_hd__decap_12
XFILLER_207_149 VPWR VGND VPWR VGND sky130_ef_sc_hd__decap_12
XFILLER_169_1325 VPWR VGND VPWR VGND sky130_ef_sc_hd__decap_12
XFILLER_21_1454 VPWR VGND VPWR VGND sky130_ef_sc_hd__decap_12
XFILLER_169_1369 VPWR VGND VPWR VGND sky130_ef_sc_hd__decap_12
XFILLER_112_1582 VPWR VGND VPWR VGND sky130_ef_sc_hd__decap_12
XFILLER_95_1522 VPWR VGND VPWR VGND sky130_ef_sc_hd__decap_12
XFILLER_74_53 VPWR VGND VPWR VGND sky130_ef_sc_hd__decap_12
XFILLER_1_1537 VPWR VGND VPWR VGND sky130_ef_sc_hd__decap_12
XFILLER_21_1498 VPWR VGND VPWR VGND sky130_ef_sc_hd__decap_12
XFILLER_188_513 VPWR VGND VPWR VGND sky130_ef_sc_hd__decap_12
XTAP_TAPCELL_ROW_142_2_3902 VGND VPWR sky130_fd_sc_hd__tapvpwrvgnd_1
XPHY_EDGE_ROW_130_2_Right_187 VGND VGND VPWR VPWR sky130_fd_sc_hd__decap_3
XFILLER_95_1566 VPWR VGND VPWR VGND sky130_ef_sc_hd__decap_12
XFILLER_74_97 VPWR VGND VPWR VGND sky130_ef_sc_hd__decap_12
XFILLER_56_1506 VPWR VGND VPWR VGND sky130_ef_sc_hd__decap_12
XFILLER_215_193 VPWR VGND VPWR VGND sky130_ef_sc_hd__decap_12
XFILLER_204_867 VGND VGND VPWR VPWR sky130_fd_sc_hd__fill_1
XFILLER_200_29 VPWR VGND VPWR VGND sky130_ef_sc_hd__decap_12
XFILLER_188_557 VPWR VGND VPWR VGND sky130_ef_sc_hd__decap_12
Xu_sram.u_mem_158 VGND VGND VPWR VPWR u_sram.u_mem_158/HI net158 sky130_fd_sc_hd__conb_1
XFILLER_90_41 VPWR VGND VPWR VGND sky130_ef_sc_hd__decap_12
Xu_sram.u_mem_169 VGND VGND VPWR VPWR net169 u_sram.u_mem_169/LO sky130_fd_sc_hd__conb_1
XFILLER_141_1244 VPWR VGND VPWR VGND sky130_ef_sc_hd__decap_12
XFILLER_90_85 VPWR VGND VPWR VGND sky130_ef_sc_hd__decap_12
XFILLER_209_27 VPWR VGND VPWR VGND sky130_ef_sc_hd__decap_12
XTAP_TAPCELL_ROW_78_2_3487 VGND VPWR sky130_fd_sc_hd__tapvpwrvgnd_1
XFILLER_32_1550 VPWR VGND VPWR VGND sky130_ef_sc_hd__decap_12
XFILLER_183_273 VGND VGND VPWR VPWR sky130_fd_sc_hd__decap_6
XFILLER_172_925 VPWR VGND VPWR VGND sky130_ef_sc_hd__decap_12
XFILLER_176_1329 VPWR VGND VPWR VGND sky130_ef_sc_hd__decap_12
XFILLER_67_1602 VGND VGND VPWR VPWR sky130_fd_sc_hd__decap_3
XFILLER_32_1594 VGND VGND VPWR VPWR sky130_fd_sc_hd__decap_8
XTAP_TAPCELL_ROW_58_2_3352 VGND VPWR sky130_fd_sc_hd__tapvpwrvgnd_1
XFILLER_217_1337 VGND VGND VPWR VPWR sky130_fd_sc_hd__decap_6
XFILLER_3_670 VGND VGND VPWR VPWR sky130_fd_sc_hd__fill_2
XFILLER_24_3 VPWR VGND VPWR VGND sky130_ef_sc_hd__decap_12
XFILLER_61_1256 VPWR VGND VPWR VGND sky130_ef_sc_hd__decap_12
XFILLER_187_1425 VPWR VGND VPWR VGND sky130_ef_sc_hd__decap_12
XFILLER_4_1161 VPWR VGND VPWR VGND sky130_ef_sc_hd__decap_12
XFILLER_187_1469 VPWR VGND VPWR VGND sky130_ef_sc_hd__decap_12
XFILLER_110_29 VPWR VGND VPWR VGND sky130_ef_sc_hd__decap_12
XFILLER_210_837 VPWR VGND VPWR VGND sky130_ef_sc_hd__decap_12
XFILLER_181_1057 VGND VGND VPWR VPWR sky130_fd_sc_hd__decap_6
XFILLER_198_1521 VPWR VGND VPWR VGND sky130_ef_sc_hd__decap_12
XFILLER_175_741 VPWR VGND VPWR VGND sky130_ef_sc_hd__decap_12
XFILLER_119_27 VPWR VGND VPWR VGND sky130_ef_sc_hd__decap_12
XFILLER_200_1341 VPWR VGND VPWR VGND sky130_ef_sc_hd__decap_12
XFILLER_198_1565 VPWR VGND VPWR VGND sky130_ef_sc_hd__decap_12
XFILLER_175_785 VPWR VGND VPWR VGND sky130_ef_sc_hd__decap_12
XFILLER_174_251 VGND VGND VPWR VPWR sky130_fd_sc_hd__fill_1
XFILLER_163_925 VPWR VGND VPWR VGND sky130_ef_sc_hd__decap_12
XFILLER_194_1429 VPWR VGND VPWR VGND sky130_ef_sc_hd__decap_12
XFILLER_190_755 VGND VGND VPWR VPWR sky130_fd_sc_hd__fill_1
XFILLER_200_1385 VPWR VGND VPWR VGND sky130_ef_sc_hd__decap_12
XFILLER_1_607 VGND VGND VPWR VPWR sky130_fd_sc_hd__decap_8
XFILLER_135_15 VPWR VGND VPWR VGND sky130_ef_sc_hd__decap_12
XTAP_TAPCELL_ROW_28_1_1073 VGND VPWR sky130_fd_sc_hd__tapvpwrvgnd_1
XFILLER_192_1197 VGND VGND VPWR VPWR sky130_fd_sc_hd__decap_6
XFILLER_118_1246 VPWR VGND VPWR VGND sky130_ef_sc_hd__decap_12
XTAP_TAPCELL_ROW_5_924 VGND VPWR sky130_fd_sc_hd__tapvpwrvgnd_1
XTAP_TAPCELL_ROW_5_935 VGND VPWR sky130_fd_sc_hd__tapvpwrvgnd_1
XTAP_TAPCELL_ROW_5_946 VGND VPWR sky130_fd_sc_hd__tapvpwrvgnd_1
XFILLER_218_937 VPWR VGND VPWR VGND sky130_ef_sc_hd__decap_12
XFILLER_215_81 VPWR VGND VPWR VGND sky130_ef_sc_hd__decap_12
XFILLER_56_110 VPWR VGND VPWR VGND sky130_ef_sc_hd__decap_12
XFILLER_217_447 VGND VGND VPWR VPWR sky130_fd_sc_hd__fill_1
XFILLER_28_68 VGND VGND VPWR VPWR sky130_fd_sc_hd__fill_1
XFILLER_211_1481 VPWR VGND VPWR VGND sky130_ef_sc_hd__decap_12
XFILLER_205_609 VGND VGND VPWR VPWR sky130_fd_sc_hd__decap_6
XFILLER_166_1509 VPWR VGND VPWR VGND sky130_ef_sc_hd__decap_12
XFILLER_151_69 VPWR VGND VPWR VGND sky130_ef_sc_hd__decap_12
XTAP_TAPCELL_ROW_127_2_3804 VGND VPWR sky130_fd_sc_hd__tapvpwrvgnd_1
XTAP_TAPCELL_ROW_116_1_1249 VGND VPWR sky130_fd_sc_hd__tapvpwrvgnd_1
XFILLER_71_113 VPWR VGND VPWR VGND sky130_ef_sc_hd__decap_12
XFILLER_198_811 VGND VGND VPWR VPWR sky130_fd_sc_hd__fill_1
XFILLER_213_653 VPWR VGND VPWR VGND sky130_ef_sc_hd__decap_12
XFILLER_129_1342 VPWR VGND VPWR VGND sky130_ef_sc_hd__decap_12
XFILLER_77_1274 VPWR VGND VPWR VGND sky130_ef_sc_hd__decap_12
XFILLER_0_1581 VPWR VGND VPWR VGND sky130_ef_sc_hd__decap_12
XFILLER_213_697 VPWR VGND VPWR VGND sky130_ef_sc_hd__decap_12
XFILLER_212_141 VPWR VGND VPWR VGND sky130_ef_sc_hd__decap_12
XFILLER_185_505 VPWR VGND VPWR VGND sky130_ef_sc_hd__decap_12
XFILLER_129_1386 VPWR VGND VPWR VGND sky130_ef_sc_hd__decap_12
XFILLER_38_1258 VPWR VGND VPWR VGND sky130_ef_sc_hd__decap_12
XPHY_EDGE_ROW_50_1_Right_636 VGND VGND VPWR VPWR sky130_fd_sc_hd__decap_3
XTAP_TAPCELL_ROW_195_2293 VGND VPWR sky130_fd_sc_hd__tapvpwrvgnd_1
XTAP_TAPCELL_ROW_83_1_1183 VGND VPWR sky130_fd_sc_hd__tapvpwrvgnd_1
XTAP_TAPCELL_ROW_64_2_3395 VGND VPWR sky130_fd_sc_hd__tapvpwrvgnd_1
XTAP_TAPCELL_ROW_216_2886 VGND VPWR sky130_fd_sc_hd__tapvpwrvgnd_1
XTAP_TAPCELL_ROW_191_2179 VGND VPWR sky130_fd_sc_hd__tapvpwrvgnd_1
XFILLER_165_273 VGND VGND VPWR VPWR sky130_fd_sc_hd__decap_6
XFILLER_60_77 VGND VGND VPWR VPWR sky130_fd_sc_hd__decap_6
XTAP_TAPCELL_ROW_216_2897 VGND VPWR sky130_fd_sc_hd__tapvpwrvgnd_1
XFILLER_180_221 VPWR VGND VPWR VGND sky130_ef_sc_hd__decap_12
XFILLER_176_77 VGND VGND VPWR VPWR sky130_fd_sc_hd__decap_6
XFILLER_49_1310 VPWR VGND VPWR VGND sky130_ef_sc_hd__decap_12
XFILLER_181_777 VGND VGND VPWR VPWR sky130_fd_sc_hd__decap_6
XFILLER_180_265 VPWR VGND VPWR VGND sky130_ef_sc_hd__decap_12
XFILLER_101_1272 VGND VGND VPWR VPWR sky130_fd_sc_hd__fill_1
XFILLER_88_1370 VPWR VGND VPWR VGND sky130_ef_sc_hd__decap_12
XFILLER_5_39 VPWR VGND VPWR VGND sky130_ef_sc_hd__decap_12
XFILLER_136_1302 VPWR VGND VPWR VGND sky130_ef_sc_hd__decap_12
XFILLER_109_93 VPWR VGND VPWR VGND sky130_ef_sc_hd__decap_12
XFILLER_4_489 VGND VGND VPWR VPWR sky130_fd_sc_hd__decap_4
XFILLER_49_1354 VPWR VGND VPWR VGND sky130_ef_sc_hd__decap_12
XFILLER_192_65 VPWR VGND VPWR VGND sky130_ef_sc_hd__decap_12
XFILLER_49_1398 VPWR VGND VPWR VGND sky130_ef_sc_hd__decap_12
XFILLER_125_81 VPWR VGND VPWR VGND sky130_ef_sc_hd__decap_12
XFILLER_169_1133 VPWR VGND VPWR VGND sky130_ef_sc_hd__decap_12
XFILLER_1_1301 VPWR VGND VPWR VGND sky130_ef_sc_hd__decap_12
XFILLER_208_469 VGND VGND VPWR VPWR sky130_fd_sc_hd__decap_6
XFILLER_5_1481 VPWR VGND VPWR VGND sky130_ef_sc_hd__decap_12
XFILLER_211_39 VPWR VGND VPWR VGND sky130_ef_sc_hd__decap_12
XTAP_TAPCELL_ROW_180_1883 VGND VPWR sky130_fd_sc_hd__tapvpwrvgnd_1
XTAP_TAPCELL_ROW_180_1872 VGND VPWR sky130_fd_sc_hd__tapvpwrvgnd_1
XTAP_TAPCELL_ROW_180_1861 VGND VPWR sky130_fd_sc_hd__tapvpwrvgnd_1
XFILLER_169_1177 VPWR VGND VPWR VGND sky130_ef_sc_hd__decap_12
XFILLER_95_1330 VPWR VGND VPWR VGND sky130_ef_sc_hd__decap_12
XFILLER_1_1345 VPWR VGND VPWR VGND sky130_ef_sc_hd__decap_12
XFILLER_206_1005 VPWR VGND VPWR VGND sky130_ef_sc_hd__decap_12
XFILLER_189_833 VGND VGND VPWR VPWR sky130_fd_sc_hd__decap_6
XFILLER_188_321 VPWR VGND VPWR VGND sky130_ef_sc_hd__decap_12
XFILLER_147_1442 VPWR VGND VPWR VGND sky130_ef_sc_hd__decap_12
XPHY_EDGE_ROW_131_2_Right_188 VGND VGND VPWR VPWR sky130_fd_sc_hd__decap_3
XFILLER_56_1314 VPWR VGND VPWR VGND sky130_ef_sc_hd__decap_12
XFILLER_189_877 VPWR VGND VPWR VGND sky130_ef_sc_hd__decap_12
XFILLER_188_365 VPWR VGND VPWR VGND sky130_ef_sc_hd__decap_12
XFILLER_143_1328 VGND VGND VPWR VPWR sky130_fd_sc_hd__fill_1
XFILLER_108_1426 VPWR VGND VPWR VGND sky130_ef_sc_hd__decap_12
XFILLER_56_1358 VPWR VGND VPWR VGND sky130_ef_sc_hd__decap_12
XFILLER_206_1049 VPWR VGND VPWR VGND sky130_ef_sc_hd__decap_12
XANTENNA__535__B1 net136 VGND VGND VPWR VPWR sky130_fd_sc_hd__diode_2
XFILLER_200_881 VPWR VGND VPWR VGND sky130_ef_sc_hd__decap_12
XTAP_TAPCELL_ROW_174_1698 VGND VPWR sky130_fd_sc_hd__tapvpwrvgnd_1
XTAP_TAPCELL_ROW_174_1687 VGND VPWR sky130_fd_sc_hd__tapvpwrvgnd_1
XFILLER_172_755 VGND VGND VPWR VPWR sky130_fd_sc_hd__fill_1
XFILLER_217_1101 VPWR VGND VPWR VGND sky130_ef_sc_hd__decap_12
XFILLER_67_1410 VPWR VGND VPWR VGND sky130_ef_sc_hd__decap_12
XPHY_EDGE_ROW_170_Left_389 VGND VGND VPWR VPWR sky130_fd_sc_hd__decap_3
XFILLER_158_1582 VPWR VGND VPWR VGND sky130_ef_sc_hd__decap_12
XFILLER_119_1522 VPWR VGND VPWR VGND sky130_ef_sc_hd__decap_12
XFILLER_67_1454 VPWR VGND VPWR VGND sky130_ef_sc_hd__decap_12
XFILLER_217_1145 VPWR VGND VPWR VGND sky130_ef_sc_hd__decap_12
XFILLER_213_1009 VPWR VGND VPWR VGND sky130_ef_sc_hd__decap_12
XFILLER_119_1566 VPWR VGND VPWR VGND sky130_ef_sc_hd__decap_12
XFILLER_67_1498 VPWR VGND VPWR VGND sky130_ef_sc_hd__decap_12
XFILLER_28_1438 VPWR VGND VPWR VGND sky130_ef_sc_hd__decap_12
XFILLER_217_1189 VPWR VGND VPWR VGND sky130_ef_sc_hd__decap_12
XFILLER_154_1468 VGND VGND VPWR VPWR sky130_fd_sc_hd__fill_1
XPHY_EDGE_ROW_7_Right_7 VGND VGND VPWR VPWR sky130_fd_sc_hd__decap_3
XFILLER_38_121 VGND VGND VPWR VPWR sky130_fd_sc_hd__decap_6
XTAP_TAPCELL_ROW_113_2_3712 VGND VPWR sky130_fd_sc_hd__tapvpwrvgnd_1
XFILLER_187_1233 VPWR VGND VPWR VGND sky130_ef_sc_hd__decap_12
XPHY_EDGE_ROW_93_2_Right_150 VGND VGND VPWR VPWR sky130_fd_sc_hd__decap_3
XFILLER_53_113 VPWR VGND VPWR VGND sky130_ef_sc_hd__decap_12
XFILLER_208_981 VPWR VGND VPWR VGND sky130_ef_sc_hd__decap_12
XFILLER_183_1119 VGND VGND VPWR VPWR sky130_fd_sc_hd__fill_1
XFILLER_121_39 VPWR VGND VPWR VGND sky130_ef_sc_hd__decap_12
XFILLER_78_1550 VPWR VGND VPWR VGND sky130_ef_sc_hd__decap_12
XPHY_EDGE_ROW_115_2_Left_547 VGND VGND VPWR VPWR sky130_fd_sc_hd__decap_3
XFILLER_78_1594 VGND VGND VPWR VPWR sky130_fd_sc_hd__decap_8
XFILLER_74_1414 VPWR VGND VPWR VGND sky130_ef_sc_hd__decap_12
XFILLER_39_1534 VPWR VGND VPWR VGND sky130_ef_sc_hd__decap_12
XFILLER_210_601 VPWR VGND VPWR VGND sky130_ef_sc_hd__decap_12
XFILLER_167_505 VPWR VGND VPWR VGND sky130_ef_sc_hd__decap_12
XFILLER_126_1526 VPWR VGND VPWR VGND sky130_ef_sc_hd__decap_12
XFILLER_14_15 VPWR VGND VPWR VGND sky130_ef_sc_hd__decap_12
XFILLER_39_1578 VPWR VGND VPWR VGND sky130_ef_sc_hd__decap_12
XTAP_TAPCELL_ROW_49_2_3297 VGND VPWR sky130_fd_sc_hd__tapvpwrvgnd_1
XFILLER_210_645 VPWR VGND VPWR VGND sky130_ef_sc_hd__decap_12
XFILLER_194_357 VGND VGND VPWR VPWR sky130_fd_sc_hd__decap_6
XANTENNA__363__A b_addr\[7\] VGND VGND VPWR VPWR sky130_fd_sc_hd__diode_2
XFILLER_124_1294 VGND VGND VPWR VPWR sky130_fd_sc_hd__decap_6
XFILLER_198_1373 VPWR VGND VPWR VGND sky130_ef_sc_hd__decap_12
XFILLER_11_1442 VPWR VGND VPWR VGND sky130_ef_sc_hd__decap_12
XFILLER_194_1259 VGND VGND VPWR VPWR sky130_fd_sc_hd__fill_1
XFILLER_85_1510 VPWR VGND VPWR VGND sky130_ef_sc_hd__decap_12
XTAP_TAPCELL_ROW_211_2761 VGND VPWR sky130_fd_sc_hd__tapvpwrvgnd_1
XTAP_TAPCELL_ROW_211_2750 VGND VPWR sky130_fd_sc_hd__tapvpwrvgnd_1
XFILLER_85_1554 VPWR VGND VPWR VGND sky130_ef_sc_hd__decap_12
XFILLER_46_1538 VPWR VGND VPWR VGND sky130_ef_sc_hd__decap_12
XFILLER_7_1009 VPWR VGND VPWR VGND sky130_ef_sc_hd__decap_12
XFILLER_218_701 VPWR VGND VPWR VGND sky130_ef_sc_hd__decap_12
XFILLER_29_110 VGND VGND VPWR VPWR sky130_fd_sc_hd__fill_2
XTAP_TAPCELL_ROW_209_2690 VGND VPWR sky130_fd_sc_hd__tapvpwrvgnd_1
XFILLER_131_1232 VPWR VGND VPWR VGND sky130_ef_sc_hd__decap_12
X_610_ clknet_3_7_0_clk _044_ VGND VGND VPWR VPWR net66 sky130_fd_sc_hd__dfxtp_1
XFILLER_176_3 VPWR VGND VPWR VGND sky130_ef_sc_hd__decap_12
XFILLER_131_1298 VPWR VGND VPWR VGND sky130_ef_sc_hd__decap_12
X_541_ net135 _244_ VGND VGND VPWR VPWR _054_ sky130_fd_sc_hd__and2_1
XFILLER_55_44 VPWR VGND VPWR VGND sky130_ef_sc_hd__decap_12
XTAP_TAPCELL_ROW_205_2587 VGND VPWR sky130_fd_sc_hd__tapvpwrvgnd_1
XTAP_TAPCELL_ROW_205_2576 VGND VPWR sky130_fd_sc_hd__tapvpwrvgnd_1
XFILLER_205_417 VPWR VGND VPWR VGND sky130_ef_sc_hd__decap_12
XFILLER_166_1317 VPWR VGND VPWR VGND sky130_ef_sc_hd__decap_12
XFILLER_22_1582 VPWR VGND VPWR VGND sky130_ef_sc_hd__decap_12
XPHY_EDGE_ROW_47_2_Left_479 VGND VGND VPWR VPWR sky130_fd_sc_hd__decap_3
XTAP_TAPCELL_ROW_197_2355 VGND VPWR sky130_fd_sc_hd__tapvpwrvgnd_1
XTAP_TAPCELL_ROW_197_2344 VGND VPWR sky130_fd_sc_hd__tapvpwrvgnd_1
X_472_ _186_ _188_ _193_ _194_ VGND VGND VPWR VPWR _204_ sky130_fd_sc_hd__or4_1
XFILLER_214_973 VGND VGND VPWR VPWR sky130_fd_sc_hd__decap_6
XFILLER_213_461 VPWR VGND VPWR VGND sky130_ef_sc_hd__decap_12
XFILLER_207_1325 VPWR VGND VPWR VGND sky130_ef_sc_hd__decap_12
XTAP_TAPCELL_ROW_197_2366 VGND VPWR sky130_fd_sc_hd__tapvpwrvgnd_1
XFILLER_207_1369 VPWR VGND VPWR VGND sky130_ef_sc_hd__decap_12
XFILLER_186_825 VPWR VGND VPWR VGND sky130_ef_sc_hd__decap_12
XFILLER_164_1085 VGND VGND VPWR VPWR sky130_fd_sc_hd__decap_6
XTAP_TAPCELL_ROW_218_2959 VGND VPWR sky130_fd_sc_hd__tapvpwrvgnd_1
XTAP_TAPCELL_ROW_218_2948 VGND VPWR sky130_fd_sc_hd__tapvpwrvgnd_1
XFILLER_200_133 VGND VGND VPWR VPWR sky130_fd_sc_hd__decap_6
XFILLER_186_869 VPWR VGND VPWR VGND sky130_ef_sc_hd__decap_12
XFILLER_185_335 VGND VGND VPWR VPWR sky130_fd_sc_hd__fill_1
XFILLER_142_1350 VGND VGND VPWR VPWR sky130_fd_sc_hd__decap_6
XFILLER_90_1282 VPWR VGND VPWR VGND sky130_ef_sc_hd__decap_12
XPHY_EDGE_ROW_51_1_Right_637 VGND VGND VPWR VPWR sky130_fd_sc_hd__decap_3
XFILLER_200_177 VPWR VGND VPWR VGND sky130_ef_sc_hd__decap_12
XFILLER_142_1394 VPWR VGND VPWR VGND sky130_ef_sc_hd__decap_12
XTAP_TAPCELL_ROW_94_2_3590 VGND VPWR sky130_fd_sc_hd__tapvpwrvgnd_1
XFILLER_51_1244 VPWR VGND VPWR VGND sky130_ef_sc_hd__decap_12
XFILLER_177_1413 VPWR VGND VPWR VGND sky130_ef_sc_hd__decap_12
XFILLER_103_1378 VGND VGND VPWR VPWR sky130_fd_sc_hd__decap_6
XFILLER_181_541 VPWR VGND VPWR VGND sky130_ef_sc_hd__decap_12
XFILLER_177_1457 VPWR VGND VPWR VGND sky130_ef_sc_hd__decap_12
XPHY_EDGE_ROW_161_2_Left_593 VGND VGND VPWR VPWR sky130_fd_sc_hd__decap_3
XFILLER_218_1421 VGND VGND VPWR VPWR sky130_fd_sc_hd__decap_6
XFILLER_181_585 VPWR VGND VPWR VGND sky130_ef_sc_hd__decap_12
XFILLER_4_253 VGND VGND VPWR VPWR sky130_fd_sc_hd__decap_4
XFILLER_4_264 VPWR VGND VPWR VGND sky130_ef_sc_hd__decap_12
XFILLER_218_1465 VPWR VGND VPWR VGND sky130_ef_sc_hd__decap_12
XFILLER_171_1001 VGND VGND VPWR VPWR sky130_fd_sc_hd__decap_6
XTAP_TAPCELL_ROW_11_1_1040 VGND VPWR sky130_fd_sc_hd__tapvpwrvgnd_1
XFILLER_214_1329 VPWR VGND VPWR VGND sky130_ef_sc_hd__decap_12
XFILLER_171_1045 VPWR VGND VPWR VGND sky130_ef_sc_hd__decap_12
XTAP_TAPCELL_ROW_86_2_3538 VGND VPWR sky130_fd_sc_hd__tapvpwrvgnd_1
XFILLER_171_1089 VPWR VGND VPWR VGND sky130_ef_sc_hd__decap_12
XTAP_TAPCELL_ROW_182_1934 VGND VPWR sky130_fd_sc_hd__tapvpwrvgnd_1
XTAP_TAPCELL_ROW_182_1923 VGND VPWR sky130_fd_sc_hd__tapvpwrvgnd_1
XTAP_TAPCELL_ROW_167_1491 VGND VPWR sky130_fd_sc_hd__tapvpwrvgnd_1
XFILLER_153_1490 VGND VGND VPWR VPWR sky130_fd_sc_hd__decap_6
XFILLER_7_1565 VGND VGND VPWR VPWR sky130_fd_sc_hd__decap_3
XFILLER_208_233 VPWR VGND VPWR VGND sky130_ef_sc_hd__decap_12
XFILLER_188_1553 VPWR VGND VPWR VGND sky130_ef_sc_hd__decap_12
XTAP_TAPCELL_ROW_163_1355 VGND VPWR sky130_fd_sc_hd__tapvpwrvgnd_1
XTAP_TAPCELL_ROW_163_1344 VGND VPWR sky130_fd_sc_hd__tapvpwrvgnd_1
XFILLER_110_1338 VPWR VGND VPWR VGND sky130_ef_sc_hd__decap_12
XFILLER_35_113 VGND VGND VPWR VPWR sky130_fd_sc_hd__fill_1
XFILLER_208_277 VPWR VGND VPWR VGND sky130_ef_sc_hd__decap_12
XFILLER_188_1597 VGND VGND VPWR VPWR sky130_fd_sc_hd__decap_8
XTAP_TAPCELL_ROW_163_1388 VGND VPWR sky130_fd_sc_hd__tapvpwrvgnd_1
XTAP_TAPCELL_ROW_163_1377 VGND VPWR sky130_fd_sc_hd__tapvpwrvgnd_1
XTAP_TAPCELL_ROW_163_1366 VGND VPWR sky130_fd_sc_hd__tapvpwrvgnd_1
XFILLER_205_951 VGND VGND VPWR VPWR sky130_fd_sc_hd__fill_1
XTAP_TAPCELL_ROW_163_1399 VGND VPWR sky130_fd_sc_hd__tapvpwrvgnd_1
XPHY_EDGE_ROW_100_1_Left_319 VGND VGND VPWR VPWR sky130_fd_sc_hd__decap_3
XFILLER_1_1175 VGND VGND VPWR VPWR sky130_fd_sc_hd__fill_1
XFILLER_189_641 VPWR VGND VPWR VGND sky130_ef_sc_hd__decap_12
XFILLER_182_1141 VGND VGND VPWR VPWR sky130_fd_sc_hd__decap_6
XFILLER_147_1272 VGND VGND VPWR VPWR sky130_fd_sc_hd__fill_1
XFILLER_189_685 VPWR VGND VPWR VGND sky130_ef_sc_hd__decap_12
XFILLER_182_1185 VPWR VGND VPWR VGND sky130_ef_sc_hd__decap_12
XPHY_EDGE_ROW_132_2_Right_189 VGND VGND VPWR VPWR sky130_fd_sc_hd__decap_3
XFILLER_91_3 VPWR VGND VPWR VGND sky130_ef_sc_hd__decap_12
XFILLER_188_195 VGND VGND VPWR VPWR sky130_fd_sc_hd__fill_1
XTAP_TAPCELL_ROW_176_1749 VGND VPWR sky130_fd_sc_hd__tapvpwrvgnd_1
XFILLER_176_357 VGND VGND VPWR VPWR sky130_fd_sc_hd__decap_6
XFILLER_160_1450 VPWR VGND VPWR VGND sky130_ef_sc_hd__decap_12
XFILLER_191_305 VPWR VGND VPWR VGND sky130_ef_sc_hd__decap_12
XFILLER_121_1434 VGND VGND VPWR VPWR sky130_fd_sc_hd__decap_6
XFILLER_195_1513 VPWR VGND VPWR VGND sky130_ef_sc_hd__decap_12
XFILLER_191_349 VPWR VGND VPWR VGND sky130_ef_sc_hd__decap_12
XFILLER_160_1494 VPWR VGND VPWR VGND sky130_ef_sc_hd__decap_12
XFILLER_219_1229 VGND VGND VPWR VPWR sky130_fd_sc_hd__decap_3
XFILLER_121_1478 VPWR VGND VPWR VGND sky130_ef_sc_hd__decap_12
XFILLER_193_1281 VGND VGND VPWR VPWR sky130_fd_sc_hd__decap_6
XFILLER_154_1232 VPWR VGND VPWR VGND sky130_ef_sc_hd__decap_12
XFILLER_119_1330 VPWR VGND VPWR VGND sky130_ef_sc_hd__decap_12
XFILLER_28_1246 VPWR VGND VPWR VGND sky130_ef_sc_hd__decap_12
XFILLER_80_1462 VGND VGND VPWR VPWR sky130_fd_sc_hd__decap_6
XFILLER_132_27 VGND VGND VPWR VPWR sky130_fd_sc_hd__fill_1
XFILLER_132_1574 VGND VGND VPWR VPWR sky130_fd_sc_hd__decap_6
XFILLER_199_405 VPWR VGND VPWR VGND sky130_ef_sc_hd__decap_12
XFILLER_187_1063 VGND VGND VPWR VPWR sky130_fd_sc_hd__fill_1
XPHY_EDGE_ROW_94_2_Right_151 VGND VGND VPWR VPWR sky130_fd_sc_hd__decap_3
XFILLER_199_449 VPWR VGND VPWR VGND sky130_ef_sc_hd__decap_12
XFILLER_41_105 VGND VGND VPWR VPWR sky130_fd_sc_hd__decap_6
XFILLER_211_921 VPWR VGND VPWR VGND sky130_ef_sc_hd__decap_12
XTAP_TAPCELL_ROW_200_2451 VGND VPWR sky130_fd_sc_hd__tapvpwrvgnd_1
XTAP_TAPCELL_ROW_200_2440 VGND VPWR sky130_fd_sc_hd__tapvpwrvgnd_1
XPHY_EDGE_ROW_157_1_Left_376 VGND VGND VPWR VPWR sky130_fd_sc_hd__decap_3
XFILLER_74_1244 VGND VGND VPWR VPWR sky130_fd_sc_hd__fill_1
XFILLER_25_69 VGND VGND VPWR VPWR sky130_fd_sc_hd__decap_8
XFILLER_39_1342 VPWR VGND VPWR VGND sky130_ef_sc_hd__decap_12
XFILLER_204_1509 VPWR VGND VPWR VGND sky130_ef_sc_hd__decap_12
XFILLER_168_825 VPWR VGND VPWR VGND sky130_ef_sc_hd__decap_12
XFILLER_39_1386 VPWR VGND VPWR VGND sky130_ef_sc_hd__decap_12
XFILLER_211_965 VPWR VGND VPWR VGND sky130_ef_sc_hd__decap_12
XFILLER_194_121 VPWR VGND VPWR VGND sky130_ef_sc_hd__decap_12
XFILLER_168_869 VPWR VGND VPWR VGND sky130_ef_sc_hd__decap_12
XFILLER_167_335 VGND VGND VPWR VPWR sky130_fd_sc_hd__fill_1
XFILLER_126_1356 VGND VGND VPWR VPWR sky130_fd_sc_hd__fill_1
XPHY_EDGE_ROW_94_1_Left_313 VGND VGND VPWR VPWR sky130_fd_sc_hd__decap_3
XTAP_TAPCELL_ROW_79_2_3492 VGND VPWR sky130_fd_sc_hd__tapvpwrvgnd_1
XFILLER_210_475 VGND VGND VPWR VPWR sky130_fd_sc_hd__fill_1
XFILLER_194_165 VPWR VGND VPWR VGND sky130_ef_sc_hd__decap_12
XFILLER_183_839 VGND VGND VPWR VPWR sky130_fd_sc_hd__fill_1
XFILLER_41_57 VPWR VGND VPWR VGND sky130_ef_sc_hd__decap_12
XTAP_TAPCELL_ROW_213_2823 VGND VPWR sky130_fd_sc_hd__tapvpwrvgnd_1
XTAP_TAPCELL_ROW_213_2812 VGND VPWR sky130_fd_sc_hd__tapvpwrvgnd_1
XTAP_TAPCELL_ROW_213_2801 VGND VPWR sky130_fd_sc_hd__tapvpwrvgnd_1
XFILLER_157_57 VPWR VGND VPWR VGND sky130_ef_sc_hd__decap_12
XFILLER_100_1518 VGND VGND VPWR VPWR sky130_fd_sc_hd__decap_6
XFILLER_6_529 VGND VGND VPWR VPWR sky130_fd_sc_hd__decap_3
XFILLER_163_585 VGND VGND VPWR VPWR sky130_fd_sc_hd__decap_3
XTAP_TAPCELL_ROW_104_2_3657 VGND VPWR sky130_fd_sc_hd__tapvpwrvgnd_1
XFILLER_11_1272 VGND VGND VPWR VPWR sky130_fd_sc_hd__fill_1
XTAP_TAPCELL_ROW_186_2034 VGND VPWR sky130_fd_sc_hd__tapvpwrvgnd_1
XTAP_TAPCELL_ROW_72_2_3446 VGND VPWR sky130_fd_sc_hd__tapvpwrvgnd_1
XFILLER_46_1302 VPWR VGND VPWR VGND sky130_ef_sc_hd__decap_12
XTAP_TAPCELL_ROW_186_2045 VGND VPWR sky130_fd_sc_hd__tapvpwrvgnd_1
XFILLER_172_1365 VGND VGND VPWR VPWR sky130_fd_sc_hd__decap_6
XFILLER_85_1384 VGND VGND VPWR VPWR sky130_fd_sc_hd__fill_1
XFILLER_137_1496 VGND VGND VPWR VPWR sky130_fd_sc_hd__fill_1
XFILLER_2_29 VPWR VGND VPWR VGND sky130_ef_sc_hd__decap_12
XFILLER_218_531 VGND VGND VPWR VPWR sky130_fd_sc_hd__fill_1
XTAP_TAPCELL_ROW_207_2649 VGND VPWR sky130_fd_sc_hd__tapvpwrvgnd_1
XTAP_TAPCELL_ROW_207_2638 VGND VPWR sky130_fd_sc_hd__tapvpwrvgnd_1
XTAP_TAPCELL_ROW_207_2627 VGND VPWR sky130_fd_sc_hd__tapvpwrvgnd_1
XFILLER_106_83 VGND VGND VPWR VPWR sky130_fd_sc_hd__fill_1
XTAP_TAPCELL_ROW_199_2406 VGND VPWR sky130_fd_sc_hd__tapvpwrvgnd_1
XFILLER_66_65 VPWR VGND VPWR VGND sky130_ef_sc_hd__decap_12
XFILLER_206_737 VPWR VGND VPWR VGND sky130_ef_sc_hd__decap_12
XTAP_TAPCELL_ROW_199_2417 VGND VPWR sky130_fd_sc_hd__tapvpwrvgnd_1
XANTENNA_input11_A func_ce VGND VGND VPWR VPWR sky130_fd_sc_hd__diode_2
XFILLER_17_113 VGND VGND VPWR VPWR sky130_fd_sc_hd__decap_8
XFILLER_205_225 VPWR VGND VPWR VGND sky130_ef_sc_hd__decap_12
XFILLER_166_1147 VGND VGND VPWR VPWR sky130_fd_sc_hd__fill_1
XFILLER_92_1300 VGND VGND VPWR VPWR sky130_fd_sc_hd__fill_1
X_524_ net177 net125 VGND VGND VPWR VPWR _236_ sky130_fd_sc_hd__or2_1
XFILLER_109_1510 VPWR VGND VPWR VGND sky130_ef_sc_hd__decap_12
XFILLER_82_53 VPWR VGND VPWR VGND sky130_ef_sc_hd__decap_12
X_455_ net147 net115 VGND VGND VPWR VPWR _187_ sky130_fd_sc_hd__xor2_1
XFILLER_57_1442 VPWR VGND VPWR VGND sky130_ef_sc_hd__decap_12
XFILLER_214_781 VPWR VGND VPWR VGND sky130_ef_sc_hd__decap_12
XFILLER_207_1133 VPWR VGND VPWR VGND sky130_ef_sc_hd__decap_12
XFILLER_198_53 VPWR VGND VPWR VGND sky130_ef_sc_hd__decap_12
XFILLER_144_1412 VGND VGND VPWR VPWR sky130_fd_sc_hd__fill_1
XFILLER_109_1554 VPWR VGND VPWR VGND sky130_ef_sc_hd__decap_12
XFILLER_82_97 VPWR VGND VPWR VGND sky130_ef_sc_hd__decap_12
XFILLER_18_1426 VPWR VGND VPWR VGND sky130_ef_sc_hd__decap_12
XFILLER_53_1328 VGND VGND VPWR VPWR sky130_fd_sc_hd__fill_1
XFILLER_207_1177 VPWR VGND VPWR VGND sky130_ef_sc_hd__decap_12
XFILLER_198_97 VPWR VGND VPWR VGND sky130_ef_sc_hd__decap_12
XFILLER_15_80 VGND VGND VPWR VPWR sky130_fd_sc_hd__decap_8
X_386_ _108_ _124_ _117_ VGND VGND VPWR VPWR _125_ sky130_fd_sc_hd__a21oi_1
XFILLER_201_497 VGND VGND VPWR VPWR sky130_fd_sc_hd__decap_6
XFILLER_186_699 VGND VGND VPWR VPWR sky130_fd_sc_hd__fill_1
XFILLER_173_305 VPWR VGND VPWR VGND sky130_ef_sc_hd__decap_12
XPHY_EDGE_ROW_52_1_Right_638 VGND VGND VPWR VPWR sky130_fd_sc_hd__decap_3
XFILLER_173_349 VPWR VGND VPWR VGND sky130_ef_sc_hd__decap_12
XTAP_TAPCELL_ROW_171_1624 VGND VPWR sky130_fd_sc_hd__tapvpwrvgnd_1
XTAP_TAPCELL_ROW_171_1613 VGND VPWR sky130_fd_sc_hd__tapvpwrvgnd_1
XTAP_TAPCELL_ROW_171_1602 VGND VPWR sky130_fd_sc_hd__tapvpwrvgnd_1
XANTENNA__505__A3 net129 VGND VGND VPWR VPWR sky130_fd_sc_hd__diode_2
XFILLER_182_861 VGND VGND VPWR VPWR sky130_fd_sc_hd__decap_6
XFILLER_217_27 VPWR VGND VPWR VGND sky130_ef_sc_hd__decap_12
XFILLER_99_105 VGND VGND VPWR VPWR sky130_fd_sc_hd__decap_6
Xoutput108 net108 VGND VGND VPWR VPWR func_rdata[27] sky130_fd_sc_hd__buf_2
Xoutput119 net119 VGND VGND VPWR VPWR func_rdata[8] sky130_fd_sc_hd__buf_2
XFILLER_190_1421 VGND VGND VPWR VPWR sky130_fd_sc_hd__decap_6
XFILLER_181_393 VPWR VGND VPWR VGND sky130_ef_sc_hd__decap_12
XFILLER_177_1287 VGND VGND VPWR VPWR sky130_fd_sc_hd__fill_1
XFILLER_68_1582 VPWR VGND VPWR VGND sky130_ef_sc_hd__decap_12
XFILLER_29_1522 VPWR VGND VPWR VGND sky130_ef_sc_hd__decap_12
XTAP_TAPCELL_ROW_42_1_1101 VGND VPWR sky130_fd_sc_hd__tapvpwrvgnd_1
XFILLER_218_1273 VPWR VGND VPWR VGND sky130_ef_sc_hd__decap_12
XFILLER_155_1552 VGND VGND VPWR VPWR sky130_fd_sc_hd__fill_1
XFILLER_29_1566 VPWR VGND VPWR VGND sky130_ef_sc_hd__decap_12
XFILLER_190_1465 VPWR VGND VPWR VGND sky130_ef_sc_hd__decap_12
XTAP_TAPCELL_ROW_169_1564 VGND VPWR sky130_fd_sc_hd__tapvpwrvgnd_1
XTAP_TAPCELL_ROW_169_1553 VGND VPWR sky130_fd_sc_hd__tapvpwrvgnd_1
XFILLER_64_1468 VGND VGND VPWR VPWR sky130_fd_sc_hd__fill_1
Xoutput90 net90 VGND VGND VPWR VPWR func_rdata[10] sky130_fd_sc_hd__buf_2
XTAP_TAPCELL_ROW_165_1439 VGND VPWR sky130_fd_sc_hd__tapvpwrvgnd_1
XFILLER_209_553 VGND VGND VPWR VPWR sky130_fd_sc_hd__decap_6
XFILLER_114_1282 VPWR VGND VPWR VGND sky130_ef_sc_hd__decap_12
XFILLER_7_1373 VPWR VGND VPWR VGND sky130_ef_sc_hd__decap_12
XFILLER_209_597 VPWR VGND VPWR VGND sky130_ef_sc_hd__decap_12
XFILLER_184_1203 VGND VGND VPWR VPWR sky130_fd_sc_hd__fill_1
XFILLER_97_1244 VPWR VGND VPWR VGND sky130_ef_sc_hd__decap_12
XFILLER_197_909 VPWR VGND VPWR VGND sky130_ef_sc_hd__decap_12
XFILLER_149_1378 VGND VGND VPWR VPWR sky130_fd_sc_hd__decap_6
XFILLER_211_217 VGND VGND VPWR VPWR sky130_fd_sc_hd__decap_6
XFILLER_196_419 VGND VGND VPWR VPWR sky130_fd_sc_hd__fill_1
XFILLER_36_1526 VPWR VGND VPWR VGND sky130_ef_sc_hd__decap_12
XFILLER_176_121 VPWR VGND VPWR VGND sky130_ef_sc_hd__decap_12
XFILLER_176_165 VPWR VGND VPWR VGND sky130_ef_sc_hd__decap_12
XFILLER_192_625 VPWR VGND VPWR VGND sky130_ef_sc_hd__decap_12
XFILLER_191_113 VPWR VGND VPWR VGND sky130_ef_sc_hd__decap_12
XFILLER_178_1029 VGND VGND VPWR VPWR sky130_fd_sc_hd__decap_6
XFILLER_165_839 VGND VGND VPWR VPWR sky130_fd_sc_hd__fill_1
XFILLER_121_1220 VPWR VGND VPWR VGND sky130_ef_sc_hd__decap_12
XANTENNA__579__CLK clknet_3_1_0_clk VGND VGND VPWR VPWR sky130_fd_sc_hd__diode_2
XFILLER_34_1294 VGND VGND VPWR VPWR sky130_fd_sc_hd__decap_6
XFILLER_192_669 VPWR VGND VPWR VGND sky130_ef_sc_hd__decap_12
XFILLER_11_27 VPWR VGND VPWR VGND sky130_ef_sc_hd__decap_12
XFILLER_219_1037 VPWR VGND VPWR VGND sky130_ef_sc_hd__decap_12
XFILLER_195_1343 VGND VGND VPWR VPWR sky130_fd_sc_hd__fill_1
XFILLER_127_27 VPWR VGND VPWR VGND sky130_ef_sc_hd__decap_12
XFILLER_121_1286 VPWR VGND VPWR VGND sky130_ef_sc_hd__decap_12
XFILLER_156_1338 VPWR VGND VPWR VGND sky130_ef_sc_hd__decap_12
XTAP_TAPCELL_ROW_76_1_1169 VGND VPWR sky130_fd_sc_hd__tapvpwrvgnd_1
XTAP_TAPCELL_ROW_57_2_3348 VGND VPWR sky130_fd_sc_hd__tapvpwrvgnd_1
XFILLER_82_1524 VGND VGND VPWR VPWR sky130_fd_sc_hd__fill_1
XFILLER_207_93 VPWR VGND VPWR VGND sky130_ef_sc_hd__decap_12
XFILLER_143_15 VPWR VGND VPWR VGND sky130_ef_sc_hd__decap_12
XANTENNA_input3_A func_addr[0] VGND VGND VPWR VPWR sky130_fd_sc_hd__diode_2
XPHY_EDGE_ROW_14_1_Right_600 VGND VGND VPWR VPWR sky130_fd_sc_hd__decap_3
XFILLER_100_121 VGND VGND VPWR VPWR sky130_fd_sc_hd__decap_6
XFILLER_80_1270 VPWR VGND VPWR VGND sky130_ef_sc_hd__decap_12
XFILLER_41_1232 VPWR VGND VPWR VGND sky130_ef_sc_hd__decap_12
XTAP_TAPCELL_ROW_202_2502 VGND VPWR sky130_fd_sc_hd__tapvpwrvgnd_1
XFILLER_189_1169 VGND VGND VPWR VPWR sky130_fd_sc_hd__decap_6
XFILLER_167_1401 VPWR VGND VPWR VGND sky130_ef_sc_hd__decap_12
XFILLER_132_1382 VPWR VGND VPWR VGND sky130_ef_sc_hd__decap_12
XFILLER_41_1298 VPWR VGND VPWR VGND sky130_ef_sc_hd__decap_12
XFILLER_203_729 VPWR VGND VPWR VGND sky130_ef_sc_hd__decap_12
XPHY_EDGE_ROW_95_2_Right_152 VGND VGND VPWR VPWR sky130_fd_sc_hd__decap_3
XFILLER_208_1453 VPWR VGND VPWR VGND sky130_ef_sc_hd__decap_12
XPHY_EDGE_ROW_204_Right_49 VGND VGND VPWR VPWR sky130_fd_sc_hd__decap_3
XFILLER_199_279 VGND VGND VPWR VPWR sky130_fd_sc_hd__fill_1
XFILLER_208_1497 VPWR VGND VPWR VGND sky130_ef_sc_hd__decap_12
XFILLER_204_1317 VPWR VGND VPWR VGND sky130_ef_sc_hd__decap_12
XFILLER_195_441 VGND VGND VPWR VPWR sky130_fd_sc_hd__decap_6
XFILLER_139_3 VPWR VGND VPWR VGND sky130_ef_sc_hd__decap_12
XFILLER_52_1350 VGND VGND VPWR VPWR sky130_fd_sc_hd__decap_6
XFILLER_195_485 VPWR VGND VPWR VGND sky130_ef_sc_hd__decap_12
XFILLER_168_699 VGND VGND VPWR VPWR sky130_fd_sc_hd__fill_1
XFILLER_202_1085 VGND VGND VPWR VPWR sky130_fd_sc_hd__decap_6
XFILLER_196_1129 VPWR VGND VPWR VGND sky130_ef_sc_hd__decap_12
XFILLER_178_1541 VPWR VGND VPWR VGND sky130_ef_sc_hd__decap_12
XFILLER_171_809 VPWR VGND VPWR VGND sky130_ef_sc_hd__decap_12
XFILLER_164_861 VGND VGND VPWR VPWR sky130_fd_sc_hd__decap_6
XTAP_TAPCELL_ROW_154_2_3976 VGND VPWR sky130_fd_sc_hd__tapvpwrvgnd_1
XFILLER_104_1462 VGND VGND VPWR VPWR sky130_fd_sc_hd__decap_6
XFILLER_100_1326 VPWR VGND VPWR VGND sky130_ef_sc_hd__decap_12
XANTENNA__551__A net136 VGND VGND VPWR VPWR sky130_fd_sc_hd__diode_2
XFILLER_13_1378 VGND VGND VPWR VPWR sky130_fd_sc_hd__decap_6
XFILLER_52_1394 VPWR VGND VPWR VGND sky130_ef_sc_hd__decap_12
XTAP_TAPCELL_ROW_188_2107 VGND VPWR sky130_fd_sc_hd__tapvpwrvgnd_1
XPHY_EDGE_ROW_213_Right_58 VGND VGND VPWR VPWR sky130_fd_sc_hd__decap_3
XFILLER_184_77 VGND VGND VPWR VPWR sky130_fd_sc_hd__decap_6
XFILLER_174_1427 VGND VGND VPWR VPWR sky130_fd_sc_hd__fill_1
XFILLER_163_393 VPWR VGND VPWR VGND sky130_ef_sc_hd__decap_12
XTAP_TAPCELL_ROW_123_1_1264 VGND VPWR sky130_fd_sc_hd__tapvpwrvgnd_1
XFILLER_219_1593 VGND VGND VPWR VPWR sky130_fd_sc_hd__decap_3
XFILLER_215_1413 VPWR VGND VPWR VGND sky130_ef_sc_hd__decap_12
XTAP_TAPCELL_ROW_134_2_3852 VGND VPWR sky130_fd_sc_hd__tapvpwrvgnd_1
XFILLER_215_1457 VPWR VGND VPWR VGND sky130_ef_sc_hd__decap_12
XFILLER_172_1173 VPWR VGND VPWR VGND sky130_ef_sc_hd__decap_12
XFILLER_117_93 VPWR VGND VPWR VGND sky130_ef_sc_hd__decap_12
XFILLER_111_1422 VPWR VGND VPWR VGND sky130_ef_sc_hd__decap_12
XFILLER_63_1490 VGND VGND VPWR VPWR sky130_fd_sc_hd__decap_6
Xclkbuf_3_6_0_clk clknet_0_clk VGND VGND VPWR VPWR clknet_3_6_0_clk sky130_fd_sc_hd__clkbuf_8
XFILLER_206_501 VPWR VGND VPWR VGND sky130_ef_sc_hd__decap_12
XFILLER_150_1482 VPWR VGND VPWR VGND sky130_ef_sc_hd__decap_12
XFILLER_133_81 VPWR VGND VPWR VGND sky130_ef_sc_hd__decap_12
XFILLER_20_1338 VPWR VGND VPWR VGND sky130_ef_sc_hd__decap_12
XFILLER_206_545 VPWR VGND VPWR VGND sky130_ef_sc_hd__decap_12
XFILLER_111_1466 VPWR VGND VPWR VGND sky130_ef_sc_hd__decap_12
XFILLER_94_1406 VGND VGND VPWR VPWR sky130_fd_sc_hd__decap_6
XFILLER_206_589 VPWR VGND VPWR VGND sky130_ef_sc_hd__decap_12
XFILLER_185_1567 VGND VGND VPWR VPWR sky130_fd_sc_hd__fill_1
XFILLER_179_909 VPWR VGND VPWR VGND sky130_ef_sc_hd__decap_12
XFILLER_146_1518 VGND VGND VPWR VPWR sky130_fd_sc_hd__decap_6
XFILLER_178_419 VGND VGND VPWR VPWR sky130_fd_sc_hd__fill_1
XFILLER_144_1220 VPWR VGND VPWR VGND sky130_ef_sc_hd__decap_12
X_507_ net172 net121 net135 _227_ VGND VGND VPWR VPWR _037_ sky130_fd_sc_hd__o211a_1
XFILLER_57_1272 VGND VGND VPWR VPWR sky130_fd_sc_hd__fill_1
XFILLER_187_953 VPWR VGND VPWR VGND sky130_ef_sc_hd__decap_12
XFILLER_158_121 VGND VGND VPWR VPWR sky130_fd_sc_hd__decap_6
X_438_ net145 net113 VGND VGND VPWR VPWR _170_ sky130_fd_sc_hd__xor2_1
XFILLER_201_261 VPWR VGND VPWR VGND sky130_ef_sc_hd__decap_12
XFILLER_109_1384 VGND VGND VPWR VPWR sky130_fd_sc_hd__fill_1
XFILLER_9_120 VGND VGND VPWR VPWR sky130_fd_sc_hd__decap_4
X_369_ u_ctrl.elem_idx\[0\] _110_ _111_ VGND VGND VPWR VPWR _015_ sky130_fd_sc_hd__o21a_1
XFILLER_174_625 VPWR VGND VPWR VGND sky130_ef_sc_hd__decap_12
XFILLER_173_113 VPWR VGND VPWR VGND sky130_ef_sc_hd__decap_12
XFILLER_70_1450 VPWR VGND VPWR VGND sky130_ef_sc_hd__decap_12
XFILLER_31_1434 VGND VGND VPWR VPWR sky130_fd_sc_hd__decap_6
XFILLER_174_669 VPWR VGND VPWR VGND sky130_ef_sc_hd__decap_12
XFILLER_122_1562 VPWR VGND VPWR VGND sky130_ef_sc_hd__decap_12
XFILLER_70_1494 VPWR VGND VPWR VGND sky130_ef_sc_hd__decap_12
XPHY_EDGE_ROW_53_1_Right_639 VGND VGND VPWR VPWR sky130_fd_sc_hd__decap_3
XFILLER_6_860 VGND VGND VPWR VPWR sky130_fd_sc_hd__decap_8
XFILLER_31_1478 VPWR VGND VPWR VGND sky130_ef_sc_hd__decap_12
XTAP_TAPCELL_ROW_43_2_3256 VGND VPWR sky130_fd_sc_hd__tapvpwrvgnd_1
XFILLER_6_893 VPWR VGND VPWR VGND sky130_ef_sc_hd__decap_12
XFILLER_116_1300 VGND VGND VPWR VPWR sky130_fd_sc_hd__fill_1
XFILLER_64_1232 VPWR VGND VPWR VGND sky130_ef_sc_hd__decap_12
XFILLER_29_1330 VPWR VGND VPWR VGND sky130_ef_sc_hd__decap_12
XPHY_EDGE_ROW_124_2_Left_556 VGND VGND VPWR VPWR sky130_fd_sc_hd__decap_3
XFILLER_190_1273 VPWR VGND VPWR VGND sky130_ef_sc_hd__decap_12
XFILLER_151_1268 VGND VGND VPWR VPWR sky130_fd_sc_hd__decap_4
XFILLER_99_1328 VGND VGND VPWR VPWR sky130_fd_sc_hd__fill_1
XFILLER_81_1590 VPWR VGND VPWR VGND sky130_ef_sc_hd__decap_12
XFILLER_3_1001 VGND VGND VPWR VPWR sky130_fd_sc_hd__decap_6
XFILLER_216_309 VPWR VGND VPWR VGND sky130_ef_sc_hd__decap_12
XFILLER_209_361 VPWR VGND VPWR VGND sky130_ef_sc_hd__decap_12
XFILLER_186_1309 VGND VGND VPWR VPWR sky130_fd_sc_hd__decap_6
XFILLER_3_1045 VPWR VGND VPWR VGND sky130_ef_sc_hd__decap_12
XFILLER_42_1574 VGND VGND VPWR VPWR sky130_fd_sc_hd__decap_6
XTAP_TAPCELL_ROW_219_3018 VGND VPWR sky130_fd_sc_hd__tapvpwrvgnd_1
XTAP_TAPCELL_ROW_219_3007 VGND VPWR sky130_fd_sc_hd__tapvpwrvgnd_1
XFILLER_3_1089 VPWR VGND VPWR VGND sky130_ef_sc_hd__decap_12
XFILLER_127_1440 VGND VGND VPWR VPWR sky130_fd_sc_hd__fill_1
XFILLER_177_441 VGND VGND VPWR VPWR sky130_fd_sc_hd__decap_6
XFILLER_22_15 VPWR VGND VPWR VGND sky130_ef_sc_hd__decap_12
XFILLER_36_1356 VGND VGND VPWR VPWR sky130_fd_sc_hd__fill_1
XFILLER_193_945 VGND VGND VPWR VPWR sky130_fd_sc_hd__decap_6
XFILLER_177_485 VPWR VGND VPWR VGND sky130_ef_sc_hd__decap_12
XFILLER_138_15 VPWR VGND VPWR VGND sky130_ef_sc_hd__decap_12
XFILLER_197_1449 VGND VGND VPWR VPWR sky130_fd_sc_hd__decap_6
XFILLER_193_989 VPWR VGND VPWR VGND sky130_ef_sc_hd__decap_12
XFILLER_192_433 VPWR VGND VPWR VGND sky130_ef_sc_hd__decap_12
XFILLER_101_1602 VGND VGND VPWR VPWR sky130_fd_sc_hd__decap_3
XFILLER_192_477 VPWR VGND VPWR VGND sky130_ef_sc_hd__decap_12
XFILLER_10_1518 VGND VGND VPWR VPWR sky130_fd_sc_hd__decap_6
XTAP_TAPCELL_ROW_120_2_3760 VGND VPWR sky130_fd_sc_hd__tapvpwrvgnd_1
XANTENNA__350__A1 b_addr\[6\] VGND VGND VPWR VPWR sky130_fd_sc_hd__diode_2
XTAP_TAPCELL_ROW_119_2_3754 VGND VPWR sky130_fd_sc_hd__tapvpwrvgnd_1
XPHY_EDGE_ROW_56_2_Left_488 VGND VGND VPWR VPWR sky130_fd_sc_hd__decap_3
XFILLER_138_1580 VGND VGND VPWR VPWR sky130_fd_sc_hd__fill_1
XTAP_TAPCELL_ROW_87_2_3543 VGND VPWR sky130_fd_sc_hd__tapvpwrvgnd_1
Xfanout121 net122 VGND VGND VPWR VPWR net121 sky130_fd_sc_hd__clkbuf_2
XFILLER_173_1493 VPWR VGND VPWR VGND sky130_ef_sc_hd__decap_12
Xfanout132 _087_ VGND VGND VPWR VPWR net132 sky130_fd_sc_hd__clkbuf_2
Xfanout143 net144 VGND VGND VPWR VPWR net143 sky130_fd_sc_hd__buf_2
Xfanout154 b_ce VGND VGND VPWR VPWR net154 sky130_fd_sc_hd__clkbuf_2
XPHY_EDGE_ROW_15_1_Right_601 VGND VGND VPWR VPWR sky130_fd_sc_hd__decap_3
XFILLER_47_1496 VGND VGND VPWR VPWR sky130_fd_sc_hd__fill_1
XFILLER_219_125 VPWR VGND VPWR VGND sky130_ef_sc_hd__decap_12
XFILLER_219_169 VPWR VGND VPWR VGND sky130_ef_sc_hd__decap_12
XTAP_TAPCELL_ROW_112_2_3708 VGND VPWR sky130_fd_sc_hd__tapvpwrvgnd_1
XFILLER_210_1365 VGND VGND VPWR VPWR sky130_fd_sc_hd__decap_6
XFILLER_103_51 VGND VGND VPWR VPWR sky130_fd_sc_hd__decap_4
XTAP_TAPCELL_ROW_3_885 VGND VPWR sky130_fd_sc_hd__tapvpwrvgnd_1
XTAP_TAPCELL_ROW_3_874 VGND VPWR sky130_fd_sc_hd__tapvpwrvgnd_1
XFILLER_167_1231 VGND VGND VPWR VPWR sky130_fd_sc_hd__fill_1
XFILLER_187_205 VPWR VGND VPWR VGND sky130_ef_sc_hd__decap_12
XFILLER_163_1117 VGND VGND VPWR VPWR sky130_fd_sc_hd__decap_3
XPHY_EDGE_ROW_96_2_Right_153 VGND VGND VPWR VPWR sky130_fd_sc_hd__decap_3
XFILLER_63_55 VGND VGND VPWR VPWR sky130_fd_sc_hd__fill_1
XFILLER_19_1510 VPWR VGND VPWR VGND sky130_ef_sc_hd__decap_12
XFILLER_208_1261 VPWR VGND VPWR VGND sky130_ef_sc_hd__decap_12
XFILLER_203_559 VGND VGND VPWR VPWR sky130_fd_sc_hd__fill_1
XFILLER_187_249 VPWR VGND VPWR VGND sky130_ef_sc_hd__decap_12
XFILLER_179_55 VGND VGND VPWR VPWR sky130_fd_sc_hd__fill_1
XFILLER_169_953 VPWR VGND VPWR VGND sky130_ef_sc_hd__decap_12
XFILLER_19_1554 VPWR VGND VPWR VGND sky130_ef_sc_hd__decap_12
XFILLER_54_1412 VGND VGND VPWR VPWR sky130_fd_sc_hd__fill_1
XFILLER_180_1453 VPWR VGND VPWR VGND sky130_ef_sc_hd__decap_12
XFILLER_106_1524 VGND VGND VPWR VPWR sky130_fd_sc_hd__fill_1
XFILLER_204_1147 VGND VGND VPWR VPWR sky130_fd_sc_hd__fill_1
XFILLER_184_923 VGND VGND VPWR VPWR sky130_fd_sc_hd__fill_1
XFILLER_180_1497 VPWR VGND VPWR VGND sky130_ef_sc_hd__decap_12
XFILLER_155_113 VPWR VGND VPWR VGND sky130_ef_sc_hd__decap_12
XFILLER_7_613 VGND VGND VPWR VPWR sky130_fd_sc_hd__fill_1
XFILLER_195_293 VPWR VGND VPWR VGND sky130_ef_sc_hd__decap_12
XFILLER_104_1270 VPWR VGND VPWR VGND sky130_ef_sc_hd__decap_12
XFILLER_6_123 VPWR VGND VPWR VGND sky130_ef_sc_hd__decap_12
XFILLER_7_657 VPWR VGND VPWR VGND sky130_ef_sc_hd__decap_12
XTAP_TAPCELL_ROW_28_2_3158 VGND VPWR sky130_fd_sc_hd__tapvpwrvgnd_1
XFILLER_171_617 VPWR VGND VPWR VGND sky130_ef_sc_hd__decap_12
XFILLER_87_1232 VPWR VGND VPWR VGND sky130_ef_sc_hd__decap_12
XFILLER_178_1371 VGND VGND VPWR VPWR sky130_fd_sc_hd__fill_1
XTAP_TAPCELL_ROW_154_1_1325 VGND VPWR sky130_fd_sc_hd__tapvpwrvgnd_1
XFILLER_139_1322 VGND VGND VPWR VPWR sky130_fd_sc_hd__decap_6
XFILLER_139_1366 VPWR VGND VPWR VGND sky130_ef_sc_hd__decap_12
XFILLER_88_41 VPWR VGND VPWR VGND sky130_ef_sc_hd__decap_12
XFILLER_87_1298 VPWR VGND VPWR VGND sky130_ef_sc_hd__decap_12
XFILLER_88_85 VPWR VGND VPWR VGND sky130_ef_sc_hd__decap_12
XFILLER_65_1552 VGND VGND VPWR VPWR sky130_fd_sc_hd__fill_1
XFILLER_191_1593 VPWR VGND VPWR VGND sky130_ef_sc_hd__decap_12
XFILLER_215_1287 VGND VGND VPWR VPWR sky130_fd_sc_hd__fill_1
XFILLER_24_1282 VPWR VGND VPWR VGND sky130_ef_sc_hd__decap_12
XFILLER_207_821 VPWR VGND VPWR VGND sky130_ef_sc_hd__decap_12
XFILLER_168_1017 VPWR VGND VPWR VGND sky130_ef_sc_hd__decap_12
XFILLER_98_1350 VGND VGND VPWR VPWR sky130_fd_sc_hd__decap_6
XFILLER_4_1365 VGND VGND VPWR VPWR sky130_fd_sc_hd__decap_6
XFILLER_207_865 VPWR VGND VPWR VGND sky130_ef_sc_hd__decap_12
XFILLER_111_1274 VPWR VGND VPWR VGND sky130_ef_sc_hd__decap_12
XFILLER_98_1394 VPWR VGND VPWR VGND sky130_ef_sc_hd__decap_12
XFILLER_0_1229 VGND VGND VPWR VPWR sky130_fd_sc_hd__decap_3
XFILLER_146_1326 VPWR VGND VPWR VGND sky130_ef_sc_hd__decap_12
XFILLER_94_1258 VPWR VGND VPWR VGND sky130_ef_sc_hd__decap_12
XFILLER_59_1378 VGND VGND VPWR VPWR sky130_fd_sc_hd__decap_6
XFILLER_124_1602 VGND VGND VPWR VPWR sky130_fd_sc_hd__decap_3
XFILLER_202_581 VGND VGND VPWR VPWR sky130_fd_sc_hd__decap_6
XFILLER_187_783 VGND VGND VPWR VPWR sky130_fd_sc_hd__fill_1
XFILLER_175_945 VGND VGND VPWR VPWR sky130_fd_sc_hd__decap_6
XFILLER_179_1113 VGND VGND VPWR VPWR sky130_fd_sc_hd__decap_6
XFILLER_174_433 VPWR VGND VPWR VGND sky130_ef_sc_hd__decap_12
XFILLER_31_1220 VPWR VGND VPWR VGND sky130_ef_sc_hd__decap_12
XFILLER_190_937 VPWR VGND VPWR VGND sky130_ef_sc_hd__decap_12
XFILLER_179_1157 VPWR VGND VPWR VGND sky130_ef_sc_hd__decap_12
XFILLER_175_989 VPWR VGND VPWR VGND sky130_ef_sc_hd__decap_12
XFILLER_174_477 VPWR VGND VPWR VGND sky130_ef_sc_hd__decap_12
XFILLER_161_105 VGND VGND VPWR VPWR sky130_fd_sc_hd__decap_6
XFILLER_122_1370 VPWR VGND VPWR VGND sky130_ef_sc_hd__decap_12
XFILLER_200_1589 VGND VGND VPWR VPWR sky130_fd_sc_hd__decap_6
XFILLER_157_1422 VPWR VGND VPWR VGND sky130_ef_sc_hd__decap_12
XFILLER_108_29 VPWR VGND VPWR VGND sky130_ef_sc_hd__decap_12
XTAP_TAPCELL_ROW_105_2_3662 VGND VPWR sky130_fd_sc_hd__tapvpwrvgnd_1
XFILLER_31_1286 VPWR VGND VPWR VGND sky130_ef_sc_hd__decap_12
XFILLER_157_1466 VPWR VGND VPWR VGND sky130_ef_sc_hd__decap_12
XFILLER_118_1406 VGND VGND VPWR VPWR sky130_fd_sc_hd__decap_6
XTAP_TAPCELL_ROW_73_2_3451 VGND VPWR sky130_fd_sc_hd__tapvpwrvgnd_1
XFILLER_66_1338 VPWR VGND VPWR VGND sky130_ef_sc_hd__decap_12
XANTENNA__617__CLK clknet_3_3_0_clk VGND VGND VPWR VPWR sky130_fd_sc_hd__diode_2
XFILLER_216_1029 VGND VGND VPWR VPWR sky130_fd_sc_hd__decap_6
XFILLER_9_1232 VPWR VGND VPWR VGND sky130_ef_sc_hd__decap_12
XFILLER_9_1298 VPWR VGND VPWR VGND sky130_ef_sc_hd__decap_12
XFILLER_217_629 VPWR VGND VPWR VGND sky130_ef_sc_hd__decap_12
XFILLER_83_111 VGND VGND VPWR VPWR sky130_fd_sc_hd__fill_1
XFILLER_216_139 VGND VGND VPWR VPWR sky130_fd_sc_hd__fill_1
XFILLER_204_83 VGND VGND VPWR VPWR sky130_fd_sc_hd__fill_1
XFILLER_186_1117 VPWR VGND VPWR VGND sky130_ef_sc_hd__decap_12
XTAP_TAPCELL_ROW_0_800 VGND VPWR sky130_fd_sc_hd__tapvpwrvgnd_1
XFILLER_17_15 VPWR VGND VPWR VGND sky130_ef_sc_hd__decap_12
XFILLER_42_1382 VPWR VGND VPWR VGND sky130_ef_sc_hd__decap_12
XFILLER_140_27 VGND VGND VPWR VPWR sky130_fd_sc_hd__fill_1
XFILLER_77_1434 VGND VGND VPWR VPWR sky130_fd_sc_hd__decap_6
XFILLER_212_301 VGND VGND VPWR VPWR sky130_fd_sc_hd__decap_6
XFILLER_197_503 VGND VGND VPWR VPWR sky130_fd_sc_hd__fill_1
XFILLER_168_1595 VGND VGND VPWR VPWR sky130_fd_sc_hd__fill_1
XFILLER_169_205 VPWR VGND VPWR VGND sky130_ef_sc_hd__decap_12
XFILLER_129_1546 VGND VGND VPWR VPWR sky130_fd_sc_hd__decap_6
XFILLER_77_1478 VPWR VGND VPWR VGND sky130_ef_sc_hd__decap_12
XFILLER_212_345 VPWR VGND VPWR VGND sky130_ef_sc_hd__decap_12
XFILLER_205_1401 VPWR VGND VPWR VGND sky130_ef_sc_hd__decap_12
XFILLER_169_249 VPWR VGND VPWR VGND sky130_ef_sc_hd__decap_12
XANTENNA_fanout151_X net151 VGND VGND VPWR VPWR sky130_fd_sc_hd__diode_2
XFILLER_212_389 VPWR VGND VPWR VGND sky130_ef_sc_hd__decap_12
XFILLER_209_1581 VPWR VGND VPWR VGND sky130_ef_sc_hd__decap_12
XFILLER_185_709 VPWR VGND VPWR VGND sky130_ef_sc_hd__decap_12
XFILLER_166_923 VGND VGND VPWR VPWR sky130_fd_sc_hd__fill_1
XFILLER_137_113 VPWR VGND VPWR VGND sky130_ef_sc_hd__decap_12
XTAP_TAPCELL_ROW_14_2_3066 VGND VPWR sky130_fd_sc_hd__tapvpwrvgnd_1
XFILLER_33_69 VGND VGND VPWR VPWR sky130_fd_sc_hd__decap_8
XFILLER_197_1213 VPWR VGND VPWR VGND sky130_ef_sc_hd__decap_12
XFILLER_193_753 VPWR VGND VPWR VGND sky130_ef_sc_hd__decap_12
XFILLER_177_293 VPWR VGND VPWR VGND sky130_ef_sc_hd__decap_12
XFILLER_149_69 VPWR VGND VPWR VGND sky130_ef_sc_hd__decap_12
XFILLER_197_1257 VPWR VGND VPWR VGND sky130_ef_sc_hd__decap_12
XFILLER_193_797 VPWR VGND VPWR VGND sky130_ef_sc_hd__decap_12
XFILLER_140_1470 VPWR VGND VPWR VGND sky130_ef_sc_hd__decap_12
XFILLER_105_1590 VPWR VGND VPWR VGND sky130_ef_sc_hd__decap_12
XFILLER_101_1410 VPWR VGND VPWR VGND sky130_ef_sc_hd__decap_12
XFILLER_10_1326 VPWR VGND VPWR VGND sky130_ef_sc_hd__decap_12
XFILLER_14_1462 VGND VGND VPWR VPWR sky130_fd_sc_hd__decap_6
XFILLER_175_1511 VGND VGND VPWR VPWR sky130_fd_sc_hd__fill_1
XFILLER_101_1454 VPWR VGND VPWR VGND sky130_ef_sc_hd__decap_12
XFILLER_88_1574 VGND VGND VPWR VPWR sky130_fd_sc_hd__decap_6
XFILLER_180_469 VGND VGND VPWR VPWR sky130_fd_sc_hd__decap_6
XFILLER_165_57 VPWR VGND VPWR VGND sky130_ef_sc_hd__decap_12
XFILLER_136_1506 VPWR VGND VPWR VGND sky130_ef_sc_hd__decap_12
XFILLER_101_1498 VPWR VGND VPWR VGND sky130_ef_sc_hd__decap_12
XFILLER_84_1438 VPWR VGND VPWR VGND sky130_ef_sc_hd__decap_12
XFILLER_3_137 VPWR VGND VPWR VGND sky130_ef_sc_hd__decap_12
XFILLER_216_1541 VPWR VGND VPWR VGND sky130_ef_sc_hd__decap_12
XFILLER_212_1427 VGND VGND VPWR VPWR sky130_fd_sc_hd__fill_1
XFILLER_58_77 VGND VGND VPWR VPWR sky130_fd_sc_hd__decap_6
XPHY_EDGE_ROW_16_1_Right_602 VGND VGND VPWR VPWR sky130_fd_sc_hd__decap_3
XFILLER_169_1337 VGND VGND VPWR VPWR sky130_fd_sc_hd__decap_6
XFILLER_114_83 VGND VGND VPWR VPWR sky130_fd_sc_hd__fill_1
XFILLER_112_1550 VPWR VGND VPWR VGND sky130_ef_sc_hd__decap_12
XFILLER_1_1505 VGND VGND VPWR VPWR sky130_fd_sc_hd__decap_6
XFILLER_21_1422 VPWR VGND VPWR VGND sky130_ef_sc_hd__decap_12
XFILLER_60_1482 VPWR VGND VPWR VGND sky130_ef_sc_hd__decap_12
XFILLER_210_1173 VPWR VGND VPWR VGND sky130_ef_sc_hd__decap_12
XFILLER_147_1602 VGND VGND VPWR VPWR sky130_fd_sc_hd__decap_3
XFILLER_112_1594 VGND VGND VPWR VPWR sky130_fd_sc_hd__decap_8
XFILLER_95_1534 VPWR VGND VPWR VGND sky130_ef_sc_hd__decap_12
XFILLER_74_65 VPWR VGND VPWR VGND sky130_ef_sc_hd__decap_12
XFILLER_1_1549 VPWR VGND VPWR VGND sky130_ef_sc_hd__decap_12
XFILLER_21_1466 VPWR VGND VPWR VGND sky130_ef_sc_hd__decap_12
XFILLER_215_161 VGND VGND VPWR VPWR sky130_fd_sc_hd__decap_6
XFILLER_204_813 VPWR VGND VPWR VGND sky130_ef_sc_hd__decap_12
XTAP_TAPCELL_ROW_142_2_3903 VGND VPWR sky130_fd_sc_hd__tapvpwrvgnd_1
XFILLER_95_1578 VPWR VGND VPWR VGND sky130_ef_sc_hd__decap_12
XFILLER_56_1518 VGND VGND VPWR VPWR sky130_fd_sc_hd__decap_6
XFILLER_188_525 VGND VGND VPWR VPWR sky130_fd_sc_hd__decap_6
Xu_sram.u_mem_159 VGND VGND VPWR VPWR u_sram.u_mem_159/HI net159 sky130_fd_sc_hd__conb_1
XFILLER_54_1220 VPWR VGND VPWR VGND sky130_ef_sc_hd__decap_12
XFILLER_188_569 VPWR VGND VPWR VGND sky130_ef_sc_hd__decap_12
XPHY_EDGE_ROW_97_2_Right_154 VGND VGND VPWR VPWR sky130_fd_sc_hd__decap_3
XFILLER_90_53 VPWR VGND VPWR VGND sky130_ef_sc_hd__decap_12
XFILLER_208_1091 VGND VGND VPWR VPWR sky130_fd_sc_hd__fill_1
XFILLER_180_1261 VPWR VGND VPWR VGND sky130_ef_sc_hd__decap_12
XFILLER_169_783 VGND VGND VPWR VPWR sky130_fd_sc_hd__fill_1
XFILLER_90_97 VPWR VGND VPWR VGND sky130_ef_sc_hd__decap_12
XFILLER_19_1384 VGND VGND VPWR VPWR sky130_fd_sc_hd__fill_1
XFILLER_141_1256 VPWR VGND VPWR VGND sky130_ef_sc_hd__decap_12
XTAP_TAPCELL_ROW_78_2_3488 VGND VPWR sky130_fd_sc_hd__tapvpwrvgnd_1
XFILLER_7_421 VPWR VGND VPWR VGND sky130_ef_sc_hd__decap_12
XFILLER_209_39 VPWR VGND VPWR VGND sky130_ef_sc_hd__decap_12
XFILLER_172_937 VPWR VGND VPWR VGND sky130_ef_sc_hd__decap_12
XFILLER_143_105 VGND VGND VPWR VPWR sky130_fd_sc_hd__decap_6
XFILLER_32_1562 VPWR VGND VPWR VGND sky130_ef_sc_hd__decap_12
XFILLER_171_447 VGND VGND VPWR VPWR sky130_fd_sc_hd__fill_1
XFILLER_99_51 VGND VGND VPWR VPWR sky130_fd_sc_hd__decap_4
XTAP_TAPCELL_ROW_58_2_3353 VGND VPWR sky130_fd_sc_hd__tapvpwrvgnd_1
XFILLER_180_981 VPWR VGND VPWR VGND sky130_ef_sc_hd__decap_12
XFILLER_26_1300 VGND VGND VPWR VPWR sky130_fd_sc_hd__fill_1
XFILLER_6_1427 VGND VGND VPWR VPWR sky130_fd_sc_hd__fill_1
XFILLER_65_111 VGND VGND VPWR VPWR sky130_fd_sc_hd__fill_1
XFILLER_17_3 VPWR VGND VPWR VGND sky130_ef_sc_hd__decap_12
XTAP_TAPCELL_ROW_51_2_3307 VGND VPWR sky130_fd_sc_hd__tapvpwrvgnd_1
XFILLER_61_1268 VGND VGND VPWR VPWR sky130_fd_sc_hd__decap_4
XFILLER_187_1437 VPWR VGND VPWR VGND sky130_ef_sc_hd__decap_12
XFILLER_4_1173 VPWR VGND VPWR VGND sky130_ef_sc_hd__decap_12
XFILLER_207_673 VPWR VGND VPWR VGND sky130_ef_sc_hd__decap_12
XFILLER_179_503 VGND VGND VPWR VPWR sky130_fd_sc_hd__fill_1
XFILLER_0_1037 VPWR VGND VPWR VGND sky130_ef_sc_hd__decap_12
XFILLER_210_805 VGND VGND VPWR VPWR sky130_fd_sc_hd__decap_6
XFILLER_167_709 VPWR VGND VPWR VGND sky130_ef_sc_hd__decap_12
XFILLER_37_1440 VGND VGND VPWR VPWR sky130_fd_sc_hd__fill_1
XFILLER_210_849 VPWR VGND VPWR VGND sky130_ef_sc_hd__decap_12
XFILLER_163_1481 VGND VGND VPWR VPWR sky130_fd_sc_hd__decap_3
XFILLER_198_1533 VGND VGND VPWR VPWR sky130_fd_sc_hd__decap_6
XFILLER_175_753 VPWR VGND VPWR VGND sky130_ef_sc_hd__decap_12
XFILLER_119_113 VPWR VGND VPWR VGND sky130_ef_sc_hd__decap_12
XFILLER_198_1577 VPWR VGND VPWR VGND sky130_ef_sc_hd__decap_12
XFILLER_190_701 VPWR VGND VPWR VGND sky130_ef_sc_hd__decap_12
XFILLER_175_797 VPWR VGND VPWR VGND sky130_ef_sc_hd__decap_12
XFILLER_163_937 VPWR VGND VPWR VGND sky130_ef_sc_hd__decap_12
XFILLER_119_39 VPWR VGND VPWR VGND sky130_ef_sc_hd__decap_12
XFILLER_11_1602 VGND VGND VPWR VPWR sky130_fd_sc_hd__decap_3
XFILLER_200_1353 VPWR VGND VPWR VGND sky130_ef_sc_hd__decap_12
XFILLER_200_1397 VPWR VGND VPWR VGND sky130_ef_sc_hd__decap_12
XFILLER_157_1274 VPWR VGND VPWR VGND sky130_ef_sc_hd__decap_12
XFILLER_135_27 VPWR VGND VPWR VGND sky130_ef_sc_hd__decap_12
XTAP_TAPCELL_ROW_28_1_1074 VGND VPWR sky130_fd_sc_hd__tapvpwrvgnd_1
XFILLER_118_1258 VPWR VGND VPWR VGND sky130_ef_sc_hd__decap_12
XFILLER_48_1580 VGND VGND VPWR VPWR sky130_fd_sc_hd__fill_1
XFILLER_218_905 VPWR VGND VPWR VGND sky130_ef_sc_hd__decap_12
XFILLER_170_1441 VPWR VGND VPWR VGND sky130_ef_sc_hd__decap_12
XTAP_TAPCELL_ROW_5_925 VGND VPWR sky130_fd_sc_hd__tapvpwrvgnd_1
XTAP_TAPCELL_ROW_5_936 VGND VPWR sky130_fd_sc_hd__tapvpwrvgnd_1
XTAP_TAPCELL_ROW_5_947 VGND VPWR sky130_fd_sc_hd__tapvpwrvgnd_1
XFILLER_215_93 VPWR VGND VPWR VGND sky130_ef_sc_hd__decap_12
XFILLER_170_1485 VPWR VGND VPWR VGND sky130_ef_sc_hd__decap_12
XFILLER_151_15 VPWR VGND VPWR VGND sky130_ef_sc_hd__decap_12
XFILLER_56_122 VGND VGND VPWR VPWR sky130_fd_sc_hd__decap_4
XFILLER_218_949 VPWR VGND VPWR VGND sky130_ef_sc_hd__decap_12
XFILLER_211_1493 VPWR VGND VPWR VGND sky130_ef_sc_hd__decap_12
XTAP_TAPCELL_ROW_127_2_3805 VGND VPWR sky130_fd_sc_hd__tapvpwrvgnd_1
XFILLER_77_1220 VPWR VGND VPWR VGND sky130_ef_sc_hd__decap_12
XFILLER_204_109 VPWR VGND VPWR VGND sky130_ef_sc_hd__decap_12
XFILLER_129_1310 VPWR VGND VPWR VGND sky130_ef_sc_hd__decap_12
XFILLER_71_125 VGND VGND VPWR VPWR sky130_fd_sc_hd__fill_2
XFILLER_129_1354 VPWR VGND VPWR VGND sky130_ef_sc_hd__decap_12
XFILLER_77_1286 VPWR VGND VPWR VGND sky130_ef_sc_hd__decap_12
XFILLER_213_665 VGND VGND VPWR VPWR sky130_fd_sc_hd__decap_6
XFILLER_212_153 VPWR VGND VPWR VGND sky130_ef_sc_hd__decap_12
XFILLER_198_867 VGND VGND VPWR VPWR sky130_fd_sc_hd__fill_1
XFILLER_129_1398 VPWR VGND VPWR VGND sky130_ef_sc_hd__decap_12
XFILLER_0_1593 VGND VGND VPWR VPWR sky130_fd_sc_hd__decap_3
XFILLER_212_197 VPWR VGND VPWR VGND sky130_ef_sc_hd__decap_12
XFILLER_205_1231 VGND VGND VPWR VPWR sky130_fd_sc_hd__fill_1
XTAP_TAPCELL_ROW_195_2294 VGND VPWR sky130_fd_sc_hd__tapvpwrvgnd_1
XFILLER_185_517 VPWR VGND VPWR VGND sky130_ef_sc_hd__decap_12
XFILLER_181_1581 VPWR VGND VPWR VGND sky130_ef_sc_hd__decap_12
XFILLER_100_41 VPWR VGND VPWR VGND sky130_ef_sc_hd__decap_12
XTAP_TAPCELL_ROW_83_1_1184 VGND VPWR sky130_fd_sc_hd__tapvpwrvgnd_1
XTAP_TAPCELL_ROW_64_2_3396 VGND VPWR sky130_fd_sc_hd__tapvpwrvgnd_1
XFILLER_16_1524 VGND VGND VPWR VPWR sky130_fd_sc_hd__fill_1
XFILLER_100_85 VPWR VGND VPWR VGND sky130_ef_sc_hd__decap_12
XANTENNA__544__A1 _191_ VGND VGND VPWR VPWR sky130_fd_sc_hd__diode_2
XFILLER_219_3 VPWR VGND VPWR VGND sky130_ef_sc_hd__decap_12
XFILLER_197_1021 VPWR VGND VPWR VGND sky130_ef_sc_hd__decap_12
XFILLER_193_561 VPWR VGND VPWR VGND sky130_ef_sc_hd__decap_12
XFILLER_121_3 VPWR VGND VPWR VGND sky130_ef_sc_hd__decap_12
XTAP_TAPCELL_ROW_44_2_3261 VGND VPWR sky130_fd_sc_hd__tapvpwrvgnd_1
XTAP_TAPCELL_ROW_216_2898 VGND VPWR sky130_fd_sc_hd__tapvpwrvgnd_1
XTAP_TAPCELL_ROW_216_2887 VGND VPWR sky130_fd_sc_hd__tapvpwrvgnd_1
XFILLER_197_1065 VPWR VGND VPWR VGND sky130_ef_sc_hd__decap_12
XFILLER_125_105 VGND VGND VPWR VPWR sky130_fd_sc_hd__decap_6
XFILLER_14_1270 VPWR VGND VPWR VGND sky130_ef_sc_hd__decap_12
XFILLER_180_233 VPWR VGND VPWR VGND sky130_ef_sc_hd__decap_12
XFILLER_88_1382 VPWR VGND VPWR VGND sky130_ef_sc_hd__decap_12
XPHY_EDGE_ROW_16_2_Right_73 VGND VGND VPWR VPWR sky130_fd_sc_hd__decap_3
XFILLER_49_1322 VGND VGND VPWR VPWR sky130_fd_sc_hd__decap_6
XFILLER_180_277 VPWR VGND VPWR VGND sky130_ef_sc_hd__decap_12
XFILLER_136_1314 VPWR VGND VPWR VGND sky130_ef_sc_hd__decap_12
XFILLER_84_1246 VPWR VGND VPWR VGND sky130_ef_sc_hd__decap_12
XFILLER_49_1366 VPWR VGND VPWR VGND sky130_ef_sc_hd__decap_12
XFILLER_192_77 VGND VGND VPWR VPWR sky130_fd_sc_hd__decap_6
XFILLER_136_1358 VPWR VGND VPWR VGND sky130_ef_sc_hd__decap_12
XANTENNA_input41_A func_wdata[7] VGND VGND VPWR VPWR sky130_fd_sc_hd__diode_2
XFILLER_216_1371 VGND VGND VPWR VPWR sky130_fd_sc_hd__fill_1
XFILLER_0_641 VGND VGND VPWR VPWR sky130_fd_sc_hd__decap_3
XFILLER_125_93 VPWR VGND VPWR VGND sky130_ef_sc_hd__decap_12
XFILLER_0_696 VGND VGND VPWR VPWR sky130_fd_sc_hd__decap_4
XTAP_TAPCELL_ROW_36_2_3209 VGND VPWR sky130_fd_sc_hd__tapvpwrvgnd_1
XFILLER_47_111 VGND VGND VPWR VPWR sky130_fd_sc_hd__fill_1
XFILLER_169_1101 VPWR VGND VPWR VGND sky130_ef_sc_hd__decap_12
XPHY_EDGE_ROW_17_1_Right_603 VGND VGND VPWR VPWR sky130_fd_sc_hd__decap_3
XFILLER_169_1145 VPWR VGND VPWR VGND sky130_ef_sc_hd__decap_12
XFILLER_1_1313 VPWR VGND VPWR VGND sky130_ef_sc_hd__decap_12
XFILLER_5_1493 VPWR VGND VPWR VGND sky130_ef_sc_hd__decap_12
XTAP_TAPCELL_ROW_180_1884 VGND VPWR sky130_fd_sc_hd__tapvpwrvgnd_1
XTAP_TAPCELL_ROW_180_1873 VGND VPWR sky130_fd_sc_hd__tapvpwrvgnd_1
XTAP_TAPCELL_ROW_180_1862 VGND VPWR sky130_fd_sc_hd__tapvpwrvgnd_1
XFILLER_169_1189 VPWR VGND VPWR VGND sky130_ef_sc_hd__decap_12
XFILLER_165_1009 VPWR VGND VPWR VGND sky130_ef_sc_hd__decap_12
XFILLER_147_1410 VPWR VGND VPWR VGND sky130_ef_sc_hd__decap_12
XFILLER_141_81 VPWR VGND VPWR VGND sky130_ef_sc_hd__decap_12
XFILLER_95_1342 VPWR VGND VPWR VGND sky130_ef_sc_hd__decap_12
XFILLER_1_1357 VPWR VGND VPWR VGND sky130_ef_sc_hd__decap_12
XFILLER_21_1274 VPWR VGND VPWR VGND sky130_ef_sc_hd__decap_12
XFILLER_204_643 VGND VGND VPWR VPWR sky130_fd_sc_hd__fill_1
XFILLER_147_1454 VPWR VGND VPWR VGND sky130_ef_sc_hd__decap_12
XFILLER_95_1386 VPWR VGND VPWR VGND sky130_ef_sc_hd__decap_12
XFILLER_56_1326 VPWR VGND VPWR VGND sky130_ef_sc_hd__decap_12
XFILLER_206_1017 VPWR VGND VPWR VGND sky130_ef_sc_hd__decap_12
XFILLER_189_889 VGND VGND VPWR VPWR sky130_fd_sc_hd__decap_6
XFILLER_188_333 VPWR VGND VPWR VGND sky130_ef_sc_hd__decap_12
XFILLER_108_1438 VPWR VGND VPWR VGND sky130_ef_sc_hd__decap_12
XFILLER_34_1602 VGND VGND VPWR VPWR sky130_fd_sc_hd__decap_3
XFILLER_188_377 VPWR VGND VPWR VGND sky130_ef_sc_hd__decap_12
XFILLER_147_1498 VPWR VGND VPWR VGND sky130_ef_sc_hd__decap_12
XPHY_EDGE_ROW_133_2_Left_565 VGND VGND VPWR VPWR sky130_fd_sc_hd__decap_3
XPHY_EDGE_ROW_98_2_Right_155 VGND VGND VPWR VPWR sky130_fd_sc_hd__decap_3
XFILLER_180_1091 VGND VGND VPWR VPWR sky130_fd_sc_hd__fill_1
XFILLER_200_893 VPWR VGND VPWR VGND sky130_ef_sc_hd__decap_12
XPHY_EDGE_ROW_172_Right_17 VGND VGND VPWR VPWR sky130_fd_sc_hd__decap_3
XFILLER_172_701 VPWR VGND VPWR VGND sky130_ef_sc_hd__decap_12
XFILLER_176_1105 VPWR VGND VPWR VGND sky130_ef_sc_hd__decap_12
XTAP_TAPCELL_ROW_174_1699 VGND VPWR sky130_fd_sc_hd__tapvpwrvgnd_1
XTAP_TAPCELL_ROW_174_1688 VGND VPWR sky130_fd_sc_hd__tapvpwrvgnd_1
XPHY_EDGE_ROW_70_2_Left_502 VGND VGND VPWR VPWR sky130_fd_sc_hd__decap_3
XFILLER_32_1370 VPWR VGND VPWR VGND sky130_ef_sc_hd__decap_12
XFILLER_176_1149 VPWR VGND VPWR VGND sky130_ef_sc_hd__decap_12
XFILLER_158_1550 VPWR VGND VPWR VGND sky130_ef_sc_hd__decap_12
XFILLER_67_1422 VPWR VGND VPWR VGND sky130_ef_sc_hd__decap_12
XFILLER_217_1113 VGND VGND VPWR VPWR sky130_fd_sc_hd__decap_6
XFILLER_154_1414 VPWR VGND VPWR VGND sky130_ef_sc_hd__decap_12
XFILLER_119_1534 VPWR VGND VPWR VGND sky130_ef_sc_hd__decap_12
XFILLER_67_1466 VPWR VGND VPWR VGND sky130_ef_sc_hd__decap_12
XFILLER_28_1406 VGND VGND VPWR VPWR sky130_fd_sc_hd__decap_6
XFILLER_217_1157 VPWR VGND VPWR VGND sky130_ef_sc_hd__decap_12
XFILLER_158_1594 VGND VGND VPWR VPWR sky130_fd_sc_hd__decap_8
XFILLER_119_1578 VPWR VGND VPWR VGND sky130_ef_sc_hd__decap_12
XPHY_EDGE_ROW_181_Right_26 VGND VGND VPWR VPWR sky130_fd_sc_hd__decap_3
XFILLER_187_1201 VPWR VGND VPWR VGND sky130_ef_sc_hd__decap_12
XTAP_TAPCELL_ROW_113_2_3713 VGND VPWR sky130_fd_sc_hd__tapvpwrvgnd_1
XFILLER_187_1245 VPWR VGND VPWR VGND sky130_ef_sc_hd__decap_12
XFILLER_208_993 VPWR VGND VPWR VGND sky130_ef_sc_hd__decap_12
XFILLER_199_609 VGND VGND VPWR VPWR sky130_fd_sc_hd__decap_6
XFILLER_187_1289 VPWR VGND VPWR VGND sky130_ef_sc_hd__decap_12
XTAP_TAPCELL_ROW_81_2_3502 VGND VPWR sky130_fd_sc_hd__tapvpwrvgnd_1
XFILLER_78_1562 VPWR VGND VPWR VGND sky130_ef_sc_hd__decap_12
XFILLER_53_125 VGND VGND VPWR VPWR sky130_fd_sc_hd__fill_2
XFILLER_74_1426 VPWR VGND VPWR VGND sky130_ef_sc_hd__decap_12
XFILLER_39_1546 VGND VGND VPWR VPWR sky130_fd_sc_hd__decap_6
XFILLER_210_613 VPWR VGND VPWR VGND sky130_ef_sc_hd__decap_12
XFILLER_201_51 VGND VGND VPWR VPWR sky130_fd_sc_hd__decap_4
XFILLER_126_1538 VPWR VGND VPWR VGND sky130_ef_sc_hd__decap_12
XPHY_EDGE_ROW_65_2_Left_497 VGND VGND VPWR VPWR sky130_fd_sc_hd__decap_3
XFILLER_14_27 VGND VGND VPWR VPWR sky130_fd_sc_hd__fill_1
XTAP_TAPCELL_ROW_49_2_3298 VGND VPWR sky130_fd_sc_hd__tapvpwrvgnd_1
XFILLER_167_517 VPWR VGND VPWR VGND sky130_ef_sc_hd__decap_12
XFILLER_210_657 VPWR VGND VPWR VGND sky130_ef_sc_hd__decap_12
XFILLER_206_1595 VGND VGND VPWR VPWR sky130_fd_sc_hd__fill_1
XPHY_EDGE_ROW_190_Right_35 VGND VGND VPWR VPWR sky130_fd_sc_hd__decap_3
XANTENNA__363__B b_addr\[6\] VGND VGND VPWR VPWR sky130_fd_sc_hd__diode_2
XFILLER_198_1341 VPWR VGND VPWR VGND sky130_ef_sc_hd__decap_12
XFILLER_175_561 VPWR VGND VPWR VGND sky130_ef_sc_hd__decap_12
XFILLER_163_701 VPWR VGND VPWR VGND sky130_ef_sc_hd__decap_12
XFILLER_198_1385 VPWR VGND VPWR VGND sky130_ef_sc_hd__decap_12
XFILLER_194_1205 VPWR VGND VPWR VGND sky130_ef_sc_hd__decap_12
XFILLER_190_531 VGND VGND VPWR VPWR sky130_fd_sc_hd__fill_1
XFILLER_107_105 VGND VGND VPWR VPWR sky130_fd_sc_hd__decap_6
XFILLER_11_1410 VPWR VGND VPWR VGND sky130_ef_sc_hd__decap_12
XFILLER_15_1590 VPWR VGND VPWR VGND sky130_ef_sc_hd__decap_12
XFILLER_30_15 VPWR VGND VPWR VGND sky130_ef_sc_hd__decap_12
XFILLER_50_1470 VPWR VGND VPWR VGND sky130_ef_sc_hd__decap_12
XTAP_TAPCELL_ROW_211_2740 VGND VPWR sky130_fd_sc_hd__tapvpwrvgnd_1
XFILLER_200_1161 VPWR VGND VPWR VGND sky130_ef_sc_hd__decap_12
XFILLER_146_15 VPWR VGND VPWR VGND sky130_ef_sc_hd__decap_12
XFILLER_102_1582 VPWR VGND VPWR VGND sky130_ef_sc_hd__decap_12
XFILLER_85_1522 VPWR VGND VPWR VGND sky130_ef_sc_hd__decap_12
XFILLER_11_1454 VPWR VGND VPWR VGND sky130_ef_sc_hd__decap_12
XTAP_TAPCELL_ROW_211_2762 VGND VPWR sky130_fd_sc_hd__tapvpwrvgnd_1
XTAP_TAPCELL_ROW_211_2751 VGND VPWR sky130_fd_sc_hd__tapvpwrvgnd_1
XFILLER_85_1566 VPWR VGND VPWR VGND sky130_ef_sc_hd__decap_12
XFILLER_11_1498 VPWR VGND VPWR VGND sky130_ef_sc_hd__decap_12
XFILLER_46_1506 VPWR VGND VPWR VGND sky130_ef_sc_hd__decap_12
XFILLER_1_438 VGND VGND VPWR VPWR sky130_fd_sc_hd__decap_4
XFILLER_1_449 VPWR VGND VPWR VGND sky130_ef_sc_hd__decap_12
XTAP_TAPCELL_ROW_59_1_1135 VGND VPWR sky130_fd_sc_hd__tapvpwrvgnd_1
XFILLER_213_1511 VGND VGND VPWR VPWR sky130_fd_sc_hd__fill_1
XFILLER_39_57 VPWR VGND VPWR VGND sky130_ef_sc_hd__decap_12
XFILLER_218_713 VPWR VGND VPWR VGND sky130_ef_sc_hd__decap_12
XFILLER_217_223 VGND VGND VPWR VPWR sky130_fd_sc_hd__fill_1
XTAP_TAPCELL_ROW_209_2691 VGND VPWR sky130_fd_sc_hd__tapvpwrvgnd_1
XPHY_EDGE_ROW_144_1_Right_730 VGND VGND VPWR VPWR sky130_fd_sc_hd__decap_3
XFILLER_131_1244 VPWR VGND VPWR VGND sky130_ef_sc_hd__decap_12
XPHY_EDGE_ROW_129_1_Left_348 VGND VGND VPWR VPWR sky130_fd_sc_hd__decap_3
XFILLER_218_757 VPWR VGND VPWR VGND sky130_ef_sc_hd__decap_12
X_540_ net77 _174_ net126 VGND VGND VPWR VPWR _244_ sky130_fd_sc_hd__mux2_1
XFILLER_22_1550 VPWR VGND VPWR VGND sky130_ef_sc_hd__decap_12
XTAP_TAPCELL_ROW_205_2588 VGND VPWR sky130_fd_sc_hd__tapvpwrvgnd_1
XTAP_TAPCELL_ROW_205_2577 VGND VPWR sky130_fd_sc_hd__tapvpwrvgnd_1
XFILLER_205_429 VPWR VGND VPWR VGND sky130_ef_sc_hd__decap_12
XFILLER_169_3 VPWR VGND VPWR VGND sky130_ef_sc_hd__decap_12
XFILLER_166_1329 VPWR VGND VPWR VGND sky130_ef_sc_hd__decap_12
XFILLER_22_1594 VGND VGND VPWR VPWR sky130_fd_sc_hd__decap_8
XFILLER_57_1602 VGND VGND VPWR VPWR sky130_fd_sc_hd__decap_3
XTAP_TAPCELL_ROW_197_2356 VGND VPWR sky130_fd_sc_hd__tapvpwrvgnd_1
XTAP_TAPCELL_ROW_197_2345 VGND VPWR sky130_fd_sc_hd__tapvpwrvgnd_1
XFILLER_92_1526 VPWR VGND VPWR VGND sky130_ef_sc_hd__decap_12
X_471_ _174_ _175_ _178_ _179_ VGND VGND VPWR VPWR _203_ sky130_fd_sc_hd__or4_1
XFILLER_207_1337 VGND VGND VPWR VPWR sky130_fd_sc_hd__decap_6
XTAP_TAPCELL_ROW_197_2367 VGND VPWR sky130_fd_sc_hd__tapvpwrvgnd_1
XFILLER_111_51 VGND VGND VPWR VPWR sky130_fd_sc_hd__decap_4
XFILLER_213_473 VPWR VGND VPWR VGND sky130_ef_sc_hd__decap_12
XFILLER_186_837 VPWR VGND VPWR VGND sky130_ef_sc_hd__decap_12
XFILLER_71_55 VGND VGND VPWR VPWR sky130_fd_sc_hd__fill_1
XTAP_TAPCELL_ROW_218_2949 VGND VPWR sky130_fd_sc_hd__tapvpwrvgnd_1
XFILLER_187_55 VGND VGND VPWR VPWR sky130_fd_sc_hd__fill_1
XFILLER_200_189 VGND VGND VPWR VPWR sky130_fd_sc_hd__decap_6
XTAP_TAPCELL_ROW_94_2_3591 VGND VPWR sky130_fd_sc_hd__tapvpwrvgnd_1
XFILLER_90_1294 VGND VGND VPWR VPWR sky130_fd_sc_hd__decap_6
XFILLER_51_1256 VPWR VGND VPWR VGND sky130_ef_sc_hd__decap_12
XFILLER_194_881 VPWR VGND VPWR VGND sky130_ef_sc_hd__decap_12
XFILLER_177_1425 VPWR VGND VPWR VGND sky130_ef_sc_hd__decap_12
XFILLER_193_391 VGND VGND VPWR VPWR sky130_fd_sc_hd__fill_1
XFILLER_181_553 VGND VGND VPWR VPWR sky130_fd_sc_hd__decap_6
XFILLER_4_221 VGND VGND VPWR VPWR sky130_fd_sc_hd__fill_2
XFILLER_5_766 VGND VGND VPWR VPWR sky130_fd_sc_hd__decap_8
XFILLER_181_597 VPWR VGND VPWR VGND sky130_ef_sc_hd__decap_12
XFILLER_177_1469 VPWR VGND VPWR VGND sky130_ef_sc_hd__decap_12
XTAP_TAPCELL_ROW_106_1_1230 VGND VPWR sky130_fd_sc_hd__tapvpwrvgnd_1
XFILLER_4_276 VPWR VGND VPWR VGND sky130_ef_sc_hd__decap_12
XFILLER_206_29 VPWR VGND VPWR VGND sky130_ef_sc_hd__decap_12
XFILLER_218_1477 VGND VGND VPWR VPWR sky130_fd_sc_hd__decap_6
XFILLER_171_1057 VGND VGND VPWR VPWR sky130_fd_sc_hd__decap_6
XFILLER_96_41 VPWR VGND VPWR VGND sky130_ef_sc_hd__decap_12
XTAP_TAPCELL_ROW_86_2_3539 VGND VPWR sky130_fd_sc_hd__tapvpwrvgnd_1
XFILLER_96_85 VPWR VGND VPWR VGND sky130_ef_sc_hd__decap_12
XFILLER_188_1521 VPWR VGND VPWR VGND sky130_ef_sc_hd__decap_12
XTAP_TAPCELL_ROW_182_1935 VGND VPWR sky130_fd_sc_hd__tapvpwrvgnd_1
XTAP_TAPCELL_ROW_182_1924 VGND VPWR sky130_fd_sc_hd__tapvpwrvgnd_1
XTAP_TAPCELL_ROW_182_1913 VGND VPWR sky130_fd_sc_hd__tapvpwrvgnd_1
XFILLER_0_493 VGND VGND VPWR VPWR sky130_fd_sc_hd__decap_4
XFILLER_208_245 VGND VGND VPWR VPWR sky130_fd_sc_hd__decap_6
XTAP_TAPCELL_ROW_167_1492 VGND VPWR sky130_fd_sc_hd__tapvpwrvgnd_1
XTAP_TAPCELL_ROW_163_1356 VGND VPWR sky130_fd_sc_hd__tapvpwrvgnd_1
XTAP_TAPCELL_ROW_163_1345 VGND VPWR sky130_fd_sc_hd__tapvpwrvgnd_1
XTAP_TAPCELL_ROW_66_2_3404 VGND VPWR sky130_fd_sc_hd__tapvpwrvgnd_1
XFILLER_208_289 VPWR VGND VPWR VGND sky130_ef_sc_hd__decap_12
XFILLER_188_1565 VPWR VGND VPWR VGND sky130_ef_sc_hd__decap_12
XFILLER_184_1429 VPWR VGND VPWR VGND sky130_ef_sc_hd__decap_12
XTAP_TAPCELL_ROW_163_1389 VGND VPWR sky130_fd_sc_hd__tapvpwrvgnd_1
XTAP_TAPCELL_ROW_163_1378 VGND VPWR sky130_fd_sc_hd__tapvpwrvgnd_1
XTAP_TAPCELL_ROW_163_1367 VGND VPWR sky130_fd_sc_hd__tapvpwrvgnd_1
XFILLER_1_1121 VPWR VGND VPWR VGND sky130_ef_sc_hd__decap_12
XPHY_EDGE_ROW_18_1_Right_604 VGND VGND VPWR VPWR sky130_fd_sc_hd__decap_3
XFILLER_189_653 VPWR VGND VPWR VGND sky130_ef_sc_hd__decap_12
XFILLER_188_141 VPWR VGND VPWR VGND sky130_ef_sc_hd__decap_12
XPHY_EDGE_ROW_50_1_Left_269 VGND VGND VPWR VPWR sky130_fd_sc_hd__decap_3
XFILLER_189_697 VPWR VGND VPWR VGND sky130_ef_sc_hd__decap_12
XTAP_TAPCELL_ROW_161_1_1340 VGND VPWR sky130_fd_sc_hd__tapvpwrvgnd_1
XFILLER_108_1246 VPWR VGND VPWR VGND sky130_ef_sc_hd__decap_12
XANTENNA__464__A net148 VGND VGND VPWR VPWR sky130_fd_sc_hd__diode_2
XFILLER_182_1197 VGND VGND VPWR VPWR sky130_fd_sc_hd__decap_6
XFILLER_84_3 VPWR VGND VPWR VGND sky130_ef_sc_hd__decap_12
XFILLER_160_1462 VGND VGND VPWR VPWR sky130_fd_sc_hd__decap_6
XPHY_EDGE_ROW_99_2_Right_156 VGND VGND VPWR VPWR sky130_fd_sc_hd__decap_3
XFILLER_191_317 VPWR VGND VPWR VGND sky130_ef_sc_hd__decap_12
XFILLER_201_1481 VPWR VGND VPWR VGND sky130_ef_sc_hd__decap_12
XFILLER_195_1525 VPWR VGND VPWR VGND sky130_ef_sc_hd__decap_12
XFILLER_172_531 VGND VGND VPWR VPWR sky130_fd_sc_hd__fill_1
XFILLER_195_1569 VPWR VGND VPWR VGND sky130_ef_sc_hd__decap_12
XFILLER_119_1342 VPWR VGND VPWR VGND sky130_ef_sc_hd__decap_12
XFILLER_116_29 VPWR VGND VPWR VGND sky130_ef_sc_hd__decap_12
XFILLER_67_1274 VPWR VGND VPWR VGND sky130_ef_sc_hd__decap_12
XFILLER_154_1244 VGND VGND VPWR VPWR sky130_fd_sc_hd__fill_1
XFILLER_119_1386 VPWR VGND VPWR VGND sky130_ef_sc_hd__decap_12
XFILLER_28_1258 VPWR VGND VPWR VGND sky130_ef_sc_hd__decap_12
XFILLER_215_727 VGND VGND VPWR VPWR sky130_fd_sc_hd__fill_1
XFILLER_199_417 VPWR VGND VPWR VGND sky130_ef_sc_hd__decap_12
XFILLER_26_125 VGND VGND VPWR VPWR sky130_fd_sc_hd__fill_2
XFILLER_212_83 VGND VGND VPWR VPWR sky130_fd_sc_hd__fill_1
XFILLER_78_1370 VPWR VGND VPWR VGND sky130_ef_sc_hd__decap_12
XFILLER_25_15 VGND VGND VPWR VPWR sky130_fd_sc_hd__decap_8
XFILLER_39_1310 VPWR VGND VPWR VGND sky130_ef_sc_hd__decap_12
XTAP_TAPCELL_ROW_200_2452 VGND VPWR sky130_fd_sc_hd__tapvpwrvgnd_1
XTAP_TAPCELL_ROW_200_2441 VGND VPWR sky130_fd_sc_hd__tapvpwrvgnd_1
XTAP_TAPCELL_ROW_200_2430 VGND VPWR sky130_fd_sc_hd__tapvpwrvgnd_1
XFILLER_126_1302 VPWR VGND VPWR VGND sky130_ef_sc_hd__decap_12
XFILLER_39_1354 VPWR VGND VPWR VGND sky130_ef_sc_hd__decap_12
XFILLER_211_933 VPWR VGND VPWR VGND sky130_ef_sc_hd__decap_12
XFILLER_210_421 VPWR VGND VPWR VGND sky130_ef_sc_hd__decap_12
XFILLER_168_837 VPWR VGND VPWR VGND sky130_ef_sc_hd__decap_12
XFILLER_39_1398 VPWR VGND VPWR VGND sky130_ef_sc_hd__decap_12
XFILLER_211_977 VPWR VGND VPWR VGND sky130_ef_sc_hd__decap_12
XFILLER_194_133 VGND VGND VPWR VPWR sky130_fd_sc_hd__decap_6
XTAP_TAPCELL_ROW_192_2220 VGND VPWR sky130_fd_sc_hd__tapvpwrvgnd_1
XTAP_TAPCELL_ROW_79_2_3493 VGND VPWR sky130_fd_sc_hd__tapvpwrvgnd_1
XTAP_TAPCELL_ROW_213_2824 VGND VPWR sky130_fd_sc_hd__tapvpwrvgnd_1
XTAP_TAPCELL_ROW_213_2813 VGND VPWR sky130_fd_sc_hd__tapvpwrvgnd_1
XTAP_TAPCELL_ROW_213_2802 VGND VPWR sky130_fd_sc_hd__tapvpwrvgnd_1
XFILLER_194_177 VPWR VGND VPWR VGND sky130_ef_sc_hd__decap_12
XFILLER_176_881 VPWR VGND VPWR VGND sky130_ef_sc_hd__decap_12
XFILLER_41_69 VPWR VGND VPWR VGND sky130_ef_sc_hd__decap_12
XFILLER_175_391 VGND VGND VPWR VPWR sky130_fd_sc_hd__fill_1
XFILLER_157_69 VPWR VGND VPWR VGND sky130_ef_sc_hd__decap_12
XFILLER_194_1035 VGND VGND VPWR VPWR sky130_fd_sc_hd__fill_1
XFILLER_191_895 VGND VGND VPWR VPWR sky130_fd_sc_hd__fill_1
XFILLER_85_1330 VPWR VGND VPWR VGND sky130_ef_sc_hd__decap_12
XTAP_TAPCELL_ROW_186_2035 VGND VPWR sky130_fd_sc_hd__tapvpwrvgnd_1
XFILLER_137_1442 VPWR VGND VPWR VGND sky130_ef_sc_hd__decap_12
XTAP_TAPCELL_ROW_72_2_3447 VGND VPWR sky130_fd_sc_hd__tapvpwrvgnd_1
XFILLER_46_1314 VPWR VGND VPWR VGND sky130_ef_sc_hd__decap_12
XTAP_TAPCELL_ROW_186_2046 VGND VPWR sky130_fd_sc_hd__tapvpwrvgnd_1
XFILLER_173_57 VPWR VGND VPWR VGND sky130_ef_sc_hd__decap_12
XFILLER_46_1358 VPWR VGND VPWR VGND sky130_ef_sc_hd__decap_12
XFILLER_133_1328 VGND VGND VPWR VPWR sky130_fd_sc_hd__fill_1
XTAP_TAPCELL_ROW_207_2639 VGND VPWR sky130_fd_sc_hd__tapvpwrvgnd_1
XTAP_TAPCELL_ROW_207_2628 VGND VPWR sky130_fd_sc_hd__tapvpwrvgnd_1
XANTENNA__549__A net136 VGND VGND VPWR VPWR sky130_fd_sc_hd__diode_2
XTAP_TAPCELL_ROW_199_2407 VGND VPWR sky130_fd_sc_hd__tapvpwrvgnd_1
XPHY_EDGE_ROW_145_1_Right_731 VGND VGND VPWR VPWR sky130_fd_sc_hd__decap_3
XFILLER_66_77 VGND VGND VPWR VPWR sky130_fd_sc_hd__decap_6
XFILLER_17_103 VGND VGND VPWR VPWR sky130_fd_sc_hd__decap_8
XFILLER_218_587 VGND VGND VPWR VPWR sky130_fd_sc_hd__fill_1
XTAP_TAPCELL_ROW_199_2418 VGND VPWR sky130_fd_sc_hd__tapvpwrvgnd_1
XFILLER_2_1441 VPWR VGND VPWR VGND sky130_ef_sc_hd__decap_12
XFILLER_206_749 VGND VGND VPWR VPWR sky130_fd_sc_hd__decap_6
XFILLER_205_237 VPWR VGND VPWR VGND sky130_ef_sc_hd__decap_12
XFILLER_122_83 VGND VGND VPWR VPWR sky130_fd_sc_hd__fill_1
XFILLER_96_1470 VPWR VGND VPWR VGND sky130_ef_sc_hd__decap_12
X_523_ net150 _199_ net128 net137 _235_ VGND VGND VPWR VPWR _045_ sky130_fd_sc_hd__o311a_1
XFILLER_2_1485 VPWR VGND VPWR VGND sky130_ef_sc_hd__decap_12
XFILLER_57_1410 VPWR VGND VPWR VGND sky130_ef_sc_hd__decap_12
XFILLER_207_1101 VPWR VGND VPWR VGND sky130_ef_sc_hd__decap_12
XFILLER_199_951 VGND VGND VPWR VPWR sky130_fd_sc_hd__fill_1
XFILLER_109_1522 VPWR VGND VPWR VGND sky130_ef_sc_hd__decap_12
XFILLER_82_65 VPWR VGND VPWR VGND sky130_ef_sc_hd__decap_12
X_454_ net145 net96 VGND VGND VPWR VPWR _186_ sky130_fd_sc_hd__xor2_1
XFILLER_57_1454 VPWR VGND VPWR VGND sky130_ef_sc_hd__decap_12
XFILLER_214_793 VPWR VGND VPWR VGND sky130_ef_sc_hd__decap_12
XFILLER_213_281 VPWR VGND VPWR VGND sky130_ef_sc_hd__decap_12
XFILLER_207_1145 VPWR VGND VPWR VGND sky130_ef_sc_hd__decap_12
XFILLER_198_65 VPWR VGND VPWR VGND sky130_ef_sc_hd__decap_12
XFILLER_186_601 VPWR VGND VPWR VGND sky130_ef_sc_hd__decap_12
XFILLER_148_1582 VPWR VGND VPWR VGND sky130_ef_sc_hd__decap_12
XFILLER_92_1356 VGND VGND VPWR VPWR sky130_fd_sc_hd__fill_1
XFILLER_18_1438 VPWR VGND VPWR VGND sky130_ef_sc_hd__decap_12
XFILLER_207_1189 VPWR VGND VPWR VGND sky130_ef_sc_hd__decap_12
XFILLER_203_1009 VPWR VGND VPWR VGND sky130_ef_sc_hd__decap_12
XFILLER_186_645 VPWR VGND VPWR VGND sky130_ef_sc_hd__decap_12
XFILLER_185_111 VGND VGND VPWR VPWR sky130_fd_sc_hd__fill_1
XFILLER_144_1468 VGND VGND VPWR VPWR sky130_fd_sc_hd__fill_1
XFILLER_109_1566 VPWR VGND VPWR VGND sky130_ef_sc_hd__decap_12
X_385_ b_addr\[0\] _123_ VGND VGND VPWR VPWR _124_ sky130_fd_sc_hd__xor2_1
XFILLER_57_1498 VPWR VGND VPWR VGND sky130_ef_sc_hd__decap_12
XFILLER_173_317 VPWR VGND VPWR VGND sky130_ef_sc_hd__decap_12
XTAP_TAPCELL_ROW_171_1614 VGND VPWR sky130_fd_sc_hd__tapvpwrvgnd_1
XTAP_TAPCELL_ROW_171_1603 VGND VPWR sky130_fd_sc_hd__tapvpwrvgnd_1
XFILLER_177_1233 VPWR VGND VPWR VGND sky130_ef_sc_hd__decap_12
XTAP_TAPCELL_ROW_171_1625 VGND VPWR sky130_fd_sc_hd__tapvpwrvgnd_1
XFILLER_217_39 VPWR VGND VPWR VGND sky130_ef_sc_hd__decap_12
XFILLER_181_361 VPWR VGND VPWR VGND sky130_ef_sc_hd__decap_12
XFILLER_68_1550 VPWR VGND VPWR VGND sky130_ef_sc_hd__decap_12
Xoutput109 net109 VGND VGND VPWR VPWR func_rdata[28] sky130_fd_sc_hd__buf_2
XFILLER_5_552 VGND VGND VPWR VPWR sky130_fd_sc_hd__fill_2
XFILLER_218_1241 VPWR VGND VPWR VGND sky130_ef_sc_hd__decap_12
XFILLER_173_1119 VGND VGND VPWR VPWR sky130_fd_sc_hd__fill_1
XFILLER_64_1414 VPWR VGND VPWR VGND sky130_ef_sc_hd__decap_12
XFILLER_29_1534 VPWR VGND VPWR VGND sky130_ef_sc_hd__decap_12
XTAP_TAPCELL_ROW_42_1_1102 VGND VPWR sky130_fd_sc_hd__tapvpwrvgnd_1
XFILLER_218_1285 VPWR VGND VPWR VGND sky130_ef_sc_hd__decap_12
XFILLER_214_1105 VPWR VGND VPWR VGND sky130_ef_sc_hd__decap_12
XFILLER_68_1594 VGND VGND VPWR VPWR sky130_fd_sc_hd__decap_8
XFILLER_214_1149 VPWR VGND VPWR VGND sky130_ef_sc_hd__decap_12
XFILLER_190_1477 VGND VGND VPWR VPWR sky130_fd_sc_hd__decap_6
XTAP_TAPCELL_ROW_169_1565 VGND VPWR sky130_fd_sc_hd__tapvpwrvgnd_1
XTAP_TAPCELL_ROW_169_1554 VGND VPWR sky130_fd_sc_hd__tapvpwrvgnd_1
XTAP_TAPCELL_ROW_169_1543 VGND VPWR sky130_fd_sc_hd__tapvpwrvgnd_1
XFILLER_116_1526 VPWR VGND VPWR VGND sky130_ef_sc_hd__decap_12
Xoutput80 net80 VGND VGND VPWR VPWR bist_fail_bits[30] sky130_fd_sc_hd__buf_2
Xoutput91 net91 VGND VGND VPWR VPWR func_rdata[11] sky130_fd_sc_hd__buf_2
XFILLER_29_1578 VPWR VGND VPWR VGND sky130_ef_sc_hd__decap_12
XTAP_TAPCELL_ROW_165_1429 VGND VPWR sky130_fd_sc_hd__tapvpwrvgnd_1
XANTENNA__459__A net148 VGND VGND VPWR VPWR sky130_fd_sc_hd__diode_2
XFILLER_7_1341 VGND VGND VPWR VPWR sky130_fd_sc_hd__decap_3
XFILLER_7_1385 VPWR VGND VPWR VGND sky130_ef_sc_hd__decap_12
XTAP_TAPCELL_ROW_128_2_3810 VGND VPWR sky130_fd_sc_hd__tapvpwrvgnd_1
XFILLER_114_1294 VGND VGND VPWR VPWR sky130_fd_sc_hd__decap_6
XFILLER_97_1256 VPWR VGND VPWR VGND sky130_ef_sc_hd__decap_12
XFILLER_188_1373 VPWR VGND VPWR VGND sky130_ef_sc_hd__decap_12
XFILLER_75_1510 VPWR VGND VPWR VGND sky130_ef_sc_hd__decap_12
XPHY_EDGE_ROW_19_1_Right_605 VGND VGND VPWR VPWR sky130_fd_sc_hd__decap_3
XFILLER_184_1259 VGND VGND VPWR VPWR sky130_fd_sc_hd__fill_1
XFILLER_189_461 VPWR VGND VPWR VGND sky130_ef_sc_hd__decap_12
XFILLER_162_1524 VGND VGND VPWR VPWR sky130_fd_sc_hd__fill_1
XFILLER_75_1554 VPWR VGND VPWR VGND sky130_ef_sc_hd__decap_12
XFILLER_36_1538 VPWR VGND VPWR VGND sky130_ef_sc_hd__decap_12
XFILLER_176_133 VGND VGND VPWR VPWR sky130_fd_sc_hd__decap_6
XFILLER_192_637 VGND VGND VPWR VPWR sky130_fd_sc_hd__decap_6
XFILLER_191_125 VPWR VGND VPWR VGND sky130_ef_sc_hd__decap_12
XFILLER_176_177 VPWR VGND VPWR VGND sky130_ef_sc_hd__decap_12
XFILLER_160_1270 VPWR VGND VPWR VGND sky130_ef_sc_hd__decap_12
XFILLER_121_1232 VPWR VGND VPWR VGND sky130_ef_sc_hd__decap_12
XFILLER_11_39 VGND VGND VPWR VPWR sky130_fd_sc_hd__decap_6
XFILLER_219_1005 VGND VGND VPWR VPWR sky130_fd_sc_hd__decap_3
XFILLER_191_169 VPWR VGND VPWR VGND sky130_ef_sc_hd__decap_12
XFILLER_173_895 VGND VGND VPWR VPWR sky130_fd_sc_hd__fill_1
XFILLER_127_39 VPWR VGND VPWR VGND sky130_ef_sc_hd__decap_12
XFILLER_121_1298 VPWR VGND VPWR VGND sky130_ef_sc_hd__decap_12
XFILLER_12_1582 VPWR VGND VPWR VGND sky130_ef_sc_hd__decap_12
XFILLER_219_1049 VPWR VGND VPWR VGND sky130_ef_sc_hd__decap_12
XFILLER_195_1399 VGND VGND VPWR VPWR sky130_fd_sc_hd__fill_1
XTAP_TAPCELL_ROW_57_2_3349 VGND VPWR sky130_fd_sc_hd__tapvpwrvgnd_1
XFILLER_143_27 VPWR VGND VPWR VGND sky130_ef_sc_hd__decap_12
XFILLER_132_1350 VGND VGND VPWR VPWR sky130_fd_sc_hd__decap_6
XFILLER_80_1282 VPWR VGND VPWR VGND sky130_ef_sc_hd__decap_12
XFILLER_41_1244 VPWR VGND VPWR VGND sky130_ef_sc_hd__decap_12
XTAP_TAPCELL_ROW_202_2503 VGND VPWR sky130_fd_sc_hd__tapvpwrvgnd_1
XFILLER_167_1413 VPWR VGND VPWR VGND sky130_ef_sc_hd__decap_12
XFILLER_132_1394 VPWR VGND VPWR VGND sky130_ef_sc_hd__decap_12
XFILLER_199_225 VPWR VGND VPWR VGND sky130_ef_sc_hd__decap_12
XFILLER_208_1421 VGND VGND VPWR VPWR sky130_fd_sc_hd__decap_6
XFILLER_167_1457 VPWR VGND VPWR VGND sky130_ef_sc_hd__decap_12
XFILLER_14_106 VGND VGND VPWR VPWR sky130_fd_sc_hd__decap_4
XPHY_EDGE_ROW_25_2_Right_82 VGND VGND VPWR VPWR sky130_fd_sc_hd__decap_3
XFILLER_168_601 VPWR VGND VPWR VGND sky130_ef_sc_hd__decap_12
XFILLER_211_741 VPWR VGND VPWR VGND sky130_ef_sc_hd__decap_12
XFILLER_208_1465 VPWR VGND VPWR VGND sky130_ef_sc_hd__decap_12
XFILLER_168_645 VPWR VGND VPWR VGND sky130_ef_sc_hd__decap_12
XFILLER_167_111 VGND VGND VPWR VPWR sky130_fd_sc_hd__fill_1
XFILLER_211_785 VPWR VGND VPWR VGND sky130_ef_sc_hd__decap_12
XFILLER_210_251 VGND VGND VPWR VPWR sky130_fd_sc_hd__fill_1
XFILLER_204_1329 VPWR VGND VPWR VGND sky130_ef_sc_hd__decap_12
XFILLER_195_497 VGND VGND VPWR VPWR sky130_fd_sc_hd__decap_6
XFILLER_183_615 VGND VGND VPWR VPWR sky130_fd_sc_hd__fill_1
XFILLER_143_1490 VGND VGND VPWR VPWR sky130_fd_sc_hd__decap_6
XTAP_TAPCELL_ROW_154_2_3977 VGND VPWR sky130_fd_sc_hd__tapvpwrvgnd_1
XANTENNA__499__A3 net129 VGND VGND VPWR VPWR sky130_fd_sc_hd__diode_2
XFILLER_201_3 VPWR VGND VPWR VGND sky130_ef_sc_hd__decap_12
XTAP_TAPCELL_ROW_188_2108 VGND VPWR sky130_fd_sc_hd__tapvpwrvgnd_1
XFILLER_178_1553 VPWR VGND VPWR VGND sky130_ef_sc_hd__decap_12
XFILLER_170_309 VPWR VGND VPWR VGND sky130_ef_sc_hd__decap_12
XFILLER_163_361 VGND VGND VPWR VPWR sky130_fd_sc_hd__decap_3
XFILLER_100_1338 VPWR VGND VPWR VGND sky130_ef_sc_hd__decap_12
XFILLER_178_1597 VGND VGND VPWR VPWR sky130_fd_sc_hd__decap_8
XFILLER_96_109 VPWR VGND VPWR VGND sky130_ef_sc_hd__decap_12
XFILLER_215_1425 VPWR VGND VPWR VGND sky130_ef_sc_hd__decap_12
XFILLER_172_1141 VGND VGND VPWR VPWR sky130_fd_sc_hd__decap_6
XFILLER_137_1272 VGND VGND VPWR VPWR sky130_fd_sc_hd__fill_1
XFILLER_215_1469 VPWR VGND VPWR VGND sky130_ef_sc_hd__decap_12
XFILLER_172_1185 VPWR VGND VPWR VGND sky130_ef_sc_hd__decap_12
XANTENNA__279__A b_addr\[7\] VGND VGND VPWR VPWR sky130_fd_sc_hd__diode_2
XFILLER_219_841 VPWR VGND VPWR VGND sky130_ef_sc_hd__decap_12
XFILLER_150_1450 VPWR VGND VPWR VGND sky130_ef_sc_hd__decap_12
XPHY_EDGE_ROW_142_2_Left_574 VGND VGND VPWR VPWR sky130_fd_sc_hd__decap_3
XFILLER_206_513 VPWR VGND VPWR VGND sky130_ef_sc_hd__decap_12
XFILLER_150_1494 VPWR VGND VPWR VGND sky130_ef_sc_hd__decap_12
XFILLER_133_93 VPWR VGND VPWR VGND sky130_ef_sc_hd__decap_12
XFILLER_111_1434 VGND VGND VPWR VPWR sky130_fd_sc_hd__decap_6
XFILLER_185_1513 VPWR VGND VPWR VGND sky130_ef_sc_hd__decap_12
XPHY_EDGE_ROW_146_1_Right_732 VGND VGND VPWR VPWR sky130_fd_sc_hd__decap_3
XFILLER_111_1478 VPWR VGND VPWR VGND sky130_ef_sc_hd__decap_12
XFILLER_206_557 VPWR VGND VPWR VGND sky130_ef_sc_hd__decap_12
X_506_ _172_ net121 VGND VGND VPWR VPWR _227_ sky130_fd_sc_hd__nand2_1
XFILLER_187_921 VPWR VGND VPWR VGND sky130_ef_sc_hd__decap_12
XFILLER_109_1330 VPWR VGND VPWR VGND sky130_ef_sc_hd__decap_12
XFILLER_183_1281 VGND VGND VPWR VPWR sky130_fd_sc_hd__decap_6
XFILLER_144_1232 VPWR VGND VPWR VGND sky130_ef_sc_hd__decap_12
X_437_ net147 net89 VGND VGND VPWR VPWR _169_ sky130_fd_sc_hd__xor2_1
XFILLER_18_1246 VPWR VGND VPWR VGND sky130_ef_sc_hd__decap_12
XFILLER_187_965 VPWR VGND VPWR VGND sky130_ef_sc_hd__decap_12
XFILLER_9_110 VGND VGND VPWR VPWR sky130_fd_sc_hd__fill_2
X_368_ _071_ _109_ net155 VGND VGND VPWR VPWR _111_ sky130_fd_sc_hd__o21a_1
XFILLER_201_273 VGND VGND VPWR VPWR sky130_fd_sc_hd__decap_6
XFILLER_186_475 VGND VGND VPWR VPWR sky130_fd_sc_hd__fill_1
XFILLER_174_637 VGND VGND VPWR VPWR sky130_fd_sc_hd__decap_6
XFILLER_161_1590 VPWR VGND VPWR VGND sky130_ef_sc_hd__decap_12
XFILLER_70_1462 VGND VGND VPWR VPWR sky130_fd_sc_hd__decap_6
XFILLER_173_125 VPWR VGND VPWR VGND sky130_ef_sc_hd__decap_12
XFILLER_122_1574 VGND VGND VPWR VPWR sky130_fd_sc_hd__decap_6
X_299_ net40 net141 net131 VGND VGND VPWR VPWR s_wdata\[6\] sky130_fd_sc_hd__a21o_1
XFILLER_173_169 VPWR VGND VPWR VGND sky130_ef_sc_hd__decap_12
XTAP_TAPCELL_ROW_43_2_3257 VGND VPWR sky130_fd_sc_hd__tapvpwrvgnd_1
XFILLER_192_1539 VGND VGND VPWR VPWR sky130_fd_sc_hd__fill_1
XFILLER_182_681 VPWR VGND VPWR VGND sky130_ef_sc_hd__decap_12
XFILLER_177_1063 VGND VGND VPWR VPWR sky130_fd_sc_hd__fill_1
XFILLER_5_393 VGND VGND VPWR VPWR sky130_fd_sc_hd__fill_1
XFILLER_29_1342 VPWR VGND VPWR VGND sky130_ef_sc_hd__decap_12
XFILLER_47_3 VPWR VGND VPWR VGND sky130_ef_sc_hd__decap_12
XFILLER_218_1093 VPWR VGND VPWR VGND sky130_ef_sc_hd__decap_12
XFILLER_190_1241 VPWR VGND VPWR VGND sky130_ef_sc_hd__decap_12
XFILLER_64_1244 VGND VGND VPWR VPWR sky130_fd_sc_hd__fill_1
XFILLER_29_1386 VPWR VGND VPWR VGND sky130_ef_sc_hd__decap_12
XFILLER_190_1285 VPWR VGND VPWR VGND sky130_ef_sc_hd__decap_12
XFILLER_116_1356 VGND VGND VPWR VPWR sky130_fd_sc_hd__fill_1
XFILLER_3_51 VGND VGND VPWR VPWR sky130_fd_sc_hd__decap_4
XFILLER_209_373 VPWR VGND VPWR VGND sky130_ef_sc_hd__decap_12
XFILLER_3_1057 VGND VGND VPWR VPWR sky130_fd_sc_hd__decap_6
XTAP_TAPCELL_ROW_219_3008 VGND VPWR sky130_fd_sc_hd__tapvpwrvgnd_1
XTAP_TAPCELL_ROW_219_3019 VGND VPWR sky130_fd_sc_hd__tapvpwrvgnd_1
XFILLER_197_729 VPWR VGND VPWR VGND sky130_ef_sc_hd__decap_12
XFILLER_36_1302 VPWR VGND VPWR VGND sky130_ef_sc_hd__decap_12
XFILLER_149_111 VGND VGND VPWR VPWR sky130_fd_sc_hd__fill_1
XFILLER_75_1384 VGND VGND VPWR VPWR sky130_fd_sc_hd__fill_1
XANTENNA_fanout141_A _083_ VGND VGND VPWR VPWR sky130_fd_sc_hd__diode_2
XFILLER_127_1496 VGND VGND VPWR VPWR sky130_fd_sc_hd__fill_1
XFILLER_192_401 VPWR VGND VPWR VGND sky130_ef_sc_hd__decap_12
XFILLER_177_497 VGND VGND VPWR VPWR sky130_fd_sc_hd__decap_6
XFILLER_165_615 VGND VGND VPWR VPWR sky130_fd_sc_hd__fill_1
XTAP_TAPCELL_ROW_140_2_3885 VGND VPWR sky130_fd_sc_hd__tapvpwrvgnd_1
XFILLER_22_27 VGND VGND VPWR VPWR sky130_fd_sc_hd__fill_1
XFILLER_192_445 VPWR VGND VPWR VGND sky130_ef_sc_hd__decap_12
XTAP_TAPCELL_ROW_139_2_3879 VGND VPWR sky130_fd_sc_hd__tapvpwrvgnd_1
XFILLER_138_27 VGND VGND VPWR VPWR sky130_fd_sc_hd__fill_1
XFILLER_192_489 VPWR VGND VPWR VGND sky130_ef_sc_hd__decap_12
XPHY_EDGE_ROW_138_1_Left_357 VGND VGND VPWR VPWR sky130_fd_sc_hd__decap_3
XTAP_TAPCELL_ROW_120_2_3761 VGND VPWR sky130_fd_sc_hd__tapvpwrvgnd_1
XFILLER_154_15 VPWR VGND VPWR VGND sky130_ef_sc_hd__decap_12
XFILLER_82_1300 VGND VGND VPWR VPWR sky130_fd_sc_hd__fill_1
XFILLER_47_1442 VPWR VGND VPWR VGND sky130_ef_sc_hd__decap_12
XFILLER_134_1412 VGND VGND VPWR VPWR sky130_fd_sc_hd__fill_1
XTAP_TAPCELL_ROW_87_2_3544 VGND VPWR sky130_fd_sc_hd__tapvpwrvgnd_1
XFILLER_78_109 VPWR VGND VPWR VGND sky130_ef_sc_hd__decap_12
Xfanout122 net126 VGND VGND VPWR VPWR net122 sky130_fd_sc_hd__buf_4
Xfanout133 _087_ VGND VGND VPWR VPWR net133 sky130_fd_sc_hd__buf_2
Xfanout155 net156 VGND VGND VPWR VPWR net155 sky130_fd_sc_hd__clkbuf_2
Xfanout144 _083_ VGND VGND VPWR VPWR net144 sky130_fd_sc_hd__buf_2
XFILLER_43_1328 VGND VGND VPWR VPWR sky130_fd_sc_hd__fill_1
XFILLER_219_137 VGND VGND VPWR VPWR sky130_fd_sc_hd__decap_3
XFILLER_216_811 VGND VGND VPWR VPWR sky130_fd_sc_hd__fill_1
XTAP_TAPCELL_ROW_112_2_3709 VGND VPWR sky130_fd_sc_hd__tapvpwrvgnd_1
XTAP_TAPCELL_ROW_3_864 VGND VPWR sky130_fd_sc_hd__tapvpwrvgnd_1
XFILLER_47_57 VPWR VGND VPWR VGND sky130_ef_sc_hd__decap_12
XTAP_TAPCELL_ROW_3_886 VGND VPWR sky130_fd_sc_hd__tapvpwrvgnd_1
XTAP_TAPCELL_ROW_3_875 VGND VPWR sky130_fd_sc_hd__tapvpwrvgnd_1
XFILLER_203_505 VPWR VGND VPWR VGND sky130_ef_sc_hd__decap_12
XFILLER_167_1287 VGND VGND VPWR VPWR sky130_fd_sc_hd__fill_1
XFILLER_163_1129 VGND VGND VPWR VPWR sky130_fd_sc_hd__fill_2
XFILLER_151_3 VPWR VGND VPWR VGND sky130_ef_sc_hd__decap_12
XFILLER_93_1440 VGND VGND VPWR VPWR sky130_fd_sc_hd__fill_1
XFILLER_19_1522 VPWR VGND VPWR VGND sky130_ef_sc_hd__decap_12
XFILLER_187_217 VGND VGND VPWR VPWR sky130_fd_sc_hd__decap_6
XFILLER_180_1421 VGND VGND VPWR VPWR sky130_fd_sc_hd__decap_6
XFILLER_169_921 VPWR VGND VPWR VGND sky130_ef_sc_hd__decap_12
XFILLER_145_1552 VGND VGND VPWR VPWR sky130_fd_sc_hd__fill_1
XFILLER_58_1582 VPWR VGND VPWR VGND sky130_ef_sc_hd__decap_12
XFILLER_208_1273 VPWR VGND VPWR VGND sky130_ef_sc_hd__decap_12
XFILLER_180_1465 VPWR VGND VPWR VGND sky130_ef_sc_hd__decap_12
XFILLER_169_965 VPWR VGND VPWR VGND sky130_ef_sc_hd__decap_12
XTAP_TAPCELL_ROW_66_1_1150 VGND VPWR sky130_fd_sc_hd__tapvpwrvgnd_1
XFILLER_8_29 VPWR VGND VPWR VGND sky130_ef_sc_hd__decap_12
XFILLER_19_1566 VPWR VGND VPWR VGND sky130_ef_sc_hd__decap_12
XFILLER_54_1468 VGND VGND VPWR VPWR sky130_fd_sc_hd__fill_1
XFILLER_195_261 VPWR VGND VPWR VGND sky130_ef_sc_hd__decap_12
XFILLER_168_475 VGND VGND VPWR VPWR sky130_fd_sc_hd__fill_1
XFILLER_195_55 VGND VGND VPWR VPWR sky130_fd_sc_hd__fill_1
XFILLER_184_979 VGND VGND VPWR VPWR sky130_fd_sc_hd__fill_1
XFILLER_155_125 VGND VGND VPWR VPWR sky130_fd_sc_hd__fill_2
XFILLER_6_135 VGND VGND VPWR VPWR sky130_fd_sc_hd__decap_4
XTAP_TAPCELL_ROW_28_2_3159 VGND VPWR sky130_fd_sc_hd__tapvpwrvgnd_1
XFILLER_171_629 VPWR VGND VPWR VGND sky130_ef_sc_hd__decap_12
XFILLER_104_1282 VPWR VGND VPWR VGND sky130_ef_sc_hd__decap_12
XFILLER_7_669 VGND VGND VPWR VPWR sky130_fd_sc_hd__decap_3
XFILLER_12_71 VPWR VGND VPWR VGND sky130_ef_sc_hd__decap_12
XFILLER_174_1203 VGND VGND VPWR VPWR sky130_fd_sc_hd__fill_1
XFILLER_170_139 VGND VGND VPWR VPWR sky130_fd_sc_hd__fill_1
XFILLER_164_681 VPWR VGND VPWR VGND sky130_ef_sc_hd__decap_12
XTAP_TAPCELL_ROW_154_1_1326 VGND VPWR sky130_fd_sc_hd__tapvpwrvgnd_1
XFILLER_87_1244 VPWR VGND VPWR VGND sky130_ef_sc_hd__decap_12
XFILLER_139_1378 VGND VGND VPWR VPWR sky130_fd_sc_hd__decap_6
XFILLER_88_53 VPWR VGND VPWR VGND sky130_ef_sc_hd__decap_12
XFILLER_191_1561 VGND VGND VPWR VPWR sky130_fd_sc_hd__decap_6
XFILLER_88_97 VPWR VGND VPWR VGND sky130_ef_sc_hd__decap_12
XFILLER_215_1233 VPWR VGND VPWR VGND sky130_ef_sc_hd__decap_12
XFILLER_214_29 VPWR VGND VPWR VGND sky130_ef_sc_hd__decap_12
XFILLER_26_1526 VPWR VGND VPWR VGND sky130_ef_sc_hd__decap_12
XFILLER_211_1119 VGND VGND VPWR VPWR sky130_fd_sc_hd__fill_1
XFILLER_111_1220 VPWR VGND VPWR VGND sky130_ef_sc_hd__decap_12
XANTENNA__569__CLK clknet_3_0_0_clk VGND VGND VPWR VPWR sky130_fd_sc_hd__diode_2
XFILLER_207_833 VGND VGND VPWR VPWR sky130_fd_sc_hd__decap_6
XFILLER_206_321 VPWR VGND VPWR VGND sky130_ef_sc_hd__decap_12
XFILLER_168_1029 VGND VGND VPWR VPWR sky130_fd_sc_hd__decap_6
XTAP_TAPCELL_ROW_158_2_4002 VGND VPWR sky130_fd_sc_hd__tapvpwrvgnd_1
XFILLER_24_1294 VGND VGND VPWR VPWR sky130_fd_sc_hd__decap_6
XFILLER_207_877 VPWR VGND VPWR VGND sky130_ef_sc_hd__decap_12
XFILLER_185_1343 VGND VGND VPWR VPWR sky130_fd_sc_hd__fill_1
XPHY_EDGE_ROW_147_1_Right_733 VGND VGND VPWR VPWR sky130_fd_sc_hd__decap_3
XFILLER_111_1286 VPWR VGND VPWR VGND sky130_ef_sc_hd__decap_12
XFILLER_206_365 VPWR VGND VPWR VGND sky130_ef_sc_hd__decap_12
XFILLER_179_729 VPWR VGND VPWR VGND sky130_ef_sc_hd__decap_12
XFILLER_146_1338 VPWR VGND VPWR VGND sky130_ef_sc_hd__decap_12
XFILLER_72_1524 VGND VGND VPWR VPWR sky130_fd_sc_hd__fill_1
XPHY_EDGE_ROW_1_Left_221 VGND VGND VPWR VPWR sky130_fd_sc_hd__decap_3
XFILLER_174_401 VPWR VGND VPWR VGND sky130_ef_sc_hd__decap_12
XFILLER_190_905 VPWR VGND VPWR VGND sky130_ef_sc_hd__decap_12
XFILLER_174_445 VPWR VGND VPWR VGND sky130_ef_sc_hd__decap_12
XFILLER_70_1270 VPWR VGND VPWR VGND sky130_ef_sc_hd__decap_12
XFILLER_31_1232 VPWR VGND VPWR VGND sky130_ef_sc_hd__decap_12
XFILLER_179_1169 VGND VGND VPWR VPWR sky130_fd_sc_hd__decap_6
XFILLER_174_489 VPWR VGND VPWR VGND sky130_ef_sc_hd__decap_12
XFILLER_122_1382 VPWR VGND VPWR VGND sky130_ef_sc_hd__decap_12
XFILLER_196_1483 VGND VGND VPWR VPWR sky130_fd_sc_hd__fill_1
XFILLER_190_949 VPWR VGND VPWR VGND sky130_ef_sc_hd__decap_12
XFILLER_157_1434 VGND VGND VPWR VPWR sky130_fd_sc_hd__decap_6
XTAP_TAPCELL_ROW_105_2_3663 VGND VPWR sky130_fd_sc_hd__tapvpwrvgnd_1
XFILLER_31_1298 VPWR VGND VPWR VGND sky130_ef_sc_hd__decap_12
XTAP_TAPCELL_ROW_73_2_3452 VGND VPWR sky130_fd_sc_hd__tapvpwrvgnd_1
XFILLER_157_1478 VPWR VGND VPWR VGND sky130_ef_sc_hd__decap_12
XFILLER_124_29 VPWR VGND VPWR VGND sky130_ef_sc_hd__decap_12
XFILLER_9_1244 VPWR VGND VPWR VGND sky130_ef_sc_hd__decap_12
XTAP_TAPCELL_ROW_10_1_1037 VGND VPWR sky130_fd_sc_hd__tapvpwrvgnd_1
XFILLER_190_1093 VPWR VGND VPWR VGND sky130_ef_sc_hd__decap_12
XFILLER_5_1119 VGND VGND VPWR VPWR sky130_fd_sc_hd__fill_1
XFILLER_42_1350 VGND VGND VPWR VPWR sky130_fd_sc_hd__decap_6
XFILLER_209_181 VPWR VGND VPWR VGND sky130_ef_sc_hd__decap_12
XFILLER_186_1129 VPWR VGND VPWR VGND sky130_ef_sc_hd__decap_12
XTAP_TAPCELL_ROW_0_801 VGND VPWR sky130_fd_sc_hd__tapvpwrvgnd_1
XFILLER_17_27 VGND VGND VPWR VPWR sky130_fd_sc_hd__decap_8
XFILLER_42_1394 VPWR VGND VPWR VGND sky130_ef_sc_hd__decap_12
XFILLER_168_1541 VPWR VGND VPWR VGND sky130_ef_sc_hd__decap_12
XFILLER_164_1427 VGND VGND VPWR VPWR sky130_fd_sc_hd__fill_1
XFILLER_169_217 VGND VGND VPWR VPWR sky130_fd_sc_hd__decap_6
XFILLER_90_1602 VGND VGND VPWR VPWR sky130_fd_sc_hd__decap_3
XFILLER_33_15 VPWR VGND VPWR VGND sky130_ef_sc_hd__decap_12
XFILLER_212_357 VGND VGND VPWR VPWR sky130_fd_sc_hd__decap_6
XFILLER_209_1593 VPWR VGND VPWR VGND sky130_ef_sc_hd__decap_12
XFILLER_205_1413 VPWR VGND VPWR VGND sky130_ef_sc_hd__decap_12
XFILLER_197_559 VGND VGND VPWR VPWR sky130_fd_sc_hd__fill_1
XFILLER_149_15 VPWR VGND VPWR VGND sky130_ef_sc_hd__decap_12
XANTENNA_fanout144_X net144 VGND VGND VPWR VPWR sky130_fd_sc_hd__diode_2
XFILLER_205_1457 VPWR VGND VPWR VGND sky130_ef_sc_hd__decap_12
XFILLER_193_721 VGND VGND VPWR VPWR sky130_fd_sc_hd__decap_6
XFILLER_184_209 VPWR VGND VPWR VGND sky130_ef_sc_hd__decap_12
XFILLER_177_261 VPWR VGND VPWR VGND sky130_ef_sc_hd__decap_12
XTAP_TAPCELL_ROW_14_2_3067 VGND VPWR sky130_fd_sc_hd__tapvpwrvgnd_1
XANTENNA__382__A b_addr\[1\] VGND VGND VPWR VPWR sky130_fd_sc_hd__diode_2
XFILLER_197_1225 VGND VGND VPWR VPWR sky130_fd_sc_hd__decap_6
XFILLER_166_979 VGND VGND VPWR VPWR sky130_fd_sc_hd__fill_1
XFILLER_137_125 VGND VGND VPWR VPWR sky130_fd_sc_hd__fill_2
XFILLER_53_1490 VGND VGND VPWR VPWR sky130_fd_sc_hd__decap_6
XFILLER_197_1269 VPWR VGND VPWR VGND sky130_ef_sc_hd__decap_12
XFILLER_193_765 VPWR VGND VPWR VGND sky130_ef_sc_hd__decap_12
XFILLER_192_253 VPWR VGND VPWR VGND sky130_ef_sc_hd__decap_12
XFILLER_140_1482 VPWR VGND VPWR VGND sky130_ef_sc_hd__decap_12
XFILLER_101_1422 VPWR VGND VPWR VGND sky130_ef_sc_hd__decap_12
Xclkbuf_3_5_0_clk clknet_0_clk VGND VGND VPWR VPWR clknet_3_5_0_clk sky130_fd_sc_hd__clkbuf_8
XFILLER_101_1466 VPWR VGND VPWR VGND sky130_ef_sc_hd__decap_12
XFILLER_84_1406 VGND VGND VPWR VPWR sky130_fd_sc_hd__decap_6
XFILLER_4_628 VGND VGND VPWR VPWR sky130_fd_sc_hd__fill_2
XFILLER_3_105 VGND VGND VPWR VPWR sky130_fd_sc_hd__decap_6
XANTENNA__323__A2 net144 VGND VGND VPWR VPWR sky130_fd_sc_hd__diode_2
XFILLER_10_1338 VPWR VGND VPWR VGND sky130_ef_sc_hd__decap_12
XFILLER_165_69 VPWR VGND VPWR VGND sky130_ef_sc_hd__decap_12
XFILLER_3_149 VGND VGND VPWR VPWR sky130_fd_sc_hd__fill_2
XFILLER_175_1567 VGND VGND VPWR VPWR sky130_fd_sc_hd__fill_1
XFILLER_136_1518 VGND VGND VPWR VPWR sky130_fd_sc_hd__decap_6
XFILLER_0_823 VGND VGND VPWR VPWR sky130_fd_sc_hd__decap_3
XFILLER_216_1553 VPWR VGND VPWR VGND sky130_ef_sc_hd__decap_12
XFILLER_134_1220 VPWR VGND VPWR VGND sky130_ef_sc_hd__decap_12
XFILLER_0_845 VGND VGND VPWR VPWR sky130_fd_sc_hd__fill_2
XFILLER_47_1272 VGND VGND VPWR VPWR sky130_fd_sc_hd__fill_1
XFILLER_216_1597 VGND VGND VPWR VPWR sky130_fd_sc_hd__decap_8
XFILLER_199_3 VPWR VGND VPWR VGND sky130_ef_sc_hd__decap_12
XFILLER_181_57 VPWR VGND VPWR VGND sky130_ef_sc_hd__decap_12
XFILLER_60_1450 VPWR VGND VPWR VGND sky130_ef_sc_hd__decap_12
XFILLER_210_1141 VGND VGND VPWR VPWR sky130_fd_sc_hd__decap_6
XFILLER_112_1562 VPWR VGND VPWR VGND sky130_ef_sc_hd__decap_12
XFILLER_21_1434 VGND VGND VPWR VPWR sky130_fd_sc_hd__decap_6
XFILLER_60_1494 VPWR VGND VPWR VGND sky130_ef_sc_hd__decap_12
XFILLER_210_1185 VPWR VGND VPWR VGND sky130_ef_sc_hd__decap_12
XFILLER_74_77 VGND VGND VPWR VPWR sky130_fd_sc_hd__decap_6
XANTENNA__557__A net136 VGND VGND VPWR VPWR sky130_fd_sc_hd__diode_2
XFILLER_21_1478 VPWR VGND VPWR VGND sky130_ef_sc_hd__decap_12
XFILLER_204_825 VPWR VGND VPWR VGND sky130_ef_sc_hd__decap_12
XTAP_TAPCELL_ROW_142_2_3904 VGND VPWR sky130_fd_sc_hd__tapvpwrvgnd_1
XFILLER_95_1546 VGND VGND VPWR VPWR sky130_fd_sc_hd__decap_6
XFILLER_204_869 VPWR VGND VPWR VGND sky130_ef_sc_hd__decap_12
XFILLER_203_335 VGND VGND VPWR VPWR sky130_fd_sc_hd__fill_1
XFILLER_19_1330 VPWR VGND VPWR VGND sky130_ef_sc_hd__decap_12
XFILLER_130_83 VGND VGND VPWR VPWR sky130_fd_sc_hd__fill_1
XFILLER_106_1300 VGND VGND VPWR VPWR sky130_fd_sc_hd__fill_1
XTAP_TAPCELL_ROW_97_1_1211 VGND VPWR sky130_fd_sc_hd__tapvpwrvgnd_1
XFILLER_54_1232 VPWR VGND VPWR VGND sky130_ef_sc_hd__decap_12
XFILLER_196_581 VGND VGND VPWR VPWR sky130_fd_sc_hd__decap_6
XFILLER_180_1273 VPWR VGND VPWR VGND sky130_ef_sc_hd__decap_12
XFILLER_90_65 VPWR VGND VPWR VGND sky130_ef_sc_hd__decap_12
XANTENNA__292__A net140 VGND VGND VPWR VPWR sky130_fd_sc_hd__diode_2
XFILLER_141_1268 VGND VGND VPWR VPWR sky130_fd_sc_hd__decap_4
XFILLER_89_1328 VGND VGND VPWR VPWR sky130_fd_sc_hd__fill_1
XFILLER_71_1590 VPWR VGND VPWR VGND sky130_ef_sc_hd__decap_12
XFILLER_7_433 VPWR VGND VPWR VGND sky130_ef_sc_hd__decap_12
XFILLER_176_1309 VGND VGND VPWR VPWR sky130_fd_sc_hd__decap_6
XFILLER_172_905 VPWR VGND VPWR VGND sky130_ef_sc_hd__decap_12
XFILLER_139_81 VPWR VGND VPWR VGND sky130_ef_sc_hd__decap_12
XFILLER_23_92 VPWR VGND VPWR VGND sky130_ef_sc_hd__decap_12
XFILLER_32_1574 VGND VGND VPWR VPWR sky130_fd_sc_hd__decap_6
XFILLER_172_949 VPWR VGND VPWR VGND sky130_ef_sc_hd__decap_12
XFILLER_7_477 VPWR VGND VPWR VGND sky130_ef_sc_hd__decap_12
XTAP_TAPCELL_ROW_58_2_3354 VGND VPWR sky130_fd_sc_hd__tapvpwrvgnd_1
XFILLER_180_993 VPWR VGND VPWR VGND sky130_ef_sc_hd__decap_12
XFILLER_117_1440 VGND VGND VPWR VPWR sky130_fd_sc_hd__fill_1
XFILLER_215_1063 VGND VGND VPWR VPWR sky130_fd_sc_hd__fill_1
XFILLER_26_1356 VGND VGND VPWR VPWR sky130_fd_sc_hd__fill_1
XTAP_TAPCELL_ROW_51_2_3308 VGND VPWR sky130_fd_sc_hd__tapvpwrvgnd_1
XTAP_TAPCELL_ROW_185_1999 VGND VPWR sky130_fd_sc_hd__tapvpwrvgnd_1
XFILLER_4_1141 VGND VGND VPWR VPWR sky130_fd_sc_hd__decap_6
XFILLER_207_641 VPWR VGND VPWR VGND sky130_ef_sc_hd__decap_12
XFILLER_187_1449 VGND VGND VPWR VPWR sky130_fd_sc_hd__decap_6
XFILLER_4_1185 VPWR VGND VPWR VGND sky130_ef_sc_hd__decap_12
XFILLER_0_1005 VGND VGND VPWR VPWR sky130_fd_sc_hd__decap_3
XFILLER_207_685 VPWR VGND VPWR VGND sky130_ef_sc_hd__decap_12
XPHY_EDGE_ROW_105_2_Left_537 VGND VGND VPWR VPWR sky130_fd_sc_hd__decap_3
XFILLER_0_1049 VPWR VGND VPWR VGND sky130_ef_sc_hd__decap_12
XFILLER_0_85 VPWR VGND VPWR VGND sky130_ef_sc_hd__decap_12
XFILLER_206_195 VGND VGND VPWR VPWR sky130_fd_sc_hd__fill_1
XPHY_EDGE_ROW_148_1_Right_734 VGND VGND VPWR VPWR sky130_fd_sc_hd__decap_3
XFILLER_179_559 VGND VGND VPWR VPWR sky130_fd_sc_hd__fill_1
XFILLER_175_721 VGND VGND VPWR VPWR sky130_fd_sc_hd__decap_6
XFILLER_166_209 VPWR VGND VPWR VGND sky130_ef_sc_hd__decap_12
XFILLER_128_1580 VGND VGND VPWR VPWR sky130_fd_sc_hd__fill_1
XFILLER_37_1496 VGND VGND VPWR VPWR sky130_fd_sc_hd__fill_1
XFILLER_119_125 VGND VGND VPWR VPWR sky130_fd_sc_hd__fill_2
XFILLER_190_713 VPWR VGND VPWR VGND sky130_ef_sc_hd__decap_12
XFILLER_175_765 VPWR VGND VPWR VGND sky130_ef_sc_hd__decap_12
XFILLER_174_253 VPWR VGND VPWR VGND sky130_ef_sc_hd__decap_12
XFILLER_200_1365 VGND VGND VPWR VPWR sky130_fd_sc_hd__decap_6
XFILLER_198_1589 VGND VGND VPWR VPWR sky130_fd_sc_hd__decap_6
XFILLER_194_1409 VPWR VGND VPWR VGND sky130_ef_sc_hd__decap_12
XFILLER_163_949 VGND VGND VPWR VPWR sky130_fd_sc_hd__decap_3
XFILLER_190_757 VPWR VGND VPWR VGND sky130_ef_sc_hd__decap_12
XFILLER_157_1220 VPWR VGND VPWR VGND sky130_ef_sc_hd__decap_12
XFILLER_157_1286 VPWR VGND VPWR VGND sky130_ef_sc_hd__decap_12
XFILLER_135_39 VPWR VGND VPWR VGND sky130_ef_sc_hd__decap_12
XPHY_EDGE_ROW_34_2_Right_91 VGND VGND VPWR VPWR sky130_fd_sc_hd__decap_3
XFILLER_44_1412 VGND VGND VPWR VPWR sky130_fd_sc_hd__fill_1
XFILLER_170_1453 VPWR VGND VPWR VGND sky130_ef_sc_hd__decap_12
XTAP_TAPCELL_ROW_5_926 VGND VPWR sky130_fd_sc_hd__tapvpwrvgnd_1
XTAP_TAPCELL_ROW_5_937 VGND VPWR sky130_fd_sc_hd__tapvpwrvgnd_1
XTAP_TAPCELL_ROW_5_948 VGND VPWR sky130_fd_sc_hd__tapvpwrvgnd_1
XFILLER_218_917 VGND VGND VPWR VPWR sky130_fd_sc_hd__decap_6
XFILLER_217_405 VPWR VGND VPWR VGND sky130_ef_sc_hd__decap_12
XFILLER_28_15 VPWR VGND VPWR VGND sky130_ef_sc_hd__decap_12
XFILLER_28_48 VPWR VGND VPWR VGND sky130_ef_sc_hd__decap_12
XFILLER_170_1497 VPWR VGND VPWR VGND sky130_ef_sc_hd__decap_12
XFILLER_151_27 VPWR VGND VPWR VGND sky130_ef_sc_hd__decap_12
XFILLER_217_449 VPWR VGND VPWR VGND sky130_ef_sc_hd__decap_12
XTAP_TAPCELL_ROW_127_2_3806 VGND VPWR sky130_fd_sc_hd__tapvpwrvgnd_1
XPHY_EDGE_ROW_37_2_Left_469 VGND VGND VPWR VPWR sky130_fd_sc_hd__decap_3
XFILLER_198_813 VPWR VGND VPWR VGND sky130_ef_sc_hd__decap_12
XFILLER_168_1371 VGND VGND VPWR VPWR sky130_fd_sc_hd__fill_1
XFILLER_129_1322 VGND VGND VPWR VPWR sky130_fd_sc_hd__decap_6
XFILLER_77_1232 VPWR VGND VPWR VGND sky130_ef_sc_hd__decap_12
XFILLER_212_121 VPWR VGND VPWR VGND sky130_ef_sc_hd__decap_12
XFILLER_212_165 VPWR VGND VPWR VGND sky130_ef_sc_hd__decap_12
XFILLER_129_1366 VPWR VGND VPWR VGND sky130_ef_sc_hd__decap_12
XFILLER_77_1298 VPWR VGND VPWR VGND sky130_ef_sc_hd__decap_12
XFILLER_55_1552 VGND VGND VPWR VPWR sky130_fd_sc_hd__fill_1
XFILLER_201_839 VGND VGND VPWR VPWR sky130_fd_sc_hd__fill_1
XTAP_TAPCELL_ROW_195_2295 VGND VPWR sky130_fd_sc_hd__tapvpwrvgnd_1
XTAP_TAPCELL_ROW_195_2284 VGND VPWR sky130_fd_sc_hd__tapvpwrvgnd_1
XFILLER_185_529 VPWR VGND VPWR VGND sky130_ef_sc_hd__decap_12
XFILLER_100_53 VPWR VGND VPWR VGND sky130_ef_sc_hd__decap_12
XTAP_TAPCELL_ROW_64_2_3397 VGND VPWR sky130_fd_sc_hd__tapvpwrvgnd_1
XFILLER_205_1287 VGND VGND VPWR VPWR sky130_fd_sc_hd__fill_1
XFILLER_181_1593 VPWR VGND VPWR VGND sky130_ef_sc_hd__decap_12
XFILLER_178_581 VGND VGND VPWR VPWR sky130_fd_sc_hd__decap_6
XPHY_EDGE_ROW_99_2_Left_531 VGND VGND VPWR VPWR sky130_fd_sc_hd__decap_3
XFILLER_100_97 VPWR VGND VPWR VGND sky130_ef_sc_hd__decap_12
XFILLER_197_1033 VPWR VGND VPWR VGND sky130_ef_sc_hd__decap_12
XFILLER_193_573 VPWR VGND VPWR VGND sky130_ef_sc_hd__decap_12
XPHY_EDGE_ROW_151_2_Left_583 VGND VGND VPWR VPWR sky130_fd_sc_hd__decap_3
XTAP_TAPCELL_ROW_216_2899 VGND VPWR sky130_fd_sc_hd__tapvpwrvgnd_1
XTAP_TAPCELL_ROW_216_2888 VGND VPWR sky130_fd_sc_hd__tapvpwrvgnd_1
XFILLER_197_1077 VPWR VGND VPWR VGND sky130_ef_sc_hd__decap_12
XFILLER_114_3 VPWR VGND VPWR VGND sky130_ef_sc_hd__decap_12
XPHY_EDGE_ROW_110_1_Right_696 VGND VGND VPWR VPWR sky130_fd_sc_hd__decap_3
XFILLER_88_1350 VGND VGND VPWR VPWR sky130_fd_sc_hd__decap_6
XFILLER_14_1282 VPWR VGND VPWR VGND sky130_ef_sc_hd__decap_12
XTAP_TAPCELL_ROW_44_2_3262 VGND VPWR sky130_fd_sc_hd__tapvpwrvgnd_1
XFILLER_180_245 VGND VGND VPWR VPWR sky130_fd_sc_hd__decap_6
XFILLER_109_51 VGND VGND VPWR VPWR sky130_fd_sc_hd__decap_4
XFILLER_101_1274 VPWR VGND VPWR VGND sky130_ef_sc_hd__decap_12
XFILLER_180_289 VPWR VGND VPWR VGND sky130_ef_sc_hd__decap_12
XFILLER_140_109 VPWR VGND VPWR VGND sky130_ef_sc_hd__decap_12
XFILLER_88_1394 VPWR VGND VPWR VGND sky130_ef_sc_hd__decap_12
XFILLER_84_1258 VPWR VGND VPWR VGND sky130_ef_sc_hd__decap_12
XFILLER_69_55 VGND VGND VPWR VPWR sky130_fd_sc_hd__fill_1
XFILLER_136_1326 VPWR VGND VPWR VGND sky130_ef_sc_hd__decap_12
XFILLER_49_1378 VGND VGND VPWR VPWR sky130_fd_sc_hd__decap_6
XFILLER_212_1203 VGND VGND VPWR VPWR sky130_fd_sc_hd__fill_1
XFILLER_114_1602 VGND VGND VPWR VPWR sky130_fd_sc_hd__decap_3
XANTENNA_input34_A func_wdata[2] VGND VGND VPWR VPWR sky130_fd_sc_hd__diode_2
XFILLER_169_1113 VGND VGND VPWR VPWR sky130_fd_sc_hd__decap_6
XFILLER_21_1220 VPWR VGND VPWR VGND sky130_ef_sc_hd__decap_12
XPHY_EDGE_ROW_207_Left_426 VGND VGND VPWR VPWR sky130_fd_sc_hd__decap_3
XFILLER_169_1157 VPWR VGND VPWR VGND sky130_ef_sc_hd__decap_12
XFILLER_112_1370 VPWR VGND VPWR VGND sky130_ef_sc_hd__decap_12
XFILLER_95_1310 VPWR VGND VPWR VGND sky130_ef_sc_hd__decap_12
XFILLER_1_1325 VPWR VGND VPWR VGND sky130_ef_sc_hd__decap_12
XTAP_TAPCELL_ROW_180_1874 VGND VPWR sky130_fd_sc_hd__tapvpwrvgnd_1
XTAP_TAPCELL_ROW_180_1863 VGND VPWR sky130_fd_sc_hd__tapvpwrvgnd_1
XFILLER_99_1490 VGND VGND VPWR VPWR sky130_fd_sc_hd__decap_6
XFILLER_21_1286 VPWR VGND VPWR VGND sky130_ef_sc_hd__decap_12
XFILLER_188_301 VGND VGND VPWR VPWR sky130_fd_sc_hd__decap_6
XFILLER_147_1422 VPWR VGND VPWR VGND sky130_ef_sc_hd__decap_12
XFILLER_141_93 VPWR VGND VPWR VGND sky130_ef_sc_hd__decap_12
XFILLER_108_1406 VGND VGND VPWR VPWR sky130_fd_sc_hd__decap_6
XFILLER_95_1354 VPWR VGND VPWR VGND sky130_ef_sc_hd__decap_12
XFILLER_1_1369 VPWR VGND VPWR VGND sky130_ef_sc_hd__decap_12
XFILLER_56_1338 VPWR VGND VPWR VGND sky130_ef_sc_hd__decap_12
XFILLER_206_1029 VGND VGND VPWR VPWR sky130_fd_sc_hd__decap_6
XFILLER_188_345 VPWR VGND VPWR VGND sky130_ef_sc_hd__decap_12
XFILLER_147_1466 VPWR VGND VPWR VGND sky130_ef_sc_hd__decap_12
XFILLER_95_1398 VPWR VGND VPWR VGND sky130_ef_sc_hd__decap_12
XANTENNA__607__CLK clknet_3_6_0_clk VGND VGND VPWR VPWR sky130_fd_sc_hd__diode_2
XFILLER_204_699 VGND VGND VPWR VPWR sky130_fd_sc_hd__fill_1
XFILLER_188_389 VPWR VGND VPWR VGND sky130_ef_sc_hd__decap_12
XFILLER_200_861 VGND VGND VPWR VPWR sky130_fd_sc_hd__decap_6
XANTENNA__535__A2 _180_ VGND VGND VPWR VPWR sky130_fd_sc_hd__diode_2
XTAP_TAPCELL_ROW_34_1_1085 VGND VPWR sky130_fd_sc_hd__tapvpwrvgnd_1
XPHY_EDGE_ROW_216_Left_435 VGND VGND VPWR VPWR sky130_fd_sc_hd__decap_3
XFILLER_176_1117 VPWR VGND VPWR VGND sky130_ef_sc_hd__decap_12
XTAP_TAPCELL_ROW_174_1689 VGND VPWR sky130_fd_sc_hd__tapvpwrvgnd_1
XFILLER_172_713 VPWR VGND VPWR VGND sky130_ef_sc_hd__decap_12
XFILLER_32_1382 VPWR VGND VPWR VGND sky130_ef_sc_hd__decap_12
XFILLER_172_757 VPWR VGND VPWR VGND sky130_ef_sc_hd__decap_12
XFILLER_171_223 VGND VGND VPWR VPWR sky130_fd_sc_hd__fill_1
XFILLER_67_1434 VGND VGND VPWR VPWR sky130_fd_sc_hd__decap_6
XFILLER_158_1562 VPWR VGND VPWR VGND sky130_ef_sc_hd__decap_12
XFILLER_4_981 VPWR VGND VPWR VGND sky130_ef_sc_hd__decap_12
XFILLER_154_1426 VPWR VGND VPWR VGND sky130_ef_sc_hd__decap_12
XFILLER_119_1546 VGND VGND VPWR VPWR sky130_fd_sc_hd__decap_6
XFILLER_67_1478 VPWR VGND VPWR VGND sky130_ef_sc_hd__decap_12
XFILLER_3_491 VGND VGND VPWR VPWR sky130_fd_sc_hd__fill_1
XFILLER_217_1169 VGND VGND VPWR VPWR sky130_fd_sc_hd__decap_6
XFILLER_6_1203 VGND VGND VPWR VPWR sky130_fd_sc_hd__fill_1
XFILLER_187_1213 VPWR VGND VPWR VGND sky130_ef_sc_hd__decap_12
XTAP_TAPCELL_ROW_113_2_3714 VGND VPWR sky130_fd_sc_hd__tapvpwrvgnd_1
XFILLER_215_909 VPWR VGND VPWR VGND sky130_ef_sc_hd__decap_12
XFILLER_208_961 VPWR VGND VPWR VGND sky130_ef_sc_hd__decap_12
XFILLER_130_1470 VPWR VGND VPWR VGND sky130_ef_sc_hd__decap_12
XFILLER_214_419 VGND VGND VPWR VPWR sky130_fd_sc_hd__fill_1
XFILLER_198_109 VPWR VGND VPWR VGND sky130_ef_sc_hd__decap_12
XFILLER_187_1257 VPWR VGND VPWR VGND sky130_ef_sc_hd__decap_12
XFILLER_165_1511 VGND VGND VPWR VPWR sky130_fd_sc_hd__fill_1
XPHY_EDGE_ROW_147_1_Left_366 VGND VGND VPWR VPWR sky130_fd_sc_hd__decap_3
XTAP_TAPCELL_ROW_81_2_3503 VGND VPWR sky130_fd_sc_hd__tapvpwrvgnd_1
XFILLER_78_1574 VGND VGND VPWR VPWR sky130_fd_sc_hd__decap_6
XPHY_EDGE_ROW_149_1_Right_735 VGND VGND VPWR VPWR sky130_fd_sc_hd__decap_3
XFILLER_126_1506 VPWR VGND VPWR VGND sky130_ef_sc_hd__decap_12
XFILLER_74_1438 VPWR VGND VPWR VGND sky130_ef_sc_hd__decap_12
XTAP_TAPCELL_ROW_49_2_3299 VGND VPWR sky130_fd_sc_hd__tapvpwrvgnd_1
XFILLER_210_625 VPWR VGND VPWR VGND sky130_ef_sc_hd__decap_12
XFILLER_206_1541 VPWR VGND VPWR VGND sky130_ef_sc_hd__decap_12
XFILLER_167_529 VPWR VGND VPWR VGND sky130_ef_sc_hd__decap_12
XPHY_EDGE_ROW_84_1_Left_303 VGND VGND VPWR VPWR sky130_fd_sc_hd__decap_3
XFILLER_210_669 VPWR VGND VPWR VGND sky130_ef_sc_hd__decap_12
XANTENNA__363__C b_addr\[5\] VGND VGND VPWR VPWR sky130_fd_sc_hd__diode_2
XFILLER_202_1427 VGND VGND VPWR VPWR sky130_fd_sc_hd__fill_1
XTAP_TAPCELL_ROW_29_2_3164 VGND VPWR sky130_fd_sc_hd__tapvpwrvgnd_1
XTAP_TAPCELL_ROW_30_2_3170 VGND VPWR sky130_fd_sc_hd__tapvpwrvgnd_1
XFILLER_198_1353 VPWR VGND VPWR VGND sky130_ef_sc_hd__decap_12
XFILLER_175_573 VPWR VGND VPWR VGND sky130_ef_sc_hd__decap_12
XFILLER_163_713 VPWR VGND VPWR VGND sky130_ef_sc_hd__decap_12
XFILLER_102_1550 VPWR VGND VPWR VGND sky130_ef_sc_hd__decap_12
XFILLER_11_1422 VPWR VGND VPWR VGND sky130_ef_sc_hd__decap_12
XFILLER_30_27 VGND VGND VPWR VPWR sky130_fd_sc_hd__fill_1
XFILLER_50_1482 VPWR VGND VPWR VGND sky130_ef_sc_hd__decap_12
XFILLER_200_1173 VPWR VGND VPWR VGND sky130_ef_sc_hd__decap_12
XFILLER_198_1397 VPWR VGND VPWR VGND sky130_ef_sc_hd__decap_12
XFILLER_194_1217 VPWR VGND VPWR VGND sky130_ef_sc_hd__decap_12
XFILLER_163_757 VPWR VGND VPWR VGND sky130_ef_sc_hd__decap_12
XFILLER_146_27 VGND VGND VPWR VPWR sky130_fd_sc_hd__fill_1
XFILLER_11_1466 VPWR VGND VPWR VGND sky130_ef_sc_hd__decap_12
XTAP_TAPCELL_ROW_211_2763 VGND VPWR sky130_fd_sc_hd__tapvpwrvgnd_1
XTAP_TAPCELL_ROW_211_2752 VGND VPWR sky130_fd_sc_hd__tapvpwrvgnd_1
XTAP_TAPCELL_ROW_211_2741 VGND VPWR sky130_fd_sc_hd__tapvpwrvgnd_1
XFILLER_190_587 VGND VGND VPWR VPWR sky130_fd_sc_hd__fill_1
XFILLER_137_1602 VGND VGND VPWR VPWR sky130_fd_sc_hd__decap_3
XFILLER_122_109 VPWR VGND VPWR VGND sky130_ef_sc_hd__decap_12
XFILLER_102_1594 VGND VGND VPWR VPWR sky130_fd_sc_hd__decap_8
XFILLER_85_1534 VPWR VGND VPWR VGND sky130_ef_sc_hd__decap_12
XFILLER_85_1578 VPWR VGND VPWR VGND sky130_ef_sc_hd__decap_12
XFILLER_1_428 VGND VGND VPWR VPWR sky130_fd_sc_hd__fill_2
XFILLER_46_1518 VGND VGND VPWR VPWR sky130_fd_sc_hd__decap_6
XTAP_TAPCELL_ROW_59_1_1136 VGND VPWR sky130_fd_sc_hd__tapvpwrvgnd_1
XFILLER_162_15 VPWR VGND VPWR VGND sky130_ef_sc_hd__decap_12
XTAP_TAPCELL_ROW_22_2_3118 VGND VPWR sky130_fd_sc_hd__tapvpwrvgnd_1
XFILLER_44_1220 VPWR VGND VPWR VGND sky130_ef_sc_hd__decap_12
XFILLER_170_1261 VPWR VGND VPWR VGND sky130_ef_sc_hd__decap_12
XFILLER_39_69 VPWR VGND VPWR VGND sky130_ef_sc_hd__decap_12
XFILLER_218_725 VPWR VGND VPWR VGND sky130_ef_sc_hd__decap_12
XFILLER_213_1567 VGND VGND VPWR VPWR sky130_fd_sc_hd__fill_1
XFILLER_131_1256 VPWR VGND VPWR VGND sky130_ef_sc_hd__decap_12
XFILLER_218_769 VPWR VGND VPWR VGND sky130_ef_sc_hd__decap_12
XTAP_TAPCELL_ROW_209_2692 VGND VPWR sky130_fd_sc_hd__tapvpwrvgnd_1
XPHY_EDGE_ROW_79_1_Left_298 VGND VGND VPWR VPWR sky130_fd_sc_hd__decap_3
XFILLER_22_1562 VPWR VGND VPWR VGND sky130_ef_sc_hd__decap_12
XFILLER_217_279 VGND VGND VPWR VPWR sky130_fd_sc_hd__fill_1
XTAP_TAPCELL_ROW_205_2589 VGND VPWR sky130_fd_sc_hd__tapvpwrvgnd_1
XTAP_TAPCELL_ROW_205_2578 VGND VPWR sky130_fd_sc_hd__tapvpwrvgnd_1
XFILLER_55_57 VPWR VGND VPWR VGND sky130_ef_sc_hd__decap_12
XTAP_TAPCELL_ROW_197_2346 VGND VPWR sky130_fd_sc_hd__tapvpwrvgnd_1
X_470_ _171_ _177_ _197_ _199_ VGND VGND VPWR VPWR _202_ sky130_fd_sc_hd__or4_1
XFILLER_213_441 VGND VGND VPWR VPWR sky130_fd_sc_hd__decap_6
XFILLER_198_643 VGND VGND VPWR VPWR sky130_fd_sc_hd__fill_1
XTAP_TAPCELL_ROW_197_2368 VGND VPWR sky130_fd_sc_hd__tapvpwrvgnd_1
XTAP_TAPCELL_ROW_197_2357 VGND VPWR sky130_fd_sc_hd__tapvpwrvgnd_1
XFILLER_186_805 VGND VGND VPWR VPWR sky130_fd_sc_hd__decap_6
XFILLER_92_1538 VPWR VGND VPWR VGND sky130_ef_sc_hd__decap_12
XFILLER_213_485 VPWR VGND VPWR VGND sky130_ef_sc_hd__decap_12
XFILLER_16_1300 VGND VGND VPWR VPWR sky130_fd_sc_hd__fill_1
XTAP_TAPCELL_ROW_218_2939 VGND VPWR sky130_fd_sc_hd__tapvpwrvgnd_1
XFILLER_186_849 VPWR VGND VPWR VGND sky130_ef_sc_hd__decap_12
XFILLER_185_337 VPWR VGND VPWR VGND sky130_ef_sc_hd__decap_12
XTAP_TAPCELL_ROW_94_2_3592 VGND VPWR sky130_fd_sc_hd__tapvpwrvgnd_1
XFILLER_51_1268 VGND VGND VPWR VPWR sky130_fd_sc_hd__decap_4
XFILLER_194_893 VPWR VGND VPWR VGND sky130_ef_sc_hd__decap_12
XFILLER_177_1437 VPWR VGND VPWR VGND sky130_ef_sc_hd__decap_12
XPHY_EDGE_ROW_111_1_Right_697 VGND VGND VPWR VPWR sky130_fd_sc_hd__decap_3
XFILLER_214_1309 VGND VGND VPWR VPWR sky130_fd_sc_hd__decap_6
XFILLER_96_53 VPWR VGND VPWR VGND sky130_ef_sc_hd__decap_12
XFILLER_27_1440 VGND VGND VPWR VPWR sky130_fd_sc_hd__fill_1
XTAP_TAPCELL_ROW_182_1936 VGND VPWR sky130_fd_sc_hd__tapvpwrvgnd_1
XTAP_TAPCELL_ROW_182_1925 VGND VPWR sky130_fd_sc_hd__tapvpwrvgnd_1
XTAP_TAPCELL_ROW_182_1914 VGND VPWR sky130_fd_sc_hd__tapvpwrvgnd_1
XFILLER_96_97 VPWR VGND VPWR VGND sky130_ef_sc_hd__decap_12
XANTENNA__288__Y _083_ VGND VGND VPWR VPWR sky130_fd_sc_hd__diode_2
XFILLER_188_1533 VGND VGND VPWR VPWR sky130_fd_sc_hd__decap_6
XTAP_TAPCELL_ROW_167_1493 VGND VPWR sky130_fd_sc_hd__tapvpwrvgnd_1
XTAP_TAPCELL_ROW_163_1346 VGND VPWR sky130_fd_sc_hd__tapvpwrvgnd_1
XTAP_TAPCELL_ROW_66_2_3405 VGND VPWR sky130_fd_sc_hd__tapvpwrvgnd_1
XFILLER_29_91 VGND VGND VPWR VPWR sky130_fd_sc_hd__decap_4
XFILLER_188_1577 VPWR VGND VPWR VGND sky130_ef_sc_hd__decap_12
XTAP_TAPCELL_ROW_163_1379 VGND VPWR sky130_fd_sc_hd__tapvpwrvgnd_1
XTAP_TAPCELL_ROW_163_1368 VGND VPWR sky130_fd_sc_hd__tapvpwrvgnd_1
XTAP_TAPCELL_ROW_163_1357 VGND VPWR sky130_fd_sc_hd__tapvpwrvgnd_1
XFILLER_1_1133 VPWR VGND VPWR VGND sky130_ef_sc_hd__decap_12
XFILLER_205_953 VPWR VGND VPWR VGND sky130_ef_sc_hd__decap_12
XFILLER_1_1177 VPWR VGND VPWR VGND sky130_ef_sc_hd__decap_12
X_599_ clknet_3_5_0_clk _033_ VGND VGND VPWR VPWR net86 sky130_fd_sc_hd__dfxtp_1
XFILLER_189_665 VGND VGND VPWR VPWR sky130_fd_sc_hd__decap_6
XFILLER_188_153 VPWR VGND VPWR VGND sky130_ef_sc_hd__decap_12
XFILLER_147_1274 VPWR VGND VPWR VGND sky130_ef_sc_hd__decap_12
XFILLER_188_197 VPWR VGND VPWR VGND sky130_ef_sc_hd__decap_12
XFILLER_108_1258 VPWR VGND VPWR VGND sky130_ef_sc_hd__decap_12
XFILLER_38_1580 VGND VGND VPWR VPWR sky130_fd_sc_hd__fill_1
XFILLER_77_3 VPWR VGND VPWR VGND sky130_ef_sc_hd__decap_12
XFILLER_191_329 VGND VGND VPWR VPWR sky130_fd_sc_hd__decap_6
XFILLER_195_1537 VPWR VGND VPWR VGND sky130_ef_sc_hd__decap_12
XANTENNA__480__A u_ctrl.cmp_valid VGND VGND VPWR VPWR sky130_fd_sc_hd__diode_2
XFILLER_201_1493 VPWR VGND VPWR VGND sky130_ef_sc_hd__decap_12
XFILLER_172_587 VGND VGND VPWR VPWR sky130_fd_sc_hd__fill_1
XFILLER_119_1310 VPWR VGND VPWR VGND sky130_ef_sc_hd__decap_12
XFILLER_104_109 VPWR VGND VPWR VGND sky130_ef_sc_hd__decap_12
XFILLER_67_1220 VPWR VGND VPWR VGND sky130_ef_sc_hd__decap_12
XFILLER_158_1370 VPWR VGND VPWR VGND sky130_ef_sc_hd__decap_12
XFILLER_119_1354 VPWR VGND VPWR VGND sky130_ef_sc_hd__decap_12
XFILLER_67_1286 VPWR VGND VPWR VGND sky130_ef_sc_hd__decap_12
XFILLER_119_1398 VPWR VGND VPWR VGND sky130_ef_sc_hd__decap_12
XFILLER_171_1581 VPWR VGND VPWR VGND sky130_ef_sc_hd__decap_12
XFILLER_187_1021 VPWR VGND VPWR VGND sky130_ef_sc_hd__decap_12
XFILLER_132_29 VPWR VGND VPWR VGND sky130_ef_sc_hd__decap_12
XFILLER_199_429 VPWR VGND VPWR VGND sky130_ef_sc_hd__decap_12
XFILLER_187_1065 VPWR VGND VPWR VGND sky130_ef_sc_hd__decap_12
XFILLER_39_1322 VGND VGND VPWR VPWR sky130_fd_sc_hd__decap_6
XTAP_TAPCELL_ROW_200_2453 VGND VPWR sky130_fd_sc_hd__tapvpwrvgnd_1
XTAP_TAPCELL_ROW_200_2442 VGND VPWR sky130_fd_sc_hd__tapvpwrvgnd_1
XTAP_TAPCELL_ROW_200_2431 VGND VPWR sky130_fd_sc_hd__tapvpwrvgnd_1
XFILLER_78_1382 VPWR VGND VPWR VGND sky130_ef_sc_hd__decap_12
XFILLER_211_945 VGND VGND VPWR VPWR sky130_fd_sc_hd__decap_6
XFILLER_168_805 VGND VGND VPWR VPWR sky130_fd_sc_hd__decap_6
XFILLER_126_1314 VPWR VGND VPWR VGND sky130_ef_sc_hd__decap_12
XFILLER_74_1246 VPWR VGND VPWR VGND sky130_ef_sc_hd__decap_12
XFILLER_39_1366 VPWR VGND VPWR VGND sky130_ef_sc_hd__decap_12
XFILLER_210_433 VPWR VGND VPWR VGND sky130_ef_sc_hd__decap_12
XTAP_TAPCELL_ROW_192_2221 VGND VPWR sky130_fd_sc_hd__tapvpwrvgnd_1
XTAP_TAPCELL_ROW_192_2210 VGND VPWR sky130_fd_sc_hd__tapvpwrvgnd_1
XFILLER_168_849 VPWR VGND VPWR VGND sky130_ef_sc_hd__decap_12
XFILLER_167_337 VPWR VGND VPWR VGND sky130_ef_sc_hd__decap_12
XFILLER_126_1358 VPWR VGND VPWR VGND sky130_ef_sc_hd__decap_12
XTAP_TAPCELL_ROW_112_1_1241 VGND VPWR sky130_fd_sc_hd__tapvpwrvgnd_1
XFILLER_211_989 VPWR VGND VPWR VGND sky130_ef_sc_hd__decap_12
XFILLER_210_477 VPWR VGND VPWR VGND sky130_ef_sc_hd__decap_12
XFILLER_206_1371 VGND VGND VPWR VPWR sky130_fd_sc_hd__fill_1
XFILLER_182_307 VGND VGND VPWR VPWR sky130_fd_sc_hd__fill_1
XFILLER_157_15 VPWR VGND VPWR VGND sky130_ef_sc_hd__decap_12
XTAP_TAPCELL_ROW_79_2_3494 VGND VPWR sky130_fd_sc_hd__tapvpwrvgnd_1
XFILLER_41_15 VPWR VGND VPWR VGND sky130_ef_sc_hd__decap_12
XTAP_TAPCELL_ROW_213_2814 VGND VPWR sky130_fd_sc_hd__tapvpwrvgnd_1
XTAP_TAPCELL_ROW_213_2803 VGND VPWR sky130_fd_sc_hd__tapvpwrvgnd_1
XFILLER_194_189 VGND VGND VPWR VPWR sky130_fd_sc_hd__decap_6
XFILLER_176_893 VPWR VGND VPWR VGND sky130_ef_sc_hd__decap_12
XFILLER_198_1161 VPWR VGND VPWR VGND sky130_ef_sc_hd__decap_12
XFILLER_191_841 VPWR VGND VPWR VGND sky130_ef_sc_hd__decap_12
XANTENNA__380__B1 net156 VGND VGND VPWR VPWR sky130_fd_sc_hd__diode_2
XANTENNA__390__A b_addr\[2\] VGND VGND VPWR VPWR sky130_fd_sc_hd__diode_2
XFILLER_11_1274 VPWR VGND VPWR VGND sky130_ef_sc_hd__decap_12
XFILLER_137_1410 VPWR VGND VPWR VGND sky130_ef_sc_hd__decap_12
XFILLER_85_1342 VPWR VGND VPWR VGND sky130_ef_sc_hd__decap_12
XTAP_TAPCELL_ROW_186_2047 VGND VPWR sky130_fd_sc_hd__tapvpwrvgnd_1
XTAP_TAPCELL_ROW_186_2036 VGND VPWR sky130_fd_sc_hd__tapvpwrvgnd_1
XFILLER_173_69 VPWR VGND VPWR VGND sky130_ef_sc_hd__decap_12
XFILLER_137_1454 VPWR VGND VPWR VGND sky130_ef_sc_hd__decap_12
XFILLER_85_1386 VPWR VGND VPWR VGND sky130_ef_sc_hd__decap_12
XTAP_TAPCELL_ROW_72_2_3448 VGND VPWR sky130_fd_sc_hd__tapvpwrvgnd_1
XFILLER_46_1326 VPWR VGND VPWR VGND sky130_ef_sc_hd__decap_12
XFILLER_137_1498 VPWR VGND VPWR VGND sky130_ef_sc_hd__decap_12
XFILLER_106_41 VPWR VGND VPWR VGND sky130_ef_sc_hd__decap_12
XFILLER_24_1602 VGND VGND VPWR VPWR sky130_fd_sc_hd__decap_3
XTAP_TAPCELL_ROW_207_2629 VGND VPWR sky130_fd_sc_hd__tapvpwrvgnd_1
XFILLER_106_85 VPWR VGND VPWR VGND sky130_ef_sc_hd__decap_12
XTAP_TAPCELL_ROW_52_2_3313 VGND VPWR sky130_fd_sc_hd__tapvpwrvgnd_1
XFILLER_218_533 VPWR VGND VPWR VGND sky130_ef_sc_hd__decap_12
XFILLER_181_3 VPWR VGND VPWR VGND sky130_ef_sc_hd__decap_12
XFILLER_170_1091 VGND VGND VPWR VPWR sky130_fd_sc_hd__fill_1
XFILLER_205_205 VPWR VGND VPWR VGND sky130_ef_sc_hd__decap_12
XTAP_TAPCELL_ROW_199_2419 VGND VPWR sky130_fd_sc_hd__tapvpwrvgnd_1
XTAP_TAPCELL_ROW_199_2408 VGND VPWR sky130_fd_sc_hd__tapvpwrvgnd_1
XFILLER_166_1105 VPWR VGND VPWR VGND sky130_ef_sc_hd__decap_12
XFILLER_17_126 VGND VGND VPWR VPWR sky130_fd_sc_hd__fill_1
XFILLER_22_1370 VPWR VGND VPWR VGND sky130_ef_sc_hd__decap_12
XFILLER_2_1453 VPWR VGND VPWR VGND sky130_ef_sc_hd__decap_12
X_522_ net67 net123 VGND VGND VPWR VPWR _235_ sky130_fd_sc_hd__or2_1
XFILLER_207_1113 VGND VGND VPWR VPWR sky130_fd_sc_hd__decap_6
XFILLER_205_249 VPWR VGND VPWR VGND sky130_ef_sc_hd__decap_12
XFILLER_166_1149 VPWR VGND VPWR VGND sky130_ef_sc_hd__decap_12
XFILLER_148_1550 VPWR VGND VPWR VGND sky130_ef_sc_hd__decap_12
XFILLER_96_1482 VPWR VGND VPWR VGND sky130_ef_sc_hd__decap_12
XFILLER_92_1302 VPWR VGND VPWR VGND sky130_ef_sc_hd__decap_12
X_453_ net146 net90 VGND VGND VPWR VPWR _185_ sky130_fd_sc_hd__xor2_1
XFILLER_2_1497 VPWR VGND VPWR VGND sky130_ef_sc_hd__decap_12
XFILLER_57_1422 VPWR VGND VPWR VGND sky130_ef_sc_hd__decap_12
XFILLER_202_923 VGND VGND VPWR VPWR sky130_fd_sc_hd__fill_1
XFILLER_186_613 VPWR VGND VPWR VGND sky130_ef_sc_hd__decap_12
XFILLER_148_1594 VGND VGND VPWR VPWR sky130_fd_sc_hd__decap_8
XFILLER_144_1414 VPWR VGND VPWR VGND sky130_ef_sc_hd__decap_12
XFILLER_109_1534 VPWR VGND VPWR VGND sky130_ef_sc_hd__decap_12
XFILLER_82_77 VGND VGND VPWR VPWR sky130_fd_sc_hd__decap_6
XFILLER_18_1406 VGND VGND VPWR VPWR sky130_fd_sc_hd__decap_6
XFILLER_57_1466 VPWR VGND VPWR VGND sky130_ef_sc_hd__decap_12
XFILLER_213_293 VPWR VGND VPWR VGND sky130_ef_sc_hd__decap_12
XFILLER_207_1157 VPWR VGND VPWR VGND sky130_ef_sc_hd__decap_12
XFILLER_198_77 VGND VGND VPWR VPWR sky130_fd_sc_hd__decap_6
XFILLER_109_1578 VPWR VGND VPWR VGND sky130_ef_sc_hd__decap_12
X_384_ _120_ _122_ VGND VGND VPWR VPWR _123_ sky130_fd_sc_hd__nand2_1
XFILLER_186_657 VPWR VGND VPWR VGND sky130_ef_sc_hd__decap_12
XTAP_TAPCELL_ROW_175_1740 VGND VPWR sky130_fd_sc_hd__tapvpwrvgnd_1
XFILLER_185_167 VGND VGND VPWR VPWR sky130_fd_sc_hd__fill_1
XFILLER_177_1201 VPWR VGND VPWR VGND sky130_ef_sc_hd__decap_12
XFILLER_173_329 VGND VGND VPWR VPWR sky130_fd_sc_hd__decap_6
XTAP_TAPCELL_ROW_171_1615 VGND VPWR sky130_fd_sc_hd__tapvpwrvgnd_1
XTAP_TAPCELL_ROW_171_1604 VGND VPWR sky130_fd_sc_hd__tapvpwrvgnd_1
XTAP_TAPCELL_ROW_171_1626 VGND VPWR sky130_fd_sc_hd__tapvpwrvgnd_1
XFILLER_177_1245 VPWR VGND VPWR VGND sky130_ef_sc_hd__decap_12
XFILLER_181_373 VPWR VGND VPWR VGND sky130_ef_sc_hd__decap_12
XFILLER_177_1289 VPWR VGND VPWR VGND sky130_ef_sc_hd__decap_12
XFILLER_155_1510 VPWR VGND VPWR VGND sky130_ef_sc_hd__decap_12
XFILLER_147_81 VPWR VGND VPWR VGND sky130_ef_sc_hd__decap_12
XPHY_EDGE_ROW_114_2_Left_546 VGND VGND VPWR VPWR sky130_fd_sc_hd__decap_3
XPHY_EDGE_ROW_112_1_Right_698 VGND VGND VPWR VPWR sky130_fd_sc_hd__decap_3
XFILLER_68_1562 VPWR VGND VPWR VGND sky130_ef_sc_hd__decap_12
XFILLER_218_1253 VGND VGND VPWR VPWR sky130_fd_sc_hd__decap_6
XFILLER_155_1554 VPWR VGND VPWR VGND sky130_ef_sc_hd__decap_12
XFILLER_64_1426 VPWR VGND VPWR VGND sky130_ef_sc_hd__decap_12
Xoutput70 net70 VGND VGND VPWR VPWR bist_fail_bits[21] sky130_fd_sc_hd__buf_2
XFILLER_29_1546 VGND VGND VPWR VPWR sky130_fd_sc_hd__decap_6
XFILLER_218_1297 VPWR VGND VPWR VGND sky130_ef_sc_hd__decap_12
XFILLER_214_1117 VPWR VGND VPWR VGND sky130_ef_sc_hd__decap_12
XTAP_TAPCELL_ROW_169_1566 VGND VPWR sky130_fd_sc_hd__tapvpwrvgnd_1
XTAP_TAPCELL_ROW_169_1555 VGND VPWR sky130_fd_sc_hd__tapvpwrvgnd_1
XTAP_TAPCELL_ROW_169_1544 VGND VPWR sky130_fd_sc_hd__tapvpwrvgnd_1
XFILLER_116_1538 VPWR VGND VPWR VGND sky130_ef_sc_hd__decap_12
Xoutput81 net81 VGND VGND VPWR VPWR bist_fail_bits[31] sky130_fd_sc_hd__buf_2
Xoutput92 net92 VGND VGND VPWR VPWR func_rdata[12] sky130_fd_sc_hd__buf_2
XFILLER_7_1397 VGND VGND VPWR VPWR sky130_fd_sc_hd__decap_3
XFILLER_188_1341 VPWR VGND VPWR VGND sky130_ef_sc_hd__decap_12
XTAP_TAPCELL_ROW_128_2_3811 VGND VPWR sky130_fd_sc_hd__tapvpwrvgnd_1
XFILLER_188_1385 VPWR VGND VPWR VGND sky130_ef_sc_hd__decap_12
XFILLER_184_1205 VPWR VGND VPWR VGND sky130_ef_sc_hd__decap_12
XFILLER_97_1268 VGND VGND VPWR VPWR sky130_fd_sc_hd__decap_4
XFILLER_40_1470 VPWR VGND VPWR VGND sky130_ef_sc_hd__decap_12
XTAP_TAPCELL_ROW_96_2_3600 VGND VPWR sky130_fd_sc_hd__tapvpwrvgnd_1
XFILLER_75_1522 VPWR VGND VPWR VGND sky130_ef_sc_hd__decap_12
XFILLER_205_783 VGND VGND VPWR VPWR sky130_fd_sc_hd__fill_1
XFILLER_189_473 VPWR VGND VPWR VGND sky130_ef_sc_hd__decap_12
XFILLER_75_1566 VPWR VGND VPWR VGND sky130_ef_sc_hd__decap_12
XFILLER_36_1506 VPWR VGND VPWR VGND sky130_ef_sc_hd__decap_12
XFILLER_203_1511 VGND VGND VPWR VPWR sky130_fd_sc_hd__fill_1
XFILLER_176_189 VGND VGND VPWR VPWR sky130_fd_sc_hd__decap_6
XPHY_EDGE_ROW_167_Left_386 VGND VGND VPWR VPWR sky130_fd_sc_hd__decap_3
XFILLER_164_307 VGND VGND VPWR VPWR sky130_fd_sc_hd__fill_1
XFILLER_160_1282 VPWR VGND VPWR VGND sky130_ef_sc_hd__decap_12
XPHY_EDGE_ROW_74_1_Right_660 VGND VGND VPWR VPWR sky130_fd_sc_hd__decap_3
XFILLER_199_1481 VPWR VGND VPWR VGND sky130_ef_sc_hd__decap_12
XFILLER_195_1301 VPWR VGND VPWR VGND sky130_ef_sc_hd__decap_12
XFILLER_191_137 VPWR VGND VPWR VGND sky130_ef_sc_hd__decap_12
XFILLER_173_841 VPWR VGND VPWR VGND sky130_ef_sc_hd__decap_12
XFILLER_121_1244 VPWR VGND VPWR VGND sky130_ef_sc_hd__decap_12
XFILLER_12_1550 VPWR VGND VPWR VGND sky130_ef_sc_hd__decap_12
XFILLER_195_1345 VPWR VGND VPWR VGND sky130_ef_sc_hd__decap_12
XPHY_EDGE_ROW_46_2_Left_478 VGND VGND VPWR VPWR sky130_fd_sc_hd__decap_3
XFILLER_12_1594 VGND VGND VPWR VPWR sky130_fd_sc_hd__decap_8
XFILLER_47_1602 VGND VGND VPWR VPWR sky130_fd_sc_hd__decap_3
XFILLER_207_51 VGND VGND VPWR VPWR sky130_fd_sc_hd__decap_4
XFILLER_82_1526 VPWR VGND VPWR VGND sky130_ef_sc_hd__decap_12
XPHY_EDGE_ROW_176_Left_395 VGND VGND VPWR VPWR sky130_fd_sc_hd__decap_3
XFILLER_143_39 VPWR VGND VPWR VGND sky130_ef_sc_hd__decap_12
XFILLER_80_1294 VGND VGND VPWR VPWR sky130_fd_sc_hd__decap_6
XPHY_EDGE_ROW_9_1_Right_595 VGND VGND VPWR VPWR sky130_fd_sc_hd__decap_3
XFILLER_215_503 VGND VGND VPWR VPWR sky130_fd_sc_hd__fill_1
XTAP_TAPCELL_ROW_202_2504 VGND VPWR sky130_fd_sc_hd__tapvpwrvgnd_1
XFILLER_36_15 VPWR VGND VPWR VGND sky130_ef_sc_hd__decap_12
XFILLER_41_1256 VPWR VGND VPWR VGND sky130_ef_sc_hd__decap_12
XFILLER_167_1425 VPWR VGND VPWR VGND sky130_ef_sc_hd__decap_12
XPHY_EDGE_ROW_160_2_Left_592 VGND VGND VPWR VPWR sky130_fd_sc_hd__decap_3
XFILLER_203_709 VPWR VGND VPWR VGND sky130_ef_sc_hd__decap_12
XFILLER_199_237 VPWR VGND VPWR VGND sky130_ef_sc_hd__decap_12
XFILLER_167_1469 VPWR VGND VPWR VGND sky130_ef_sc_hd__decap_12
XANTENNA__385__A b_addr\[0\] VGND VGND VPWR VPWR sky130_fd_sc_hd__diode_2
XANTENNA_clkbuf_3_7_0_clk_A clknet_0_clk VGND VGND VPWR VPWR sky130_fd_sc_hd__diode_2
XFILLER_211_753 VPWR VGND VPWR VGND sky130_ef_sc_hd__decap_12
XFILLER_208_1477 VGND VGND VPWR VPWR sky130_fd_sc_hd__decap_6
XFILLER_168_613 VPWR VGND VPWR VGND sky130_ef_sc_hd__decap_12
XFILLER_168_657 VPWR VGND VPWR VGND sky130_ef_sc_hd__decap_12
XFILLER_211_797 VPWR VGND VPWR VGND sky130_ef_sc_hd__decap_12
XFILLER_167_167 VGND VGND VPWR VPWR sky130_fd_sc_hd__fill_1
XFILLER_178_1521 VPWR VGND VPWR VGND sky130_ef_sc_hd__decap_12
XFILLER_191_671 VGND VGND VPWR VPWR sky130_fd_sc_hd__fill_1
XTAP_TAPCELL_ROW_188_2109 VGND VPWR sky130_fd_sc_hd__tapvpwrvgnd_1
XFILLER_178_1565 VPWR VGND VPWR VGND sky130_ef_sc_hd__decap_12
XTAP_TAPCELL_ROW_154_2_3978 VGND VPWR sky130_fd_sc_hd__tapvpwrvgnd_1
XFILLER_174_1429 VPWR VGND VPWR VGND sky130_ef_sc_hd__decap_12
XFILLER_117_51 VGND VGND VPWR VPWR sky130_fd_sc_hd__decap_4
XFILLER_7_3 VPWR VGND VPWR VGND sky130_ef_sc_hd__decap_12
XFILLER_215_1437 VPWR VGND VPWR VGND sky130_ef_sc_hd__decap_12
XFILLER_77_55 VGND VGND VPWR VPWR sky130_fd_sc_hd__fill_1
XFILLER_172_1197 VGND VGND VPWR VPWR sky130_fd_sc_hd__decap_6
XFILLER_219_853 VPWR VGND VPWR VGND sky130_ef_sc_hd__decap_12
XFILLER_150_1462 VGND VGND VPWR VPWR sky130_fd_sc_hd__decap_6
XANTENNA__279__B b_addr\[6\] VGND VGND VPWR VPWR sky130_fd_sc_hd__diode_2
XFILLER_218_363 VGND VGND VPWR VPWR sky130_fd_sc_hd__fill_1
XFILLER_219_897 VPWR VGND VPWR VGND sky130_ef_sc_hd__decap_12
XFILLER_206_525 VGND VGND VPWR VPWR sky130_fd_sc_hd__decap_6
XFILLER_185_1525 VPWR VGND VPWR VGND sky130_ef_sc_hd__decap_12
XFILLER_206_569 VPWR VGND VPWR VGND sky130_ef_sc_hd__decap_12
XFILLER_185_1569 VPWR VGND VPWR VGND sky130_ef_sc_hd__decap_12
X_505_ net150 _185_ net129 net138 _226_ VGND VGND VPWR VPWR _036_ sky130_fd_sc_hd__o311a_1
XFILLER_2_1261 VPWR VGND VPWR VGND sky130_ef_sc_hd__decap_12
XFILLER_26_81 VGND VGND VPWR VPWR sky130_fd_sc_hd__decap_3
XFILLER_187_933 VPWR VGND VPWR VGND sky130_ef_sc_hd__decap_12
XFILLER_186_421 VPWR VGND VPWR VGND sky130_ef_sc_hd__decap_12
XFILLER_144_1244 VGND VGND VPWR VPWR sky130_fd_sc_hd__fill_1
XFILLER_109_1342 VPWR VGND VPWR VGND sky130_ef_sc_hd__decap_12
X_436_ _167_ _168_ net157 VGND VGND VPWR VPWR _025_ sky130_fd_sc_hd__a21boi_1
XFILLER_57_1274 VPWR VGND VPWR VGND sky130_ef_sc_hd__decap_12
XFILLER_187_977 VPWR VGND VPWR VGND sky130_ef_sc_hd__decap_12
XFILLER_109_1386 VPWR VGND VPWR VGND sky130_ef_sc_hd__decap_12
X_367_ net47 u_ctrl.state\[0\] _109_ VGND VGND VPWR VPWR _110_ sky130_fd_sc_hd__nor3_1
XFILLER_18_1258 VPWR VGND VPWR VGND sky130_ef_sc_hd__decap_12
XFILLER_173_137 VPWR VGND VPWR VGND sky130_ef_sc_hd__decap_12
X_298_ net39 net141 net131 VGND VGND VPWR VPWR s_wdata\[5\] sky130_fd_sc_hd__a21o_1
XFILLER_170_811 VGND VGND VPWR VPWR sky130_fd_sc_hd__fill_1
XTAP_TAPCELL_ROW_43_2_3258 VGND VPWR sky130_fd_sc_hd__tapvpwrvgnd_1
XFILLER_182_693 VGND VGND VPWR VPWR sky130_fd_sc_hd__decap_6
XFILLER_181_181 VPWR VGND VPWR VGND sky130_ef_sc_hd__decap_12
XFILLER_5_361 VGND VGND VPWR VPWR sky130_fd_sc_hd__decap_8
XPHY_EDGE_ROW_156_1_Left_375 VGND VGND VPWR VPWR sky130_fd_sc_hd__decap_3
XPHY_EDGE_ROW_113_1_Right_699 VGND VGND VPWR VPWR sky130_fd_sc_hd__decap_3
XFILLER_68_1370 VPWR VGND VPWR VGND sky130_ef_sc_hd__decap_12
XFILLER_29_1310 VPWR VGND VPWR VGND sky130_ef_sc_hd__decap_12
XFILLER_218_1061 VPWR VGND VPWR VGND sky130_ef_sc_hd__decap_12
XFILLER_190_1253 VGND VGND VPWR VPWR sky130_fd_sc_hd__decap_6
XFILLER_116_1302 VPWR VGND VPWR VGND sky130_ef_sc_hd__decap_12
XFILLER_29_1354 VPWR VGND VPWR VGND sky130_ef_sc_hd__decap_12
XFILLER_155_1384 VGND VGND VPWR VPWR sky130_fd_sc_hd__fill_1
XPHY_EDGE_ROW_93_1_Left_312 VGND VGND VPWR VPWR sky130_fd_sc_hd__decap_3
XFILLER_29_1398 VPWR VGND VPWR VGND sky130_ef_sc_hd__decap_12
XFILLER_190_1297 VPWR VGND VPWR VGND sky130_ef_sc_hd__decap_12
XFILLER_7_1161 VPWR VGND VPWR VGND sky130_ef_sc_hd__decap_12
XFILLER_209_385 VGND VGND VPWR VPWR sky130_fd_sc_hd__decap_6
XTAP_TAPCELL_ROW_219_3009 VGND VPWR sky130_fd_sc_hd__tapvpwrvgnd_1
XFILLER_184_1035 VGND VGND VPWR VPWR sky130_fd_sc_hd__fill_1
XFILLER_162_1300 VGND VGND VPWR VPWR sky130_fd_sc_hd__fill_1
XFILLER_75_1330 VPWR VGND VPWR VGND sky130_ef_sc_hd__decap_12
XFILLER_189_281 VPWR VGND VPWR VGND sky130_ef_sc_hd__decap_12
XFILLER_127_1442 VPWR VGND VPWR VGND sky130_ef_sc_hd__decap_12
XFILLER_36_1314 VPWR VGND VPWR VGND sky130_ef_sc_hd__decap_12
XFILLER_123_1328 VGND VGND VPWR VPWR sky130_fd_sc_hd__fill_1
XFILLER_36_1358 VPWR VGND VPWR VGND sky130_ef_sc_hd__decap_12
XFILLER_192_413 VGND VGND VPWR VPWR sky130_fd_sc_hd__decap_6
XANTENNA_fanout134_A _087_ VGND VGND VPWR VPWR sky130_fd_sc_hd__diode_2
XFILLER_192_457 VPWR VGND VPWR VGND sky130_ef_sc_hd__decap_12
XTAP_TAPCELL_ROW_140_2_3886 VGND VPWR sky130_fd_sc_hd__tapvpwrvgnd_1
XPHY_EDGE_ROW_75_1_Right_661 VGND VGND VPWR VPWR sky130_fd_sc_hd__decap_3
XFILLER_195_1175 VGND VGND VPWR VPWR sky130_fd_sc_hd__fill_1
XFILLER_173_671 VGND VGND VPWR VPWR sky130_fd_sc_hd__fill_1
XFILLER_218_83 VGND VGND VPWR VPWR sky130_fd_sc_hd__fill_1
XFILLER_154_27 VGND VGND VPWR VPWR sky130_fd_sc_hd__fill_1
XFILLER_86_1470 VPWR VGND VPWR VGND sky130_ef_sc_hd__decap_12
XFILLER_47_1410 VPWR VGND VPWR VGND sky130_ef_sc_hd__decap_12
XPHY_EDGE_ROW_184_Left_403 VGND VGND VPWR VPWR sky130_fd_sc_hd__decap_3
XFILLER_138_1582 VPWR VGND VPWR VGND sky130_ef_sc_hd__decap_12
XTAP_TAPCELL_ROW_87_2_3545 VGND VPWR sky130_fd_sc_hd__tapvpwrvgnd_1
XFILLER_47_1454 VPWR VGND VPWR VGND sky130_ef_sc_hd__decap_12
XFILLER_86_121 VGND VGND VPWR VPWR sky130_fd_sc_hd__decap_6
XFILLER_82_1356 VGND VGND VPWR VPWR sky130_fd_sc_hd__fill_1
Xfanout145 net146 VGND VGND VPWR VPWR net145 sky130_fd_sc_hd__clkbuf_8
Xfanout123 net124 VGND VGND VPWR VPWR net123 sky130_fd_sc_hd__clkbuf_2
Xfanout134 _087_ VGND VGND VPWR VPWR net134 sky130_fd_sc_hd__dlymetal6s2s_1
Xfanout156 net157 VGND VGND VPWR VPWR net156 sky130_fd_sc_hd__buf_2
XFILLER_47_1498 VPWR VGND VPWR VGND sky130_ef_sc_hd__decap_12
XFILLER_170_15 VPWR VGND VPWR VGND sky130_ef_sc_hd__decap_12
XFILLER_134_1468 VGND VGND VPWR VPWR sky130_fd_sc_hd__fill_1
XFILLER_47_69 VPWR VGND VPWR VGND sky130_ef_sc_hd__decap_12
XTAP_TAPCELL_ROW_3_887 VGND VPWR sky130_fd_sc_hd__tapvpwrvgnd_1
XTAP_TAPCELL_ROW_3_876 VGND VPWR sky130_fd_sc_hd__tapvpwrvgnd_1
XTAP_TAPCELL_ROW_3_865 VGND VPWR sky130_fd_sc_hd__tapvpwrvgnd_1
XFILLER_216_867 VGND VGND VPWR VPWR sky130_fd_sc_hd__fill_1
XFILLER_167_1233 VPWR VGND VPWR VGND sky130_ef_sc_hd__decap_12
XFILLER_3_1581 VPWR VGND VPWR VGND sky130_ef_sc_hd__decap_12
XFILLER_203_517 VPWR VGND VPWR VGND sky130_ef_sc_hd__decap_12
XFILLER_63_57 VPWR VGND VPWR VGND sky130_ef_sc_hd__decap_12
XFILLER_58_1550 VPWR VGND VPWR VGND sky130_ef_sc_hd__decap_12
XFILLER_208_1241 VPWR VGND VPWR VGND sky130_ef_sc_hd__decap_12
XPHY_EDGE_ROW_193_Left_412 VGND VGND VPWR VPWR sky130_fd_sc_hd__decap_3
XFILLER_179_57 VPWR VGND VPWR VGND sky130_ef_sc_hd__decap_12
XFILLER_169_933 VPWR VGND VPWR VGND sky130_ef_sc_hd__decap_12
XFILLER_168_421 VPWR VGND VPWR VGND sky130_ef_sc_hd__decap_12
XFILLER_19_1534 VPWR VGND VPWR VGND sky130_ef_sc_hd__decap_12
XFILLER_54_1414 VPWR VGND VPWR VGND sky130_ef_sc_hd__decap_12
XFILLER_58_1594 VGND VGND VPWR VPWR sky130_fd_sc_hd__decap_8
XFILLER_211_561 VPWR VGND VPWR VGND sky130_ef_sc_hd__decap_12
XFILLER_208_1285 VPWR VGND VPWR VGND sky130_ef_sc_hd__decap_12
XFILLER_204_1105 VPWR VGND VPWR VGND sky130_ef_sc_hd__decap_12
XFILLER_169_977 VPWR VGND VPWR VGND sky130_ef_sc_hd__decap_12
XFILLER_144_3 VPWR VGND VPWR VGND sky130_ef_sc_hd__decap_12
XFILLER_106_1526 VPWR VGND VPWR VGND sky130_ef_sc_hd__decap_12
XFILLER_93_1496 VGND VGND VPWR VPWR sky130_fd_sc_hd__fill_1
XFILLER_19_1578 VPWR VGND VPWR VGND sky130_ef_sc_hd__decap_12
XFILLER_204_1149 VPWR VGND VPWR VGND sky130_ef_sc_hd__decap_12
XFILLER_195_273 VGND VGND VPWR VPWR sky130_fd_sc_hd__decap_6
XFILLER_184_925 VPWR VGND VPWR VGND sky130_ef_sc_hd__decap_12
XFILLER_180_1477 VGND VGND VPWR VPWR sky130_fd_sc_hd__decap_6
XANTENNA__326__A0 b_addr\[1\] VGND VGND VPWR VPWR sky130_fd_sc_hd__diode_2
XFILLER_104_1294 VGND VGND VPWR VPWR sky130_fd_sc_hd__decap_6
XFILLER_178_1373 VPWR VGND VPWR VGND sky130_ef_sc_hd__decap_12
XFILLER_164_693 VGND VGND VPWR VPWR sky130_fd_sc_hd__decap_6
XFILLER_87_1256 VPWR VGND VPWR VGND sky130_ef_sc_hd__decap_12
XFILLER_12_83 VGND VGND VPWR VPWR sky130_fd_sc_hd__fill_1
XFILLER_163_181 VPWR VGND VPWR VGND sky130_ef_sc_hd__decap_12
XFILLER_128_83 VGND VGND VPWR VPWR sky130_fd_sc_hd__fill_1
XFILLER_65_1510 VPWR VGND VPWR VGND sky130_ef_sc_hd__decap_12
XFILLER_215_1201 VPWR VGND VPWR VGND sky130_ef_sc_hd__decap_12
XFILLER_174_1259 VGND VGND VPWR VPWR sky130_fd_sc_hd__fill_1
XFILLER_88_65 VPWR VGND VPWR VGND sky130_ef_sc_hd__decap_12
XFILLER_65_1554 VPWR VGND VPWR VGND sky130_ef_sc_hd__decap_12
XFILLER_215_1245 VPWR VGND VPWR VGND sky130_ef_sc_hd__decap_12
XFILLER_152_1524 VGND VGND VPWR VPWR sky130_fd_sc_hd__fill_1
XFILLER_26_1538 VPWR VGND VPWR VGND sky130_ef_sc_hd__decap_12
XFILLER_215_1289 VPWR VGND VPWR VGND sky130_ef_sc_hd__decap_12
XFILLER_8_1470 VPWR VGND VPWR VGND sky130_ef_sc_hd__decap_12
XFILLER_150_1270 VPWR VGND VPWR VGND sky130_ef_sc_hd__decap_12
XTAP_TAPCELL_ROW_158_2_4003 VGND VPWR sky130_fd_sc_hd__tapvpwrvgnd_1
XFILLER_111_1232 VPWR VGND VPWR VGND sky130_ef_sc_hd__decap_12
XFILLER_206_333 VPWR VGND VPWR VGND sky130_ef_sc_hd__decap_12
XFILLER_207_889 VGND VGND VPWR VPWR sky130_fd_sc_hd__decap_6
XFILLER_206_377 VPWR VGND VPWR VGND sky130_ef_sc_hd__decap_12
XFILLER_111_1298 VPWR VGND VPWR VGND sky130_ef_sc_hd__decap_12
XFILLER_2_1091 VGND VGND VPWR VPWR sky130_fd_sc_hd__fill_1
XFILLER_185_1399 VGND VGND VPWR VPWR sky130_fd_sc_hd__fill_1
XFILLER_187_741 VPWR VGND VPWR VGND sky130_ef_sc_hd__decap_12
X_419_ _153_ _117_ _102_ b_addr\[5\] VGND VGND VPWR VPWR _154_ sky130_fd_sc_hd__a2bb2o_1
XFILLER_187_785 VPWR VGND VPWR VGND sky130_ef_sc_hd__decap_12
XFILLER_186_251 VGND VGND VPWR VPWR sky130_fd_sc_hd__fill_1
XFILLER_174_413 VGND VGND VPWR VPWR sky130_fd_sc_hd__decap_6
XTAP_TAPCELL_ROW_125_2_3788 VGND VPWR sky130_fd_sc_hd__tapvpwrvgnd_1
XTAP_TAPCELL_ROW_17_1_1051 VGND VPWR sky130_fd_sc_hd__tapvpwrvgnd_1
XFILLER_122_1350 VGND VGND VPWR VPWR sky130_fd_sc_hd__decap_6
XFILLER_70_1282 VPWR VGND VPWR VGND sky130_ef_sc_hd__decap_12
XFILLER_190_917 VGND VGND VPWR VPWR sky130_fd_sc_hd__decap_6
XFILLER_174_457 VPWR VGND VPWR VGND sky130_ef_sc_hd__decap_12
XFILLER_31_1244 VPWR VGND VPWR VGND sky130_ef_sc_hd__decap_12
XFILLER_122_1394 VPWR VGND VPWR VGND sky130_ef_sc_hd__decap_12
XFILLER_6_681 VPWR VGND VPWR VGND sky130_ef_sc_hd__decap_12
XFILLER_192_1315 VGND VGND VPWR VPWR sky130_fd_sc_hd__fill_1
XTAP_TAPCELL_ROW_73_2_3453 VGND VPWR sky130_fd_sc_hd__tapvpwrvgnd_1
XTAP_TAPCELL_ROW_105_1_1227 VGND VPWR sky130_fd_sc_hd__tapvpwrvgnd_1
XFILLER_190_1061 VPWR VGND VPWR VGND sky130_ef_sc_hd__decap_12
XFILLER_68_121 VGND VGND VPWR VPWR sky130_fd_sc_hd__decap_6
XFILLER_9_1256 VPWR VGND VPWR VGND sky130_ef_sc_hd__decap_12
XTAP_TAPCELL_ROW_10_1_1038 VGND VPWR sky130_fd_sc_hd__tapvpwrvgnd_1
XFILLER_217_609 VGND VGND VPWR VPWR sky130_fd_sc_hd__decap_6
XFILLER_204_41 VPWR VGND VPWR VGND sky130_ef_sc_hd__decap_12
XFILLER_83_113 VPWR VGND VPWR VGND sky130_ef_sc_hd__decap_12
XFILLER_204_85 VPWR VGND VPWR VGND sky130_ef_sc_hd__decap_12
XFILLER_133_1490 VGND VGND VPWR VPWR sky130_fd_sc_hd__decap_6
XTAP_TAPCELL_ROW_72_1_1161 VGND VPWR sky130_fd_sc_hd__tapvpwrvgnd_1
XTAP_TAPCELL_ROW_0_802 VGND VPWR sky130_fd_sc_hd__tapvpwrvgnd_1
XFILLER_209_193 VPWR VGND VPWR VGND sky130_ef_sc_hd__decap_12
XFILLER_168_1553 VPWR VGND VPWR VGND sky130_ef_sc_hd__decap_12
XFILLER_140_29 VPWR VGND VPWR VGND sky130_ef_sc_hd__decap_12
XFILLER_197_505 VPWR VGND VPWR VGND sky130_ef_sc_hd__decap_12
XFILLER_168_1597 VGND VGND VPWR VPWR sky130_fd_sc_hd__decap_8
XFILLER_209_1561 VGND VGND VPWR VPWR sky130_fd_sc_hd__decap_6
XFILLER_205_1425 VPWR VGND VPWR VGND sky130_ef_sc_hd__decap_12
XTAP_TAPCELL_ROW_160_1_1337 VGND VPWR sky130_fd_sc_hd__tapvpwrvgnd_1
XFILLER_33_27 VPWR VGND VPWR VGND sky130_ef_sc_hd__decap_12
XFILLER_205_1469 VPWR VGND VPWR VGND sky130_ef_sc_hd__decap_12
XFILLER_166_925 VPWR VGND VPWR VGND sky130_ef_sc_hd__decap_12
XFILLER_149_27 VPWR VGND VPWR VGND sky130_ef_sc_hd__decap_12
XFILLER_127_1272 VGND VGND VPWR VPWR sky130_fd_sc_hd__fill_1
XTAP_TAPCELL_ROW_14_2_3068 VGND VPWR sky130_fd_sc_hd__tapvpwrvgnd_1
XFILLER_192_221 VPWR VGND VPWR VGND sky130_ef_sc_hd__decap_12
XFILLER_177_273 VGND VGND VPWR VPWR sky130_fd_sc_hd__decap_6
XFILLER_193_777 VGND VGND VPWR VPWR sky130_fd_sc_hd__decap_6
XFILLER_192_265 VPWR VGND VPWR VGND sky130_ef_sc_hd__decap_12
XFILLER_140_1450 VPWR VGND VPWR VGND sky130_ef_sc_hd__decap_12
XFILLER_175_1513 VPWR VGND VPWR VGND sky130_ef_sc_hd__decap_12
XFILLER_165_15 VPWR VGND VPWR VGND sky130_ef_sc_hd__decap_12
XFILLER_140_1494 VPWR VGND VPWR VGND sky130_ef_sc_hd__decap_12
XFILLER_101_1434 VGND VGND VPWR VPWR sky130_fd_sc_hd__decap_6
XPHY_EDGE_ROW_76_1_Right_662 VGND VGND VPWR VPWR sky130_fd_sc_hd__decap_3
XFILLER_101_1478 VPWR VGND VPWR VGND sky130_ef_sc_hd__decap_12
XFILLER_216_1521 VPWR VGND VPWR VGND sky130_ef_sc_hd__decap_12
XFILLER_0_802 VGND VGND VPWR VPWR sky130_fd_sc_hd__decap_3
XFILLER_216_1565 VPWR VGND VPWR VGND sky130_ef_sc_hd__decap_12
XFILLER_173_1281 VGND VGND VPWR VPWR sky130_fd_sc_hd__decap_6
XFILLER_134_1232 VPWR VGND VPWR VGND sky130_ef_sc_hd__decap_12
XFILLER_212_1429 VPWR VGND VPWR VGND sky130_ef_sc_hd__decap_12
XFILLER_0_879 VGND VGND VPWR VPWR sky130_fd_sc_hd__decap_3
XFILLER_181_69 VPWR VGND VPWR VGND sky130_ef_sc_hd__decap_12
XFILLER_114_41 VPWR VGND VPWR VGND sky130_ef_sc_hd__decap_12
XFILLER_151_1590 VPWR VGND VPWR VGND sky130_ef_sc_hd__decap_12
XFILLER_114_85 VPWR VGND VPWR VGND sky130_ef_sc_hd__decap_12
XFILLER_60_1462 VGND VGND VPWR VPWR sky130_fd_sc_hd__decap_6
XFILLER_112_1574 VGND VGND VPWR VPWR sky130_fd_sc_hd__decap_6
XFILLER_210_1197 VGND VGND VPWR VPWR sky130_fd_sc_hd__decap_6
XFILLER_204_837 VPWR VGND VPWR VGND sky130_ef_sc_hd__decap_12
XFILLER_167_1063 VGND VGND VPWR VPWR sky130_fd_sc_hd__fill_1
XFILLER_182_1539 VGND VGND VPWR VPWR sky130_fd_sc_hd__fill_1
XFILLER_180_1241 VPWR VGND VPWR VGND sky130_ef_sc_hd__decap_12
XFILLER_169_741 VPWR VGND VPWR VGND sky130_ef_sc_hd__decap_12
XPHY_EDGE_ROW_123_2_Left_555 VGND VGND VPWR VPWR sky130_fd_sc_hd__decap_3
XTAP_TAPCELL_ROW_97_1_1212 VGND VPWR sky130_fd_sc_hd__tapvpwrvgnd_1
XANTENNA__547__B1 net138 VGND VGND VPWR VPWR sky130_fd_sc_hd__diode_2
XFILLER_19_1342 VPWR VGND VPWR VGND sky130_ef_sc_hd__decap_12
XFILLER_54_1244 VGND VGND VPWR VPWR sky130_fd_sc_hd__fill_1
XFILLER_212_881 VPWR VGND VPWR VGND sky130_ef_sc_hd__decap_12
XFILLER_208_1093 VPWR VGND VPWR VGND sky130_ef_sc_hd__decap_12
XFILLER_169_785 VPWR VGND VPWR VGND sky130_ef_sc_hd__decap_12
XFILLER_168_251 VGND VGND VPWR VPWR sky130_fd_sc_hd__fill_1
XFILLER_90_77 VGND VGND VPWR VPWR sky130_fd_sc_hd__decap_6
XFILLER_19_1386 VPWR VGND VPWR VGND sky130_ef_sc_hd__decap_12
XFILLER_211_391 VGND VGND VPWR VPWR sky130_fd_sc_hd__fill_1
XFILLER_184_755 VGND VGND VPWR VPWR sky130_fd_sc_hd__fill_1
XFILLER_180_1285 VPWR VGND VPWR VGND sky130_ef_sc_hd__decap_12
XFILLER_106_1356 VGND VGND VPWR VPWR sky130_fd_sc_hd__fill_1
XFILLER_23_71 VGND VGND VPWR VPWR sky130_fd_sc_hd__decap_8
XFILLER_172_917 VGND VGND VPWR VPWR sky130_fd_sc_hd__decap_6
XFILLER_171_405 VPWR VGND VPWR VGND sky130_ef_sc_hd__decap_12
XFILLER_7_445 VGND VGND VPWR VPWR sky130_fd_sc_hd__decap_3
XFILLER_139_93 VPWR VGND VPWR VGND sky130_ef_sc_hd__decap_12
XFILLER_7_489 VPWR VGND VPWR VGND sky130_ef_sc_hd__decap_12
XFILLER_180_961 VPWR VGND VPWR VGND sky130_ef_sc_hd__decap_12
XFILLER_171_449 VPWR VGND VPWR VGND sky130_ef_sc_hd__decap_12
XTAP_TAPCELL_ROW_58_2_3355 VGND VPWR sky130_fd_sc_hd__tapvpwrvgnd_1
XFILLER_3_673 VPWR VGND VPWR VGND sky130_ef_sc_hd__decap_12
XFILLER_155_81 VPWR VGND VPWR VGND sky130_ef_sc_hd__decap_12
XFILLER_3_695 VGND VGND VPWR VPWR sky130_fd_sc_hd__decap_6
XFILLER_26_1302 VPWR VGND VPWR VGND sky130_ef_sc_hd__decap_12
XPHY_EDGE_ROW_219_Right_64 VGND VGND VPWR VPWR sky130_fd_sc_hd__decap_3
XFILLER_191_1381 VPWR VGND VPWR VGND sky130_ef_sc_hd__decap_12
XPHY_EDGE_ROW_150_2_Right_207 VGND VGND VPWR VPWR sky130_fd_sc_hd__decap_3
XFILLER_65_1384 VGND VGND VPWR VPWR sky130_fd_sc_hd__fill_1
XFILLER_6_1429 VPWR VGND VPWR VGND sky130_ef_sc_hd__decap_12
XFILLER_117_1496 VGND VGND VPWR VPWR sky130_fd_sc_hd__fill_1
XFILLER_65_113 VPWR VGND VPWR VGND sky130_ef_sc_hd__decap_12
XTAP_TAPCELL_ROW_7_990 VGND VPWR sky130_fd_sc_hd__tapvpwrvgnd_1
XTAP_TAPCELL_ROW_51_2_3309 VGND VPWR sky130_fd_sc_hd__tapvpwrvgnd_1
XFILLER_207_653 VPWR VGND VPWR VGND sky130_ef_sc_hd__decap_12
XFILLER_0_53 VGND VGND VPWR VPWR sky130_fd_sc_hd__decap_3
XFILLER_206_141 VPWR VGND VPWR VGND sky130_ef_sc_hd__decap_12
XFILLER_179_505 VPWR VGND VPWR VGND sky130_ef_sc_hd__decap_12
XFILLER_4_1197 VGND VGND VPWR VPWR sky130_fd_sc_hd__decap_6
XFILLER_207_697 VPWR VGND VPWR VGND sky130_ef_sc_hd__decap_12
XFILLER_72_1300 VGND VGND VPWR VPWR sky130_fd_sc_hd__fill_1
XFILLER_0_97 VPWR VGND VPWR VGND sky130_ef_sc_hd__decap_12
XPHY_EDGE_ROW_55_2_Left_487 VGND VGND VPWR VPWR sky130_fd_sc_hd__decap_3
XANTENNA__483__A net156 VGND VGND VPWR VPWR sky130_fd_sc_hd__diode_2
XFILLER_37_1442 VPWR VGND VPWR VGND sky130_ef_sc_hd__decap_12
XFILLER_124_1412 VGND VGND VPWR VPWR sky130_fd_sc_hd__fill_1
XFILLER_9_51 VGND VGND VPWR VPWR sky130_fd_sc_hd__decap_4
XFILLER_174_221 VPWR VGND VPWR VGND sky130_ef_sc_hd__decap_12
XFILLER_33_1328 VGND VGND VPWR VPWR sky130_fd_sc_hd__fill_1
XFILLER_175_777 VGND VGND VPWR VPWR sky130_fd_sc_hd__decap_6
XTAP_TAPCELL_ROW_155_2_3983 VGND VPWR sky130_fd_sc_hd__tapvpwrvgnd_1
XFILLER_190_725 VPWR VGND VPWR VGND sky130_ef_sc_hd__decap_12
XFILLER_174_265 VPWR VGND VPWR VGND sky130_ef_sc_hd__decap_12
XFILLER_190_769 VPWR VGND VPWR VGND sky130_ef_sc_hd__decap_12
XFILLER_157_1232 VPWR VGND VPWR VGND sky130_ef_sc_hd__decap_12
XFILLER_0_109 VGND VGND VPWR VPWR sky130_fd_sc_hd__decap_3
XFILLER_157_1298 VPWR VGND VPWR VGND sky130_ef_sc_hd__decap_12
XFILLER_83_1440 VGND VGND VPWR VPWR sky130_fd_sc_hd__fill_1
XFILLER_48_1582 VPWR VGND VPWR VGND sky130_ef_sc_hd__decap_12
XFILLER_215_51 VGND VGND VPWR VPWR sky130_fd_sc_hd__decap_4
XFILLER_170_1421 VGND VGND VPWR VPWR sky130_fd_sc_hd__decap_6
XFILLER_135_1552 VGND VGND VPWR VPWR sky130_fd_sc_hd__fill_1
XTAP_TAPCELL_ROW_5_927 VGND VPWR sky130_fd_sc_hd__tapvpwrvgnd_1
XTAP_TAPCELL_ROW_5_938 VGND VPWR sky130_fd_sc_hd__tapvpwrvgnd_1
XFILLER_170_1465 VPWR VGND VPWR VGND sky130_ef_sc_hd__decap_12
XPHY_EDGE_ROW_119_1_Left_338 VGND VGND VPWR VPWR sky130_fd_sc_hd__decap_3
XFILLER_28_27 VGND VGND VPWR VPWR sky130_fd_sc_hd__fill_1
XFILLER_44_1468 VGND VGND VPWR VPWR sky130_fd_sc_hd__fill_1
XFILLER_217_417 VPWR VGND VPWR VGND sky130_ef_sc_hd__decap_12
XFILLER_151_39 VPWR VGND VPWR VGND sky130_ef_sc_hd__decap_12
XFILLER_71_105 VGND VGND VPWR VPWR sky130_fd_sc_hd__decap_6
XFILLER_164_1203 VGND VGND VPWR VPWR sky130_fd_sc_hd__fill_1
XFILLER_77_1244 VPWR VGND VPWR VGND sky130_ef_sc_hd__decap_12
XFILLER_44_15 VPWR VGND VPWR VGND sky130_ef_sc_hd__decap_12
XFILLER_198_825 VPWR VGND VPWR VGND sky130_ef_sc_hd__decap_12
XFILLER_212_133 VGND VGND VPWR VPWR sky130_fd_sc_hd__decap_6
XFILLER_198_869 VPWR VGND VPWR VGND sky130_ef_sc_hd__decap_12
XFILLER_197_335 VGND VGND VPWR VPWR sky130_fd_sc_hd__fill_1
XFILLER_129_1378 VGND VGND VPWR VPWR sky130_fd_sc_hd__decap_6
XFILLER_94_1580 VGND VGND VPWR VPWR sky130_fd_sc_hd__fill_1
XANTENNA__529__B1 net138 VGND VGND VPWR VPWR sky130_fd_sc_hd__diode_2
XFILLER_212_177 VPWR VGND VPWR VGND sky130_ef_sc_hd__decap_12
XFILLER_205_1233 VPWR VGND VPWR VGND sky130_ef_sc_hd__decap_12
XTAP_TAPCELL_ROW_195_2285 VGND VPWR sky130_fd_sc_hd__tapvpwrvgnd_1
XFILLER_181_1561 VGND VGND VPWR VPWR sky130_fd_sc_hd__decap_6
XFILLER_16_1526 VPWR VGND VPWR VGND sky130_ef_sc_hd__decap_12
XFILLER_197_1001 VGND VGND VPWR VPWR sky130_fd_sc_hd__decap_6
XTAP_TAPCELL_ROW_195_2296 VGND VPWR sky130_fd_sc_hd__tapvpwrvgnd_1
XFILLER_100_65 VPWR VGND VPWR VGND sky130_ef_sc_hd__decap_12
XFILLER_201_1119 VGND VGND VPWR VPWR sky130_fd_sc_hd__fill_1
XFILLER_193_541 VPWR VGND VPWR VGND sky130_ef_sc_hd__decap_12
XFILLER_166_755 VGND VGND VPWR VPWR sky130_fd_sc_hd__fill_1
XTAP_TAPCELL_ROW_216_2889 VGND VPWR sky130_fd_sc_hd__tapvpwrvgnd_1
XFILLER_197_1045 VPWR VGND VPWR VGND sky130_ef_sc_hd__decap_12
XFILLER_193_585 VPWR VGND VPWR VGND sky130_ef_sc_hd__decap_12
XFILLER_101_1220 VPWR VGND VPWR VGND sky130_ef_sc_hd__decap_12
XFILLER_5_927 VGND VGND VPWR VPWR sky130_fd_sc_hd__fill_1
XFILLER_14_1294 VGND VGND VPWR VPWR sky130_fd_sc_hd__decap_6
XTAP_TAPCELL_ROW_44_2_3263 VGND VPWR sky130_fd_sc_hd__tapvpwrvgnd_1
XFILLER_197_1089 VPWR VGND VPWR VGND sky130_ef_sc_hd__decap_12
XFILLER_107_3 VPWR VGND VPWR VGND sky130_ef_sc_hd__decap_12
XANTENNA__332__S net140 VGND VGND VPWR VPWR sky130_fd_sc_hd__diode_2
XFILLER_175_1343 VGND VGND VPWR VPWR sky130_fd_sc_hd__fill_1
XFILLER_101_1286 VPWR VGND VPWR VGND sky130_ef_sc_hd__decap_12
XPHY_EDGE_ROW_77_1_Right_663 VGND VGND VPWR VPWR sky130_fd_sc_hd__decap_3
XFILLER_136_1338 VPWR VGND VPWR VGND sky130_ef_sc_hd__decap_12
XFILLER_216_1373 VPWR VGND VPWR VGND sky130_ef_sc_hd__decap_12
XFILLER_125_51 VGND VGND VPWR VPWR sky130_fd_sc_hd__decap_4
XFILLER_62_1524 VGND VGND VPWR VPWR sky130_fd_sc_hd__fill_1
XFILLER_0_676 VGND VGND VPWR VPWR sky130_fd_sc_hd__fill_1
XFILLER_47_113 VPWR VGND VPWR VGND sky130_ef_sc_hd__decap_12
XFILLER_212_1259 VGND VGND VPWR VPWR sky130_fd_sc_hd__fill_1
XFILLER_85_55 VGND VGND VPWR VPWR sky130_fd_sc_hd__fill_1
XANTENNA_input27_A func_wdata[23] VGND VGND VPWR VPWR sky130_fd_sc_hd__diode_2
XFILLER_60_1270 VPWR VGND VPWR VGND sky130_ef_sc_hd__decap_12
XFILLER_217_951 VGND VGND VPWR VPWR sky130_fd_sc_hd__fill_1
XFILLER_21_1232 VPWR VGND VPWR VGND sky130_ef_sc_hd__decap_12
XFILLER_204_601 VPWR VGND VPWR VGND sky130_ef_sc_hd__decap_12
XTAP_TAPCELL_ROW_180_1875 VGND VPWR sky130_fd_sc_hd__tapvpwrvgnd_1
XTAP_TAPCELL_ROW_180_1864 VGND VPWR sky130_fd_sc_hd__tapvpwrvgnd_1
XFILLER_169_1169 VGND VGND VPWR VPWR sky130_fd_sc_hd__decap_6
XFILLER_112_1382 VPWR VGND VPWR VGND sky130_ef_sc_hd__decap_12
XFILLER_95_1322 VGND VGND VPWR VPWR sky130_fd_sc_hd__decap_6
XFILLER_1_1337 VGND VGND VPWR VPWR sky130_fd_sc_hd__decap_6
XFILLER_18_82 VGND VGND VPWR VPWR sky130_fd_sc_hd__fill_2
XPHY_EDGE_ROW_40_1_Left_259 VGND VGND VPWR VPWR sky130_fd_sc_hd__decap_3
XFILLER_204_645 VPWR VGND VPWR VGND sky130_ef_sc_hd__decap_12
XFILLER_203_111 VGND VGND VPWR VPWR sky130_fd_sc_hd__fill_1
XFILLER_186_1483 VGND VGND VPWR VPWR sky130_fd_sc_hd__fill_1
XFILLER_147_1434 VGND VGND VPWR VPWR sky130_fd_sc_hd__decap_6
XFILLER_95_1366 VPWR VGND VPWR VGND sky130_ef_sc_hd__decap_12
XFILLER_21_1298 VPWR VGND VPWR VGND sky130_ef_sc_hd__decap_12
XFILLER_188_357 VGND VGND VPWR VPWR sky130_fd_sc_hd__decap_6
XFILLER_147_1478 VPWR VGND VPWR VGND sky130_ef_sc_hd__decap_12
XTAP_TAPCELL_ROW_129_1_1275 VGND VPWR sky130_fd_sc_hd__tapvpwrvgnd_1
XTAP_TAPCELL_ROW_34_1_1086 VGND VPWR sky130_fd_sc_hd__tapvpwrvgnd_1
XFILLER_180_1093 VPWR VGND VPWR VGND sky130_ef_sc_hd__decap_12
XFILLER_32_1350 VGND VGND VPWR VPWR sky130_fd_sc_hd__decap_6
XFILLER_172_725 VPWR VGND VPWR VGND sky130_ef_sc_hd__decap_12
XFILLER_176_1129 VPWR VGND VPWR VGND sky130_ef_sc_hd__decap_12
XFILLER_172_769 VPWR VGND VPWR VGND sky130_ef_sc_hd__decap_12
XFILLER_7_297 VGND VGND VPWR VPWR sky130_fd_sc_hd__decap_8
XFILLER_32_1394 VPWR VGND VPWR VGND sky130_ef_sc_hd__decap_12
XFILLER_171_279 VGND VGND VPWR VPWR sky130_fd_sc_hd__fill_1
XFILLER_158_1574 VGND VGND VPWR VPWR sky130_fd_sc_hd__decap_6
XFILLER_154_1438 VPWR VGND VPWR VGND sky130_ef_sc_hd__decap_12
XTAP_TAPCELL_ROW_88_2_3550 VGND VPWR sky130_fd_sc_hd__tapvpwrvgnd_1
XFILLER_80_1602 VGND VGND VPWR VPWR sky130_fd_sc_hd__decap_3
XFILLER_4_993 VPWR VGND VPWR VGND sky130_ef_sc_hd__decap_12
XFILLER_3_481 VGND VGND VPWR VPWR sky130_fd_sc_hd__fill_1
XPHY_EDGE_ROW_151_2_Right_208 VGND VGND VPWR VPWR sky130_fd_sc_hd__decap_3
XFILLER_22_3 VPWR VGND VPWR VGND sky130_ef_sc_hd__decap_12
XTAP_TAPCELL_ROW_113_2_3715 VGND VPWR sky130_fd_sc_hd__tapvpwrvgnd_1
XFILLER_6_1259 VGND VGND VPWR VPWR sky130_fd_sc_hd__fill_1
XFILLER_187_1225 VGND VGND VPWR VPWR sky130_fd_sc_hd__decap_6
XFILLER_43_1490 VGND VGND VPWR VPWR sky130_fd_sc_hd__decap_6
XFILLER_53_105 VGND VGND VPWR VPWR sky130_fd_sc_hd__decap_6
XFILLER_208_973 VGND VGND VPWR VPWR sky130_fd_sc_hd__decap_6
XFILLER_207_461 VPWR VGND VPWR VGND sky130_ef_sc_hd__decap_12
XFILLER_187_1269 VPWR VGND VPWR VGND sky130_ef_sc_hd__decap_12
XFILLER_130_1482 VPWR VGND VPWR VGND sky130_ef_sc_hd__decap_12
XTAP_TAPCELL_ROW_81_2_3504 VGND VPWR sky130_fd_sc_hd__tapvpwrvgnd_1
Xclkbuf_3_4_0_clk clknet_0_clk VGND VGND VPWR VPWR clknet_3_4_0_clk sky130_fd_sc_hd__clkbuf_8
XFILLER_74_1406 VGND VGND VPWR VPWR sky130_fd_sc_hd__decap_6
XFILLER_179_335 VGND VGND VPWR VPWR sky130_fd_sc_hd__fill_1
XFILLER_165_1567 VGND VGND VPWR VPWR sky130_fd_sc_hd__fill_1
XFILLER_126_1518 VGND VGND VPWR VPWR sky130_fd_sc_hd__decap_6
XFILLER_210_637 VGND VGND VPWR VPWR sky130_fd_sc_hd__decap_6
XFILLER_195_839 VGND VGND VPWR VPWR sky130_fd_sc_hd__fill_1
XFILLER_14_29 VPWR VGND VPWR VGND sky130_ef_sc_hd__decap_12
XFILLER_206_1553 VPWR VGND VPWR VGND sky130_ef_sc_hd__decap_12
XFILLER_124_1220 VPWR VGND VPWR VGND sky130_ef_sc_hd__decap_12
XFILLER_37_1272 VGND VGND VPWR VPWR sky130_fd_sc_hd__fill_1
XFILLER_206_1597 VGND VGND VPWR VPWR sky130_fd_sc_hd__decap_8
XFILLER_175_541 VPWR VGND VPWR VGND sky130_ef_sc_hd__decap_12
XTAP_TAPCELL_ROW_29_2_3165 VGND VPWR sky130_fd_sc_hd__tapvpwrvgnd_1
XANTENNA__363__D b_addr\[4\] VGND VGND VPWR VPWR sky130_fd_sc_hd__diode_2
XTAP_TAPCELL_ROW_30_2_3171 VGND VPWR sky130_fd_sc_hd__tapvpwrvgnd_1
XFILLER_200_1141 VGND VGND VPWR VPWR sky130_fd_sc_hd__decap_6
XFILLER_198_1365 VGND VGND VPWR VPWR sky130_fd_sc_hd__decap_6
XTAP_TAPCELL_ROW_190_2160 VGND VPWR sky130_fd_sc_hd__tapvpwrvgnd_1
XFILLER_175_585 VPWR VGND VPWR VGND sky130_ef_sc_hd__decap_12
XFILLER_163_725 VGND VGND VPWR VPWR sky130_fd_sc_hd__decap_3
XFILLER_50_1450 VPWR VGND VPWR VGND sky130_ef_sc_hd__decap_12
XFILLER_194_1229 VPWR VGND VPWR VGND sky130_ef_sc_hd__decap_12
XFILLER_190_533 VPWR VGND VPWR VGND sky130_ef_sc_hd__decap_12
XFILLER_163_769 VPWR VGND VPWR VGND sky130_ef_sc_hd__decap_12
XFILLER_102_1562 VPWR VGND VPWR VGND sky130_ef_sc_hd__decap_12
XFILLER_11_1434 VGND VGND VPWR VPWR sky130_fd_sc_hd__decap_6
XFILLER_50_1494 VPWR VGND VPWR VGND sky130_ef_sc_hd__decap_12
XTAP_TAPCELL_ROW_211_2764 VGND VPWR sky130_fd_sc_hd__tapvpwrvgnd_1
XTAP_TAPCELL_ROW_211_2753 VGND VPWR sky130_fd_sc_hd__tapvpwrvgnd_1
XTAP_TAPCELL_ROW_211_2742 VGND VPWR sky130_fd_sc_hd__tapvpwrvgnd_1
XFILLER_200_1185 VPWR VGND VPWR VGND sky130_ef_sc_hd__decap_12
XFILLER_85_1546 VGND VGND VPWR VPWR sky130_fd_sc_hd__decap_6
XFILLER_11_1478 VPWR VGND VPWR VGND sky130_ef_sc_hd__decap_12
XFILLER_39_15 VPWR VGND VPWR VGND sky130_ef_sc_hd__decap_12
XFILLER_213_1513 VPWR VGND VPWR VGND sky130_ef_sc_hd__decap_12
XFILLER_130_121 VGND VGND VPWR VPWR sky130_fd_sc_hd__decap_6
XTAP_TAPCELL_ROW_22_2_3119 VGND VPWR sky130_fd_sc_hd__tapvpwrvgnd_1
XFILLER_162_27 VGND VGND VPWR VPWR sky130_fd_sc_hd__fill_1
XFILLER_44_1232 VPWR VGND VPWR VGND sky130_ef_sc_hd__decap_12
XFILLER_218_737 VPWR VGND VPWR VGND sky130_ef_sc_hd__decap_12
XFILLER_170_1273 VPWR VGND VPWR VGND sky130_ef_sc_hd__decap_12
XFILLER_29_113 VPWR VGND VPWR VGND sky130_ef_sc_hd__decap_12
XFILLER_217_225 VPWR VGND VPWR VGND sky130_ef_sc_hd__decap_12
XTAP_TAPCELL_ROW_209_2693 VGND VPWR sky130_fd_sc_hd__tapvpwrvgnd_1
XFILLER_131_1268 VGND VGND VPWR VPWR sky130_fd_sc_hd__decap_4
XFILLER_79_1328 VGND VGND VPWR VPWR sky130_fd_sc_hd__fill_1
XFILLER_61_1590 VPWR VGND VPWR VGND sky130_ef_sc_hd__decap_12
XFILLER_211_1281 VGND VGND VPWR VPWR sky130_fd_sc_hd__decap_6
XTAP_TAPCELL_ROW_205_2579 VGND VPWR sky130_fd_sc_hd__tapvpwrvgnd_1
XFILLER_166_1309 VGND VGND VPWR VPWR sky130_fd_sc_hd__decap_6
XFILLER_22_1574 VGND VGND VPWR VPWR sky130_fd_sc_hd__decap_6
XFILLER_55_69 VPWR VGND VPWR VGND sky130_ef_sc_hd__decap_12
XTAP_TAPCELL_ROW_197_2347 VGND VPWR sky130_fd_sc_hd__tapvpwrvgnd_1
XFILLER_92_1506 VPWR VGND VPWR VGND sky130_ef_sc_hd__decap_12
XTAP_TAPCELL_ROW_197_2358 VGND VPWR sky130_fd_sc_hd__tapvpwrvgnd_1
XFILLER_213_497 VGND VGND VPWR VPWR sky130_fd_sc_hd__decap_6
XFILLER_201_615 VGND VGND VPWR VPWR sky130_fd_sc_hd__fill_1
XFILLER_185_305 VPWR VGND VPWR VGND sky130_ef_sc_hd__decap_12
XANTENNA__327__S net140 VGND VGND VPWR VPWR sky130_fd_sc_hd__diode_2
XFILLER_198_699 VGND VGND VPWR VPWR sky130_fd_sc_hd__fill_1
XFILLER_185_349 VPWR VGND VPWR VGND sky130_ef_sc_hd__decap_12
XFILLER_107_1440 VGND VGND VPWR VPWR sky130_fd_sc_hd__fill_1
XFILLER_71_57 VPWR VGND VPWR VGND sky130_ef_sc_hd__decap_12
XFILLER_205_1063 VGND VGND VPWR VPWR sky130_fd_sc_hd__fill_1
XFILLER_194_861 VGND VGND VPWR VPWR sky130_fd_sc_hd__decap_6
XFILLER_187_57 VPWR VGND VPWR VGND sky130_ef_sc_hd__decap_12
XFILLER_16_1356 VGND VGND VPWR VPWR sky130_fd_sc_hd__fill_1
XFILLER_193_393 VPWR VGND VPWR VGND sky130_ef_sc_hd__decap_12
XFILLER_177_1449 VGND VGND VPWR VPWR sky130_fd_sc_hd__decap_6
XPHY_EDGE_ROW_78_1_Right_664 VGND VGND VPWR VPWR sky130_fd_sc_hd__decap_3
XFILLER_20_83 VGND VGND VPWR VPWR sky130_fd_sc_hd__fill_1
XFILLER_136_83 VGND VGND VPWR VPWR sky130_fd_sc_hd__fill_1
XFILLER_1_941 VGND VGND VPWR VPWR sky130_fd_sc_hd__decap_8
XFILLER_118_1580 VGND VGND VPWR VPWR sky130_fd_sc_hd__fill_1
XFILLER_96_65 VPWR VGND VPWR VGND sky130_ef_sc_hd__decap_12
XFILLER_0_473 VGND VGND VPWR VPWR sky130_fd_sc_hd__fill_1
XFILLER_7_1513 VPWR VGND VPWR VGND sky130_ef_sc_hd__decap_12
XTAP_TAPCELL_ROW_182_1926 VGND VPWR sky130_fd_sc_hd__tapvpwrvgnd_1
XTAP_TAPCELL_ROW_182_1915 VGND VPWR sky130_fd_sc_hd__tapvpwrvgnd_1
XFILLER_27_1496 VGND VGND VPWR VPWR sky130_fd_sc_hd__fill_1
XTAP_TAPCELL_ROW_182_1937 VGND VPWR sky130_fd_sc_hd__tapvpwrvgnd_1
XTAP_TAPCELL_ROW_167_1494 VGND VPWR sky130_fd_sc_hd__tapvpwrvgnd_1
XTAP_TAPCELL_ROW_163_1347 VGND VPWR sky130_fd_sc_hd__tapvpwrvgnd_1
XTAP_TAPCELL_ROW_66_2_3406 VGND VPWR sky130_fd_sc_hd__tapvpwrvgnd_1
XFILLER_184_1409 VPWR VGND VPWR VGND sky130_ef_sc_hd__decap_12
XTAP_TAPCELL_ROW_163_1369 VGND VPWR sky130_fd_sc_hd__tapvpwrvgnd_1
XTAP_TAPCELL_ROW_163_1358 VGND VPWR sky130_fd_sc_hd__tapvpwrvgnd_1
XFILLER_1_1101 VPWR VGND VPWR VGND sky130_ef_sc_hd__decap_12
XFILLER_5_1281 VGND VGND VPWR VPWR sky130_fd_sc_hd__decap_6
XFILLER_205_921 VPWR VGND VPWR VGND sky130_ef_sc_hd__decap_12
XFILLER_188_1589 VGND VGND VPWR VPWR sky130_fd_sc_hd__decap_6
XFILLER_147_1220 VPWR VGND VPWR VGND sky130_ef_sc_hd__decap_12
XFILLER_1_1145 VPWR VGND VPWR VGND sky130_ef_sc_hd__decap_12
XFILLER_205_965 VPWR VGND VPWR VGND sky130_ef_sc_hd__decap_12
XFILLER_188_121 VPWR VGND VPWR VGND sky130_ef_sc_hd__decap_12
X_598_ clknet_3_5_0_clk _032_ VGND VGND VPWR VPWR net85 sky130_fd_sc_hd__dfxtp_1
XFILLER_1_1189 VPWR VGND VPWR VGND sky130_ef_sc_hd__decap_12
XFILLER_204_475 VGND VGND VPWR VPWR sky130_fd_sc_hd__fill_1
XFILLER_188_165 VPWR VGND VPWR VGND sky130_ef_sc_hd__decap_12
XFILLER_147_1286 VPWR VGND VPWR VGND sky130_ef_sc_hd__decap_12
XFILLER_177_839 VGND VGND VPWR VPWR sky130_fd_sc_hd__fill_1
XTAP_TAPCELL_ROW_65_1_1147 VGND VPWR sky130_fd_sc_hd__tapvpwrvgnd_1
XTAP_TAPCELL_ROW_15_2_3073 VGND VPWR sky130_fd_sc_hd__tapvpwrvgnd_1
XFILLER_34_1412 VGND VGND VPWR VPWR sky130_fd_sc_hd__fill_1
XFILLER_200_681 VPWR VGND VPWR VGND sky130_ef_sc_hd__decap_12
XFILLER_195_1505 VGND VGND VPWR VPWR sky130_fd_sc_hd__decap_6
XFILLER_195_1549 VPWR VGND VPWR VGND sky130_ef_sc_hd__decap_12
XFILLER_172_533 VPWR VGND VPWR VGND sky130_ef_sc_hd__decap_12
XANTENNA_1 _067_ VGND VGND VPWR VPWR sky130_fd_sc_hd__diode_2
XFILLER_67_1232 VPWR VGND VPWR VGND sky130_ef_sc_hd__decap_12
XFILLER_6_85 VGND VGND VPWR VPWR sky130_fd_sc_hd__decap_8
XFILLER_158_1382 VPWR VGND VPWR VGND sky130_ef_sc_hd__decap_12
XFILLER_119_1322 VGND VGND VPWR VPWR sky130_fd_sc_hd__decap_6
XFILLER_154_1246 VPWR VGND VPWR VGND sky130_ef_sc_hd__decap_12
XFILLER_119_1366 VPWR VGND VPWR VGND sky130_ef_sc_hd__decap_12
XFILLER_112_121 VGND VGND VPWR VPWR sky130_fd_sc_hd__decap_6
XFILLER_67_1298 VPWR VGND VPWR VGND sky130_ef_sc_hd__decap_12
XFILLER_45_1552 VGND VGND VPWR VPWR sky130_fd_sc_hd__fill_1
XFILLER_171_1593 VPWR VGND VPWR VGND sky130_ef_sc_hd__decap_12
XPHY_EDGE_ROW_152_2_Right_209 VGND VGND VPWR VPWR sky130_fd_sc_hd__decap_3
XFILLER_215_729 VPWR VGND VPWR VGND sky130_ef_sc_hd__decap_12
XFILLER_212_41 VPWR VGND VPWR VGND sky130_ef_sc_hd__decap_12
XFILLER_187_1033 VPWR VGND VPWR VGND sky130_ef_sc_hd__decap_12
XFILLER_208_781 VPWR VGND VPWR VGND sky130_ef_sc_hd__decap_12
XFILLER_187_1077 VPWR VGND VPWR VGND sky130_ef_sc_hd__decap_12
XTAP_TAPCELL_ROW_143_2_3910 VGND VPWR sky130_fd_sc_hd__tapvpwrvgnd_1
XFILLER_78_1350 VGND VGND VPWR VPWR sky130_fd_sc_hd__decap_6
XPHY_EDGE_ROW_15_2_Right_72 VGND VGND VPWR VPWR sky130_fd_sc_hd__decap_3
XFILLER_212_85 VPWR VGND VPWR VGND sky130_ef_sc_hd__decap_12
XTAP_TAPCELL_ROW_200_2443 VGND VPWR sky130_fd_sc_hd__tapvpwrvgnd_1
XTAP_TAPCELL_ROW_200_2432 VGND VPWR sky130_fd_sc_hd__tapvpwrvgnd_1
XFILLER_78_1394 VPWR VGND VPWR VGND sky130_ef_sc_hd__decap_12
XFILLER_210_401 VPWR VGND VPWR VGND sky130_ef_sc_hd__decap_12
XTAP_TAPCELL_ROW_200_2454 VGND VPWR sky130_fd_sc_hd__tapvpwrvgnd_1
XTAP_TAPCELL_ROW_192_2200 VGND VPWR sky130_fd_sc_hd__tapvpwrvgnd_1
XFILLER_167_305 VPWR VGND VPWR VGND sky130_ef_sc_hd__decap_12
XFILLER_126_1326 VPWR VGND VPWR VGND sky130_ef_sc_hd__decap_12
XFILLER_74_1258 VPWR VGND VPWR VGND sky130_ef_sc_hd__decap_12
XFILLER_39_1378 VGND VGND VPWR VPWR sky130_fd_sc_hd__decap_6
XFILLER_210_445 VPWR VGND VPWR VGND sky130_ef_sc_hd__decap_12
XTAP_TAPCELL_ROW_192_2222 VGND VPWR sky130_fd_sc_hd__tapvpwrvgnd_1
XTAP_TAPCELL_ROW_192_2211 VGND VPWR sky130_fd_sc_hd__tapvpwrvgnd_1
XTAP_TAPCELL_ROW_112_1_1242 VGND VPWR sky130_fd_sc_hd__tapvpwrvgnd_1
XFILLER_210_489 VPWR VGND VPWR VGND sky130_ef_sc_hd__decap_12
XFILLER_202_1203 VGND VGND VPWR VPWR sky130_fd_sc_hd__fill_1
XFILLER_183_809 VPWR VGND VPWR VGND sky130_ef_sc_hd__decap_12
XFILLER_176_861 VGND VGND VPWR VPWR sky130_fd_sc_hd__decap_6
XFILLER_167_349 VPWR VGND VPWR VGND sky130_ef_sc_hd__decap_12
XFILLER_104_1602 VGND VGND VPWR VPWR sky130_fd_sc_hd__decap_3
XFILLER_41_27 VPWR VGND VPWR VGND sky130_ef_sc_hd__decap_12
XTAP_TAPCELL_ROW_213_2815 VGND VPWR sky130_fd_sc_hd__tapvpwrvgnd_1
XTAP_TAPCELL_ROW_213_2804 VGND VPWR sky130_fd_sc_hd__tapvpwrvgnd_1
XFILLER_157_27 VPWR VGND VPWR VGND sky130_ef_sc_hd__decap_12
XFILLER_198_1173 VPWR VGND VPWR VGND sky130_ef_sc_hd__decap_12
XFILLER_191_853 VPWR VGND VPWR VGND sky130_ef_sc_hd__decap_12
XFILLER_175_393 VPWR VGND VPWR VGND sky130_ef_sc_hd__decap_12
XFILLER_163_533 VPWR VGND VPWR VGND sky130_ef_sc_hd__decap_12
XFILLER_11_1220 VPWR VGND VPWR VGND sky130_ef_sc_hd__decap_12
XFILLER_194_1037 VPWR VGND VPWR VGND sky130_ef_sc_hd__decap_12
XFILLER_191_897 VPWR VGND VPWR VGND sky130_ef_sc_hd__decap_12
XFILLER_190_363 VGND VGND VPWR VPWR sky130_fd_sc_hd__fill_1
XFILLER_102_1370 VPWR VGND VPWR VGND sky130_ef_sc_hd__decap_12
XFILLER_89_1490 VGND VGND VPWR VPWR sky130_fd_sc_hd__decap_6
XFILLER_85_1310 VPWR VGND VPWR VGND sky130_ef_sc_hd__decap_12
XTAP_TAPCELL_ROW_59_2_3360 VGND VPWR sky130_fd_sc_hd__tapvpwrvgnd_1
XFILLER_173_15 VPWR VGND VPWR VGND sky130_ef_sc_hd__decap_12
XFILLER_137_1422 VPWR VGND VPWR VGND sky130_ef_sc_hd__decap_12
XFILLER_85_1354 VPWR VGND VPWR VGND sky130_ef_sc_hd__decap_12
XANTENNA_clkbuf_3_3_0_clk_A clknet_0_clk VGND VGND VPWR VPWR sky130_fd_sc_hd__diode_2
XFILLER_11_1286 VPWR VGND VPWR VGND sky130_ef_sc_hd__decap_12
XTAP_TAPCELL_ROW_186_2048 VGND VPWR sky130_fd_sc_hd__tapvpwrvgnd_1
XTAP_TAPCELL_ROW_186_2037 VGND VPWR sky130_fd_sc_hd__tapvpwrvgnd_1
XFILLER_137_1466 VPWR VGND VPWR VGND sky130_ef_sc_hd__decap_12
XFILLER_85_1398 VPWR VGND VPWR VGND sky130_ef_sc_hd__decap_12
XTAP_TAPCELL_ROW_72_2_3449 VGND VPWR sky130_fd_sc_hd__tapvpwrvgnd_1
XFILLER_46_1338 VPWR VGND VPWR VGND sky130_ef_sc_hd__decap_12
XPHY_EDGE_ROW_132_2_Left_564 VGND VGND VPWR VPWR sky130_fd_sc_hd__decap_3
XFILLER_106_53 VPWR VGND VPWR VGND sky130_ef_sc_hd__decap_12
XFILLER_218_501 VPWR VGND VPWR VGND sky130_ef_sc_hd__decap_12
XFILLER_213_1343 VGND VGND VPWR VPWR sky130_fd_sc_hd__fill_1
XTAP_TAPCELL_ROW_52_2_3314 VGND VPWR sky130_fd_sc_hd__tapvpwrvgnd_1
XFILLER_218_545 VPWR VGND VPWR VGND sky130_ef_sc_hd__decap_12
XFILLER_106_97 VPWR VGND VPWR VGND sky130_ef_sc_hd__decap_12
XFILLER_218_589 VPWR VGND VPWR VGND sky130_ef_sc_hd__decap_12
XTAP_TAPCELL_ROW_199_2409 VGND VPWR sky130_fd_sc_hd__tapvpwrvgnd_1
XFILLER_174_3 VPWR VGND VPWR VGND sky130_ef_sc_hd__decap_12
XFILLER_122_41 VPWR VGND VPWR VGND sky130_ef_sc_hd__decap_12
XFILLER_2_1421 VGND VGND VPWR VPWR sky130_fd_sc_hd__decap_6
XFILLER_205_217 VGND VGND VPWR VPWR sky130_fd_sc_hd__decap_6
XFILLER_166_1117 VPWR VGND VPWR VGND sky130_ef_sc_hd__decap_12
XFILLER_96_1450 VPWR VGND VPWR VGND sky130_ef_sc_hd__decap_12
X_521_ net150 _177_ net128 net137 _234_ VGND VGND VPWR VPWR _044_ sky130_fd_sc_hd__o311a_1
XFILLER_2_1465 VPWR VGND VPWR VGND sky130_ef_sc_hd__decap_12
XFILLER_22_1382 VPWR VGND VPWR VGND sky130_ef_sc_hd__decap_12
XFILLER_199_953 VPWR VGND VPWR VGND sky130_ef_sc_hd__decap_12
XFILLER_148_1562 VPWR VGND VPWR VGND sky130_ef_sc_hd__decap_12
XFILLER_122_85 VPWR VGND VPWR VGND sky130_ef_sc_hd__decap_12
XFILLER_96_1494 VPWR VGND VPWR VGND sky130_ef_sc_hd__decap_12
XFILLER_92_1314 VPWR VGND VPWR VGND sky130_ef_sc_hd__decap_12
X_452_ net146 net101 VGND VGND VPWR VPWR _184_ sky130_fd_sc_hd__xor2_1
XFILLER_57_1434 VGND VGND VPWR VPWR sky130_fd_sc_hd__decap_6
XFILLER_213_261 VPWR VGND VPWR VGND sky130_ef_sc_hd__decap_12
XFILLER_144_1426 VPWR VGND VPWR VGND sky130_ef_sc_hd__decap_12
XFILLER_109_1546 VGND VGND VPWR VPWR sky130_fd_sc_hd__decap_6
XFILLER_92_1358 VPWR VGND VPWR VGND sky130_ef_sc_hd__decap_12
X_383_ b_addr\[1\] _104_ VGND VGND VPWR VPWR _122_ sky130_fd_sc_hd__nand2_1
XFILLER_57_1478 VPWR VGND VPWR VGND sky130_ef_sc_hd__decap_12
XFILLER_207_1169 VGND VGND VPWR VPWR sky130_fd_sc_hd__decap_6
XFILLER_186_625 VPWR VGND VPWR VGND sky130_ef_sc_hd__decap_12
XFILLER_185_113 VPWR VGND VPWR VGND sky130_ef_sc_hd__decap_12
XFILLER_15_72 VGND VGND VPWR VPWR sky130_fd_sc_hd__decap_3
XFILLER_202_979 VGND VGND VPWR VPWR sky130_fd_sc_hd__fill_1
XFILLER_186_669 VPWR VGND VPWR VGND sky130_ef_sc_hd__decap_12
XTAP_TAPCELL_ROW_175_1741 VGND VPWR sky130_fd_sc_hd__tapvpwrvgnd_1
XTAP_TAPCELL_ROW_175_1730 VGND VPWR sky130_fd_sc_hd__tapvpwrvgnd_1
XTAP_TAPCELL_ROW_171_1605 VGND VPWR sky130_fd_sc_hd__tapvpwrvgnd_1
XFILLER_177_1213 VPWR VGND VPWR VGND sky130_ef_sc_hd__decap_12
XTAP_TAPCELL_ROW_171_1627 VGND VPWR sky130_fd_sc_hd__tapvpwrvgnd_1
XTAP_TAPCELL_ROW_171_1616 VGND VPWR sky130_fd_sc_hd__tapvpwrvgnd_1
XFILLER_177_1257 VPWR VGND VPWR VGND sky130_ef_sc_hd__decap_12
XFILLER_120_1470 VPWR VGND VPWR VGND sky130_ef_sc_hd__decap_12
XFILLER_181_385 VGND VGND VPWR VPWR sky130_fd_sc_hd__decap_6
XFILLER_155_1522 VPWR VGND VPWR VGND sky130_ef_sc_hd__decap_12
XFILLER_147_93 VPWR VGND VPWR VGND sky130_ef_sc_hd__decap_12
XFILLER_68_1574 VGND VGND VPWR VPWR sky130_fd_sc_hd__decap_6
XFILLER_5_587 VGND VGND VPWR VPWR sky130_fd_sc_hd__fill_2
XFILLER_49_8 VPWR VGND VPWR VGND sky130_ef_sc_hd__decap_12
XFILLER_116_1506 VPWR VGND VPWR VGND sky130_ef_sc_hd__decap_12
XFILLER_64_1438 VPWR VGND VPWR VGND sky130_ef_sc_hd__decap_12
XPHY_EDGE_ROW_64_2_Left_496 VGND VGND VPWR VPWR sky130_fd_sc_hd__decap_3
Xoutput60 net60 VGND VGND VPWR VPWR bist_fail_bits[12] sky130_fd_sc_hd__buf_2
XFILLER_214_1129 VPWR VGND VPWR VGND sky130_ef_sc_hd__decap_12
XTAP_TAPCELL_ROW_169_1567 VGND VPWR sky130_fd_sc_hd__tapvpwrvgnd_1
XTAP_TAPCELL_ROW_169_1556 VGND VPWR sky130_fd_sc_hd__tapvpwrvgnd_1
XTAP_TAPCELL_ROW_169_1545 VGND VPWR sky130_fd_sc_hd__tapvpwrvgnd_1
XFILLER_155_1566 VPWR VGND VPWR VGND sky130_ef_sc_hd__decap_12
XPHY_EDGE_ROW_79_1_Right_665 VGND VGND VPWR VPWR sky130_fd_sc_hd__decap_3
Xoutput82 net82 VGND VGND VPWR VPWR bist_fail_bits[3] sky130_fd_sc_hd__buf_2
Xoutput71 net71 VGND VGND VPWR VPWR bist_fail_bits[22] sky130_fd_sc_hd__buf_2
Xoutput93 net93 VGND VGND VPWR VPWR func_rdata[13] sky130_fd_sc_hd__buf_2
XFILLER_163_81 VGND VGND VPWR VPWR sky130_fd_sc_hd__decap_3
XFILLER_0_270 VGND VGND VPWR VPWR sky130_fd_sc_hd__decap_3
XFILLER_0_281 VGND VGND VPWR VPWR sky130_fd_sc_hd__decap_6
XFILLER_188_1353 VPWR VGND VPWR VGND sky130_ef_sc_hd__decap_12
XTAP_TAPCELL_ROW_128_2_3812 VGND VPWR sky130_fd_sc_hd__tapvpwrvgnd_1
XFILLER_188_1397 VPWR VGND VPWR VGND sky130_ef_sc_hd__decap_12
XFILLER_184_1217 VPWR VGND VPWR VGND sky130_ef_sc_hd__decap_12
XFILLER_40_1482 VPWR VGND VPWR VGND sky130_ef_sc_hd__decap_12
XFILLER_127_1602 VGND VGND VPWR VPWR sky130_fd_sc_hd__decap_3
XTAP_TAPCELL_ROW_96_2_3601 VGND VPWR sky130_fd_sc_hd__tapvpwrvgnd_1
XFILLER_75_1534 VPWR VGND VPWR VGND sky130_ef_sc_hd__decap_12
XFILLER_189_441 VGND VGND VPWR VPWR sky130_fd_sc_hd__decap_6
XPHY_EDGE_ROW_169_Right_14 VGND VGND VPWR VPWR sky130_fd_sc_hd__decap_3
XFILLER_162_1526 VPWR VGND VPWR VGND sky130_ef_sc_hd__decap_12
XFILLER_75_1578 VPWR VGND VPWR VGND sky130_ef_sc_hd__decap_12
XFILLER_36_1518 VGND VGND VPWR VPWR sky130_fd_sc_hd__decap_6
XFILLER_189_485 VPWR VGND VPWR VGND sky130_ef_sc_hd__decap_12
XFILLER_165_809 VPWR VGND VPWR VGND sky130_ef_sc_hd__decap_12
XFILLER_34_1220 VPWR VGND VPWR VGND sky130_ef_sc_hd__decap_12
XFILLER_203_1567 VGND VGND VPWR VPWR sky130_fd_sc_hd__fill_1
XFILLER_191_105 VGND VGND VPWR VPWR sky130_fd_sc_hd__decap_6
XPHY_EDGE_ROW_128_1_Left_347 VGND VGND VPWR VPWR sky130_fd_sc_hd__decap_3
XFILLER_195_1313 VPWR VGND VPWR VGND sky130_ef_sc_hd__decap_12
XFILLER_191_149 VPWR VGND VPWR VGND sky130_ef_sc_hd__decap_12
XFILLER_173_853 VPWR VGND VPWR VGND sky130_ef_sc_hd__decap_12
XFILLER_160_1294 VGND VGND VPWR VPWR sky130_fd_sc_hd__decap_6
XFILLER_121_1256 VPWR VGND VPWR VGND sky130_ef_sc_hd__decap_12
XFILLER_199_1493 VPWR VGND VPWR VGND sky130_ef_sc_hd__decap_12
XFILLER_195_1357 VPWR VGND VPWR VGND sky130_ef_sc_hd__decap_12
XFILLER_172_363 VGND VGND VPWR VPWR sky130_fd_sc_hd__fill_1
XFILLER_12_1562 VPWR VGND VPWR VGND sky130_ef_sc_hd__decap_12
XPHY_EDGE_ROW_178_Right_23 VGND VGND VPWR VPWR sky130_fd_sc_hd__decap_3
XFILLER_173_897 VPWR VGND VPWR VGND sky130_ef_sc_hd__decap_12
XFILLER_82_1538 VPWR VGND VPWR VGND sky130_ef_sc_hd__decap_12
XFILLER_219_309 VPWR VGND VPWR VGND sky130_ef_sc_hd__decap_12
XTAP_TAPCELL_ROW_37_2_3216 VGND VPWR sky130_fd_sc_hd__tapvpwrvgnd_1
XFILLER_36_27 VGND VGND VPWR VPWR sky130_fd_sc_hd__fill_1
XFILLER_41_1268 VGND VGND VPWR VPWR sky130_fd_sc_hd__decap_4
XTAP_TAPCELL_ROW_202_2505 VGND VPWR sky130_fd_sc_hd__tapvpwrvgnd_1
XFILLER_199_205 VPWR VGND VPWR VGND sky130_ef_sc_hd__decap_12
XFILLER_167_1437 VPWR VGND VPWR VGND sky130_ef_sc_hd__decap_12
XFILLER_215_559 VGND VGND VPWR VPWR sky130_fd_sc_hd__fill_1
XFILLER_199_249 VPWR VGND VPWR VGND sky130_ef_sc_hd__decap_12
XPHY_EDGE_ROW_187_Right_32 VGND VGND VPWR VPWR sky130_fd_sc_hd__decap_3
XFILLER_202_209 VPWR VGND VPWR VGND sky130_ef_sc_hd__decap_12
XFILLER_211_721 VGND VGND VPWR VPWR sky130_fd_sc_hd__decap_6
XFILLER_204_1309 VGND VGND VPWR VPWR sky130_fd_sc_hd__decap_6
XFILLER_196_923 VGND VGND VPWR VPWR sky130_fd_sc_hd__fill_1
XFILLER_168_625 VPWR VGND VPWR VGND sky130_ef_sc_hd__decap_12
XFILLER_168_15 VPWR VGND VPWR VGND sky130_ef_sc_hd__decap_12
XFILLER_167_113 VPWR VGND VPWR VGND sky130_ef_sc_hd__decap_12
XTAP_TAPCELL_ROW_143_1_1303 VGND VPWR sky130_fd_sc_hd__tapvpwrvgnd_1
XFILLER_211_765 VPWR VGND VPWR VGND sky130_ef_sc_hd__decap_12
XFILLER_210_253 VPWR VGND VPWR VGND sky130_ef_sc_hd__decap_12
XFILLER_168_669 VPWR VGND VPWR VGND sky130_ef_sc_hd__decap_12
XFILLER_17_1440 VGND VGND VPWR VPWR sky130_fd_sc_hd__fill_1
XFILLER_183_617 VPWR VGND VPWR VGND sky130_ef_sc_hd__decap_12
XFILLER_6_307 VGND VGND VPWR VPWR sky130_fd_sc_hd__fill_1
XFILLER_178_1533 VGND VGND VPWR VPWR sky130_fd_sc_hd__decap_6
XPHY_EDGE_ROW_196_Right_41 VGND VGND VPWR VPWR sky130_fd_sc_hd__decap_3
XTAP_TAPCELL_ROW_154_2_3979 VGND VPWR sky130_fd_sc_hd__tapvpwrvgnd_1
XFILLER_219_1541 VPWR VGND VPWR VGND sky130_ef_sc_hd__decap_12
XFILLER_178_1577 VPWR VGND VPWR VGND sky130_ef_sc_hd__decap_12
XFILLER_215_1449 VGND VGND VPWR VPWR sky130_fd_sc_hd__decap_6
XFILLER_137_1274 VPWR VGND VPWR VGND sky130_ef_sc_hd__decap_12
XANTENNA__340__S net153 VGND VGND VPWR VPWR sky130_fd_sc_hd__diode_2
XFILLER_28_1580 VGND VGND VPWR VPWR sky130_fd_sc_hd__fill_1
XTAP_TAPCELL_ROW_164_1420 VGND VPWR sky130_fd_sc_hd__tapvpwrvgnd_1
XTAP_TAPCELL_ROW_114_2_3720 VGND VPWR sky130_fd_sc_hd__tapvpwrvgnd_1
XANTENNA__279__C b_addr\[5\] VGND VGND VPWR VPWR sky130_fd_sc_hd__diode_2
XFILLER_219_865 VGND VGND VPWR VPWR sky130_fd_sc_hd__decap_3
XFILLER_133_51 VGND VGND VPWR VPWR sky130_fd_sc_hd__decap_4
XTAP_TAPCELL_ROW_89_1_1195 VGND VPWR sky130_fd_sc_hd__tapvpwrvgnd_1
XFILLER_93_55 VGND VGND VPWR VPWR sky130_fd_sc_hd__fill_1
XFILLER_185_1537 VPWR VGND VPWR VGND sky130_ef_sc_hd__decap_12
XFILLER_2_1273 VPWR VGND VPWR VGND sky130_ef_sc_hd__decap_12
X_504_ net58 net124 VGND VGND VPWR VPWR _226_ sky130_fd_sc_hd__or2_1
XFILLER_57_1220 VPWR VGND VPWR VGND sky130_ef_sc_hd__decap_12
XFILLER_148_1370 VPWR VGND VPWR VGND sky130_ef_sc_hd__decap_12
XFILLER_109_1310 VPWR VGND VPWR VGND sky130_ef_sc_hd__decap_12
XFILLER_214_581 VGND VGND VPWR VPWR sky130_fd_sc_hd__decap_6
XFILLER_199_783 VGND VGND VPWR VPWR sky130_fd_sc_hd__fill_1
XFILLER_187_945 VGND VGND VPWR VPWR sky130_fd_sc_hd__decap_6
XFILLER_109_1354 VPWR VGND VPWR VGND sky130_ef_sc_hd__decap_12
X_435_ b_addr\[7\] _102_ VGND VGND VPWR VPWR _168_ sky130_fd_sc_hd__nand2_1
XFILLER_57_1286 VPWR VGND VPWR VGND sky130_ef_sc_hd__decap_12
XFILLER_186_433 VPWR VGND VPWR VGND sky130_ef_sc_hd__decap_12
XFILLER_109_1398 VPWR VGND VPWR VGND sky130_ef_sc_hd__decap_12
X_366_ net153 _108_ _102_ VGND VGND VPWR VPWR _109_ sky130_fd_sc_hd__a21o_1
XFILLER_187_989 VPWR VGND VPWR VGND sky130_ef_sc_hd__decap_12
XFILLER_186_477 VPWR VGND VPWR VGND sky130_ef_sc_hd__decap_12
XFILLER_173_105 VGND VGND VPWR VPWR sky130_fd_sc_hd__decap_6
X_297_ net38 net141 net131 VGND VGND VPWR VPWR s_wdata\[4\] sky130_fd_sc_hd__a21o_1
XANTENNA__344__A1 b_addr\[3\] VGND VGND VPWR VPWR sky130_fd_sc_hd__diode_2
XFILLER_177_1021 VPWR VGND VPWR VGND sky130_ef_sc_hd__decap_12
XFILLER_173_149 VPWR VGND VPWR VGND sky130_ef_sc_hd__decap_12
XTAP_TAPCELL_ROW_43_2_3259 VGND VPWR sky130_fd_sc_hd__tapvpwrvgnd_1
XFILLER_177_1065 VPWR VGND VPWR VGND sky130_ef_sc_hd__decap_12
XFILLER_181_193 VPWR VGND VPWR VGND sky130_ef_sc_hd__decap_12
XFILLER_170_867 VGND VGND VPWR VPWR sky130_fd_sc_hd__fill_1
XFILLER_155_1330 VPWR VGND VPWR VGND sky130_ef_sc_hd__decap_12
XFILLER_68_1382 VPWR VGND VPWR VGND sky130_ef_sc_hd__decap_12
XFILLER_5_384 VGND VGND VPWR VPWR sky130_fd_sc_hd__fill_1
XFILLER_29_1322 VGND VGND VPWR VPWR sky130_fd_sc_hd__decap_6
XFILLER_218_1073 VPWR VGND VPWR VGND sky130_ef_sc_hd__decap_12
XPHY_EDGE_ROW_200_Right_45 VGND VGND VPWR VPWR sky130_fd_sc_hd__decap_3
XFILLER_116_1314 VPWR VGND VPWR VGND sky130_ef_sc_hd__decap_12
XFILLER_64_1246 VPWR VGND VPWR VGND sky130_ef_sc_hd__decap_12
XFILLER_29_1366 VPWR VGND VPWR VGND sky130_ef_sc_hd__decap_12
XFILLER_116_1358 VPWR VGND VPWR VGND sky130_ef_sc_hd__decap_12
XFILLER_95_111 VGND VGND VPWR VPWR sky130_fd_sc_hd__fill_1
XTAP_TAPCELL_ROW_136_1_1290 VGND VPWR sky130_fd_sc_hd__tapvpwrvgnd_1
XFILLER_7_1173 VGND VGND VPWR VPWR sky130_fd_sc_hd__decap_3
XFILLER_188_1161 VPWR VGND VPWR VGND sky130_ef_sc_hd__decap_12
XFILLER_197_709 VPWR VGND VPWR VGND sky130_ef_sc_hd__decap_12
XFILLER_127_1410 VPWR VGND VPWR VGND sky130_ef_sc_hd__decap_12
XFILLER_75_1342 VPWR VGND VPWR VGND sky130_ef_sc_hd__decap_12
XFILLER_178_923 VGND VGND VPWR VPWR sky130_fd_sc_hd__fill_1
XFILLER_127_1454 VPWR VGND VPWR VGND sky130_ef_sc_hd__decap_12
XFILLER_75_1386 VPWR VGND VPWR VGND sky130_ef_sc_hd__decap_12
XFILLER_36_1326 VPWR VGND VPWR VGND sky130_ef_sc_hd__decap_12
XFILLER_189_293 VPWR VGND VPWR VGND sky130_ef_sc_hd__decap_12
XFILLER_162_1356 VGND VGND VPWR VPWR sky130_fd_sc_hd__fill_1
XFILLER_149_113 VPWR VGND VPWR VGND sky130_ef_sc_hd__decap_12
XFILLER_165_617 VPWR VGND VPWR VGND sky130_ef_sc_hd__decap_12
XFILLER_127_1498 VPWR VGND VPWR VGND sky130_ef_sc_hd__decap_12
XFILLER_14_1602 VGND VGND VPWR VPWR sky130_fd_sc_hd__decap_3
XTAP_TAPCELL_ROW_140_2_3887 VGND VPWR sky130_fd_sc_hd__tapvpwrvgnd_1
XFILLER_138_29 VPWR VGND VPWR VGND sky130_ef_sc_hd__decap_12
XFILLER_195_1121 VPWR VGND VPWR VGND sky130_ef_sc_hd__decap_12
XFILLER_192_469 VGND VGND VPWR VPWR sky130_fd_sc_hd__decap_6
XFILLER_12_1370 VPWR VGND VPWR VGND sky130_ef_sc_hd__decap_12
XFILLER_191_1007 VGND VGND VPWR VPWR sky130_fd_sc_hd__fill_1
XFILLER_86_1482 VPWR VGND VPWR VGND sky130_ef_sc_hd__decap_12
XFILLER_82_1302 VPWR VGND VPWR VGND sky130_ef_sc_hd__decap_12
XANTENNA__592__CLK clknet_3_3_0_clk VGND VGND VPWR VPWR sky130_fd_sc_hd__diode_2
XFILLER_47_1422 VPWR VGND VPWR VGND sky130_ef_sc_hd__decap_12
XFILLER_138_1550 VPWR VGND VPWR VGND sky130_ef_sc_hd__decap_12
XFILLER_134_1414 VPWR VGND VPWR VGND sky130_ef_sc_hd__decap_12
XTAP_TAPCELL_ROW_87_2_3546 VGND VPWR sky130_fd_sc_hd__tapvpwrvgnd_1
XFILLER_47_1466 VPWR VGND VPWR VGND sky130_ef_sc_hd__decap_12
XFILLER_138_1594 VGND VGND VPWR VPWR sky130_fd_sc_hd__decap_8
Xfanout146 net148 VGND VGND VPWR VPWR net146 sky130_fd_sc_hd__buf_4
Xfanout135 net136 VGND VGND VPWR VPWR net135 sky130_fd_sc_hd__buf_2
Xfanout124 net125 VGND VGND VPWR VPWR net124 sky130_fd_sc_hd__buf_1
XANTENNA_input1_A bist_mode VGND VGND VPWR VPWR sky130_fd_sc_hd__diode_2
Xfanout157 net45 VGND VGND VPWR VPWR net157 sky130_fd_sc_hd__buf_2
XFILLER_47_15 VPWR VGND VPWR VGND sky130_ef_sc_hd__decap_12
XFILLER_170_27 VGND VGND VPWR VPWR sky130_fd_sc_hd__fill_1
XTAP_TAPCELL_ROW_67_2_3411 VGND VPWR sky130_fd_sc_hd__tapvpwrvgnd_1
XFILLER_216_813 VPWR VGND VPWR VGND sky130_ef_sc_hd__decap_12
XFILLER_167_1201 VPWR VGND VPWR VGND sky130_ef_sc_hd__decap_12
XTAP_TAPCELL_ROW_3_888 VGND VPWR sky130_fd_sc_hd__tapvpwrvgnd_1
XTAP_TAPCELL_ROW_3_877 VGND VPWR sky130_fd_sc_hd__tapvpwrvgnd_1
XTAP_TAPCELL_ROW_3_866 VGND VPWR sky130_fd_sc_hd__tapvpwrvgnd_1
XFILLER_167_1245 VPWR VGND VPWR VGND sky130_ef_sc_hd__decap_12
XFILLER_203_529 VPWR VGND VPWR VGND sky130_ef_sc_hd__decap_12
XFILLER_167_1289 VPWR VGND VPWR VGND sky130_ef_sc_hd__decap_12
XFILLER_145_1510 VPWR VGND VPWR VGND sky130_ef_sc_hd__decap_12
XFILLER_93_1442 VPWR VGND VPWR VGND sky130_ef_sc_hd__decap_12
XFILLER_3_1593 VPWR VGND VPWR VGND sky130_ef_sc_hd__decap_12
XFILLER_58_1562 VPWR VGND VPWR VGND sky130_ef_sc_hd__decap_12
XFILLER_208_1253 VGND VGND VPWR VPWR sky130_fd_sc_hd__decap_6
XFILLER_63_69 VPWR VGND VPWR VGND sky130_ef_sc_hd__decap_12
XFILLER_19_1546 VGND VGND VPWR VPWR sky130_fd_sc_hd__decap_6
XFILLER_54_1426 VPWR VGND VPWR VGND sky130_ef_sc_hd__decap_12
XFILLER_204_1117 VPWR VGND VPWR VGND sky130_ef_sc_hd__decap_12
XFILLER_179_69 VPWR VGND VPWR VGND sky130_ef_sc_hd__decap_12
XFILLER_169_945 VGND VGND VPWR VPWR sky130_fd_sc_hd__decap_6
XFILLER_168_433 VPWR VGND VPWR VGND sky130_ef_sc_hd__decap_12
XFILLER_145_1554 VPWR VGND VPWR VGND sky130_ef_sc_hd__decap_12
XFILLER_211_573 VPWR VGND VPWR VGND sky130_ef_sc_hd__decap_12
XFILLER_208_1297 VPWR VGND VPWR VGND sky130_ef_sc_hd__decap_12
XFILLER_184_937 VPWR VGND VPWR VGND sky130_ef_sc_hd__decap_12
XFILLER_169_989 VPWR VGND VPWR VGND sky130_ef_sc_hd__decap_12
XFILLER_168_477 VPWR VGND VPWR VGND sky130_ef_sc_hd__decap_12
XFILLER_155_105 VGND VGND VPWR VPWR sky130_fd_sc_hd__decap_6
XFILLER_137_3 VPWR VGND VPWR VGND sky130_ef_sc_hd__decap_12
XFILLER_106_1538 VPWR VGND VPWR VGND sky130_ef_sc_hd__decap_12
XFILLER_183_447 VGND VGND VPWR VPWR sky130_fd_sc_hd__fill_1
XFILLER_195_57 VPWR VGND VPWR VGND sky130_ef_sc_hd__decap_12
XFILLER_178_1341 VPWR VGND VPWR VGND sky130_ef_sc_hd__decap_12
XFILLER_171_609 VGND VGND VPWR VPWR sky130_fd_sc_hd__decap_6
XFILLER_192_981 VPWR VGND VPWR VGND sky130_ef_sc_hd__decap_12
XFILLER_174_1205 VPWR VGND VPWR VGND sky130_ef_sc_hd__decap_12
XFILLER_30_1470 VPWR VGND VPWR VGND sky130_ef_sc_hd__decap_12
XFILLER_178_1385 VPWR VGND VPWR VGND sky130_ef_sc_hd__decap_12
XFILLER_163_193 VGND VGND VPWR VPWR sky130_fd_sc_hd__decap_3
XFILLER_87_1268 VGND VGND VPWR VPWR sky130_fd_sc_hd__decap_4
XFILLER_65_1522 VPWR VGND VPWR VGND sky130_ef_sc_hd__decap_12
XFILLER_215_1213 VPWR VGND VPWR VGND sky130_ef_sc_hd__decap_12
XFILLER_88_77 VGND VGND VPWR VPWR sky130_fd_sc_hd__decap_6
XFILLER_2_354 VGND VGND VPWR VPWR sky130_fd_sc_hd__fill_1
XFILLER_26_1506 VPWR VGND VPWR VGND sky130_ef_sc_hd__decap_12
XFILLER_215_1257 VPWR VGND VPWR VGND sky130_ef_sc_hd__decap_12
XFILLER_77_111 VGND VGND VPWR VPWR sky130_fd_sc_hd__fill_1
XFILLER_65_1566 VPWR VGND VPWR VGND sky130_ef_sc_hd__decap_12
XFILLER_144_83 VGND VGND VPWR VPWR sky130_fd_sc_hd__fill_1
XFILLER_8_1482 VPWR VGND VPWR VGND sky130_ef_sc_hd__decap_12
XFILLER_219_673 VPWR VGND VPWR VGND sky130_ef_sc_hd__decap_12
XFILLER_206_301 VGND VGND VPWR VPWR sky130_fd_sc_hd__decap_6
XFILLER_185_1301 VPWR VGND VPWR VGND sky130_ef_sc_hd__decap_12
XFILLER_150_1282 VPWR VGND VPWR VGND sky130_ef_sc_hd__decap_12
XFILLER_111_1244 VPWR VGND VPWR VGND sky130_ef_sc_hd__decap_12
XFILLER_206_345 VPWR VGND VPWR VGND sky130_ef_sc_hd__decap_12
XFILLER_189_1481 VPWR VGND VPWR VGND sky130_ef_sc_hd__decap_12
XFILLER_185_1345 VPWR VGND VPWR VGND sky130_ef_sc_hd__decap_12
XTAP_TAPCELL_ROW_158_2_4004 VGND VPWR sky130_fd_sc_hd__tapvpwrvgnd_1
XFILLER_37_81 VPWR VGND VPWR VGND sky130_ef_sc_hd__decap_12
XFILLER_206_389 VPWR VGND VPWR VGND sky130_ef_sc_hd__decap_12
XFILLER_179_709 VPWR VGND VPWR VGND sky130_ef_sc_hd__decap_12
XFILLER_37_1602 VGND VGND VPWR VPWR sky130_fd_sc_hd__decap_3
XFILLER_187_753 VPWR VGND VPWR VGND sky130_ef_sc_hd__decap_12
XFILLER_72_1526 VPWR VGND VPWR VGND sky130_ef_sc_hd__decap_12
X_418_ _140_ _145_ _151_ _152_ _108_ VGND VGND VPWR VPWR _153_ sky130_fd_sc_hd__o311a_1
XTAP_TAPCELL_ROW_125_2_3789 VGND VPWR sky130_fd_sc_hd__tapvpwrvgnd_1
XTAP_TAPCELL_ROW_17_1_1052 VGND VPWR sky130_fd_sc_hd__tapvpwrvgnd_1
XFILLER_187_797 VPWR VGND VPWR VGND sky130_ef_sc_hd__decap_12
X_349_ net156 _095_ VGND VGND VPWR VPWR _011_ sky130_fd_sc_hd__and2_1
XFILLER_174_469 VGND VGND VPWR VPWR sky130_fd_sc_hd__decap_6
XFILLER_70_1294 VGND VGND VPWR VPWR sky130_fd_sc_hd__decap_6
XFILLER_31_1256 VPWR VGND VPWR VGND sky130_ef_sc_hd__decap_12
XFILLER_196_1441 VPWR VGND VPWR VGND sky130_ef_sc_hd__decap_12
XFILLER_196_1485 VPWR VGND VPWR VGND sky130_ef_sc_hd__decap_12
XFILLER_5_181 VGND VGND VPWR VPWR sky130_fd_sc_hd__decap_4
XFILLER_6_693 VGND VGND VPWR VPWR sky130_fd_sc_hd__decap_6
XPHY_EDGE_ROW_24_2_Right_81 VGND VGND VPWR VPWR sky130_fd_sc_hd__decap_3
XTAP_TAPCELL_ROW_105_1_1228 VGND VPWR sky130_fd_sc_hd__tapvpwrvgnd_1
XTAP_TAPCELL_ROW_73_2_3454 VGND VPWR sky130_fd_sc_hd__tapvpwrvgnd_1
XFILLER_190_1073 VPWR VGND VPWR VGND sky130_ef_sc_hd__decap_12
XFILLER_9_1268 VGND VGND VPWR VPWR sky130_fd_sc_hd__decap_4
XPHY_EDGE_ROW_27_2_Left_459 VGND VGND VPWR VPWR sky130_fd_sc_hd__decap_3
XFILLER_216_109 VPWR VGND VPWR VGND sky130_ef_sc_hd__decap_12
XFILLER_209_161 VGND VGND VPWR VPWR sky130_fd_sc_hd__decap_6
XFILLER_204_53 VPWR VGND VPWR VGND sky130_ef_sc_hd__decap_12
XFILLER_83_125 VGND VGND VPWR VPWR sky130_fd_sc_hd__fill_2
XTAP_TAPCELL_ROW_72_1_1162 VGND VPWR sky130_fd_sc_hd__tapvpwrvgnd_1
XTAP_TAPCELL_ROW_0_803 VGND VPWR sky130_fd_sc_hd__tapvpwrvgnd_1
XFILLER_204_97 VPWR VGND VPWR VGND sky130_ef_sc_hd__decap_12
XFILLER_168_1521 VPWR VGND VPWR VGND sky130_ef_sc_hd__decap_12
XFILLER_168_1565 VPWR VGND VPWR VGND sky130_ef_sc_hd__decap_12
XFILLER_197_517 VPWR VGND VPWR VGND sky130_ef_sc_hd__decap_12
XFILLER_164_1429 VPWR VGND VPWR VGND sky130_ef_sc_hd__decap_12
XTAP_TAPCELL_ROW_160_1_1338 VGND VPWR sky130_fd_sc_hd__tapvpwrvgnd_1
XPHY_EDGE_ROW_89_2_Left_521 VGND VGND VPWR VPWR sky130_fd_sc_hd__decap_3
XFILLER_33_39 VPWR VGND VPWR VGND sky130_ef_sc_hd__decap_12
XFILLER_205_1437 VPWR VGND VPWR VGND sky130_ef_sc_hd__decap_12
XFILLER_149_39 VPWR VGND VPWR VGND sky130_ef_sc_hd__decap_12
XTAP_TAPCELL_ROW_14_2_3069 VGND VPWR sky130_fd_sc_hd__tapvpwrvgnd_1
XFILLER_166_937 VPWR VGND VPWR VGND sky130_ef_sc_hd__decap_12
XPHY_EDGE_ROW_141_2_Left_573 VGND VGND VPWR VPWR sky130_fd_sc_hd__decap_3
XFILLER_137_105 VGND VGND VPWR VPWR sky130_fd_sc_hd__decap_6
XFILLER_192_233 VPWR VGND VPWR VGND sky130_ef_sc_hd__decap_12
XFILLER_165_447 VGND VGND VPWR VPWR sky130_fd_sc_hd__fill_1
XFILLER_140_1462 VGND VGND VPWR VPWR sky130_fd_sc_hd__decap_6
XFILLER_192_277 VPWR VGND VPWR VGND sky130_ef_sc_hd__decap_12
XFILLER_174_981 VPWR VGND VPWR VGND sky130_ef_sc_hd__decap_12
XFILLER_165_27 VPWR VGND VPWR VGND sky130_ef_sc_hd__decap_12
XFILLER_175_1525 VPWR VGND VPWR VGND sky130_ef_sc_hd__decap_12
XFILLER_175_1569 VPWR VGND VPWR VGND sky130_ef_sc_hd__decap_12
XFILLER_216_1533 VGND VGND VPWR VPWR sky130_fd_sc_hd__decap_6
XFILLER_181_15 VPWR VGND VPWR VGND sky130_ef_sc_hd__decap_12
XFILLER_47_1274 VPWR VGND VPWR VGND sky130_ef_sc_hd__decap_12
XFILLER_59_111 VGND VGND VPWR VPWR sky130_fd_sc_hd__fill_1
XFILLER_216_1577 VPWR VGND VPWR VGND sky130_ef_sc_hd__decap_12
XFILLER_134_1244 VGND VGND VPWR VPWR sky130_fd_sc_hd__fill_1
XFILLER_0_858 VGND VGND VPWR VPWR sky130_fd_sc_hd__decap_3
XFILLER_114_53 VPWR VGND VPWR VGND sky130_ef_sc_hd__decap_12
XFILLER_216_643 VGND VGND VPWR VPWR sky130_fd_sc_hd__fill_1
XFILLER_114_97 VPWR VGND VPWR VGND sky130_ef_sc_hd__decap_12
XFILLER_204_805 VGND VGND VPWR VPWR sky130_fd_sc_hd__decap_6
XFILLER_204_849 VPWR VGND VPWR VGND sky130_ef_sc_hd__decap_12
XFILLER_203_337 VPWR VGND VPWR VGND sky130_ef_sc_hd__decap_12
XFILLER_130_41 VPWR VGND VPWR VGND sky130_ef_sc_hd__decap_12
XFILLER_19_1310 VPWR VGND VPWR VGND sky130_ef_sc_hd__decap_12
XFILLER_58_1370 VPWR VGND VPWR VGND sky130_ef_sc_hd__decap_12
XFILLER_208_1061 VPWR VGND VPWR VGND sky130_ef_sc_hd__decap_12
XFILLER_169_753 VPWR VGND VPWR VGND sky130_ef_sc_hd__decap_12
XFILLER_130_85 VPWR VGND VPWR VGND sky130_ef_sc_hd__decap_12
XTAP_TAPCELL_ROW_111_2_3697 VGND VPWR sky130_fd_sc_hd__tapvpwrvgnd_1
XFILLER_106_1302 VPWR VGND VPWR VGND sky130_ef_sc_hd__decap_12
XFILLER_93_1272 VGND VGND VPWR VPWR sky130_fd_sc_hd__fill_1
XANTENNA__547__A1 net151 VGND VGND VPWR VPWR sky130_fd_sc_hd__diode_2
XFILLER_19_1354 VPWR VGND VPWR VGND sky130_ef_sc_hd__decap_12
XFILLER_212_893 VPWR VGND VPWR VGND sky130_ef_sc_hd__decap_12
XFILLER_184_701 VPWR VGND VPWR VGND sky130_ef_sc_hd__decap_12
XFILLER_180_1253 VGND VGND VPWR VPWR sky130_fd_sc_hd__decap_6
XFILLER_145_1384 VGND VGND VPWR VPWR sky130_fd_sc_hd__fill_1
XFILLER_180_1297 VPWR VGND VPWR VGND sky130_ef_sc_hd__decap_12
XFILLER_169_797 VPWR VGND VPWR VGND sky130_ef_sc_hd__decap_12
XFILLER_19_1398 VPWR VGND VPWR VGND sky130_ef_sc_hd__decap_12
XFILLER_171_417 VPWR VGND VPWR VGND sky130_ef_sc_hd__decap_12
XTAP_TAPCELL_ROW_58_2_3356 VGND VPWR sky130_fd_sc_hd__tapvpwrvgnd_1
XFILLER_180_973 VGND VGND VPWR VPWR sky130_fd_sc_hd__decap_6
XFILLER_174_1035 VGND VGND VPWR VPWR sky130_fd_sc_hd__fill_1
XFILLER_65_1330 VPWR VGND VPWR VGND sky130_ef_sc_hd__decap_12
XFILLER_215_1021 VPWR VGND VPWR VGND sky130_ef_sc_hd__decap_12
XFILLER_155_93 VPWR VGND VPWR VGND sky130_ef_sc_hd__decap_12
XFILLER_152_1300 VGND VGND VPWR VPWR sky130_fd_sc_hd__fill_1
XFILLER_3_685 VGND VGND VPWR VPWR sky130_fd_sc_hd__decap_3
XFILLER_26_1314 VPWR VGND VPWR VGND sky130_ef_sc_hd__decap_12
XFILLER_215_1065 VPWR VGND VPWR VGND sky130_ef_sc_hd__decap_12
XFILLER_191_1393 VGND VGND VPWR VPWR sky130_fd_sc_hd__decap_6
XFILLER_117_1442 VPWR VGND VPWR VGND sky130_ef_sc_hd__decap_12
XFILLER_26_1358 VPWR VGND VPWR VGND sky130_ef_sc_hd__decap_12
XFILLER_113_1328 VGND VGND VPWR VPWR sky130_fd_sc_hd__fill_1
XTAP_TAPCELL_ROW_7_980 VGND VPWR sky130_fd_sc_hd__tapvpwrvgnd_1
XTAP_TAPCELL_ROW_7_991 VGND VPWR sky130_fd_sc_hd__tapvpwrvgnd_1
XFILLER_171_81 VPWR VGND VPWR VGND sky130_ef_sc_hd__decap_12
XFILLER_65_125 VGND VGND VPWR VPWR sky130_fd_sc_hd__fill_2
XPHY_EDGE_ROW_137_1_Left_356 VGND VGND VPWR VPWR sky130_fd_sc_hd__decap_3
XFILLER_207_665 VGND VGND VPWR VPWR sky130_fd_sc_hd__decap_6
XFILLER_206_153 VPWR VGND VPWR VGND sky130_ef_sc_hd__decap_12
XFILLER_206_197 VPWR VGND VPWR VGND sky130_ef_sc_hd__decap_12
XFILLER_185_1175 VGND VGND VPWR VPWR sky130_fd_sc_hd__fill_1
XFILLER_179_517 VPWR VGND VPWR VGND sky130_ef_sc_hd__decap_12
XFILLER_37_1410 VPWR VGND VPWR VGND sky130_ef_sc_hd__decap_12
XFILLER_76_1470 VPWR VGND VPWR VGND sky130_ef_sc_hd__decap_12
XFILLER_187_561 VPWR VGND VPWR VGND sky130_ef_sc_hd__decap_12
XFILLER_128_1582 VPWR VGND VPWR VGND sky130_ef_sc_hd__decap_12
XFILLER_72_1356 VGND VGND VPWR VPWR sky130_fd_sc_hd__fill_1
XFILLER_37_1454 VPWR VGND VPWR VGND sky130_ef_sc_hd__decap_12
XTAP_TAPCELL_ROW_48_1_1113 VGND VPWR sky130_fd_sc_hd__tapvpwrvgnd_1
XFILLER_124_1468 VGND VGND VPWR VPWR sky130_fd_sc_hd__fill_1
XFILLER_119_105 VGND VGND VPWR VPWR sky130_fd_sc_hd__decap_6
XFILLER_9_96 VGND VGND VPWR VPWR sky130_fd_sc_hd__decap_3
XFILLER_37_1498 VPWR VGND VPWR VGND sky130_ef_sc_hd__decap_12
XFILLER_174_233 VPWR VGND VPWR VGND sky130_ef_sc_hd__decap_12
XFILLER_190_737 VPWR VGND VPWR VGND sky130_ef_sc_hd__decap_12
XFILLER_174_277 VPWR VGND VPWR VGND sky130_ef_sc_hd__decap_12
XTAP_TAPCELL_ROW_155_2_3984 VGND VPWR sky130_fd_sc_hd__tapvpwrvgnd_1
XFILLER_171_951 VGND VGND VPWR VPWR sky130_fd_sc_hd__fill_1
XFILLER_157_1244 VPWR VGND VPWR VGND sky130_ef_sc_hd__decap_12
XFILLER_44_1414 VPWR VGND VPWR VGND sky130_ef_sc_hd__decap_12
XFILLER_48_1550 VPWR VGND VPWR VGND sky130_ef_sc_hd__decap_12
XFILLER_83_1496 VGND VGND VPWR VPWR sky130_fd_sc_hd__fill_1
XTAP_TAPCELL_ROW_5_928 VGND VPWR sky130_fd_sc_hd__tapvpwrvgnd_1
XTAP_TAPCELL_ROW_5_939 VGND VPWR sky130_fd_sc_hd__tapvpwrvgnd_1
XFILLER_48_1594 VGND VGND VPWR VPWR sky130_fd_sc_hd__decap_8
XFILLER_170_1477 VGND VGND VPWR VPWR sky130_fd_sc_hd__decap_6
XANTENNA__630__CLK clknet_3_3_0_clk VGND VGND VPWR VPWR sky130_fd_sc_hd__diode_2
XFILLER_217_429 VPWR VGND VPWR VGND sky130_ef_sc_hd__decap_12
XPHY_EDGE_ROW_69_1_Left_288 VGND VGND VPWR VPWR sky130_fd_sc_hd__decap_3
XFILLER_198_837 VPWR VGND VPWR VGND sky130_ef_sc_hd__decap_12
XFILLER_168_1373 VPWR VGND VPWR VGND sky130_ef_sc_hd__decap_12
XFILLER_77_1256 VPWR VGND VPWR VGND sky130_ef_sc_hd__decap_12
XFILLER_0_1541 VPWR VGND VPWR VGND sky130_ef_sc_hd__decap_12
XFILLER_44_27 VGND VGND VPWR VPWR sky130_fd_sc_hd__fill_1
XFILLER_205_1201 VPWR VGND VPWR VGND sky130_ef_sc_hd__decap_12
XFILLER_164_1259 VGND VGND VPWR VPWR sky130_fd_sc_hd__fill_1
XFILLER_90_1412 VGND VGND VPWR VPWR sky130_fd_sc_hd__fill_1
XANTENNA__529__A1 net149 VGND VGND VPWR VPWR sky130_fd_sc_hd__diode_2
XFILLER_55_1510 VPWR VGND VPWR VGND sky130_ef_sc_hd__decap_12
XFILLER_212_189 VGND VGND VPWR VPWR sky130_fd_sc_hd__decap_6
XFILLER_209_1381 VPWR VGND VPWR VGND sky130_ef_sc_hd__decap_12
XFILLER_200_307 VGND VGND VPWR VPWR sky130_fd_sc_hd__fill_1
XTAP_TAPCELL_ROW_195_2286 VGND VPWR sky130_fd_sc_hd__tapvpwrvgnd_1
XFILLER_166_701 VPWR VGND VPWR VGND sky130_ef_sc_hd__decap_12
XFILLER_142_1524 VGND VGND VPWR VPWR sky130_fd_sc_hd__fill_1
XFILLER_55_1554 VPWR VGND VPWR VGND sky130_ef_sc_hd__decap_12
XFILLER_205_1245 VPWR VGND VPWR VGND sky130_ef_sc_hd__decap_12
XTAP_TAPCELL_ROW_195_2297 VGND VPWR sky130_fd_sc_hd__tapvpwrvgnd_1
XFILLER_100_77 VGND VGND VPWR VPWR sky130_fd_sc_hd__decap_6
XFILLER_16_1538 VPWR VGND VPWR VGND sky130_ef_sc_hd__decap_12
XFILLER_60_15 VPWR VGND VPWR VGND sky130_ef_sc_hd__decap_12
XFILLER_205_1289 VPWR VGND VPWR VGND sky130_ef_sc_hd__decap_12
XFILLER_193_553 VGND VGND VPWR VPWR sky130_fd_sc_hd__decap_6
XFILLER_176_15 VPWR VGND VPWR VGND sky130_ef_sc_hd__decap_12
XFILLER_197_1057 VGND VGND VPWR VPWR sky130_fd_sc_hd__decap_6
XFILLER_193_597 VPWR VGND VPWR VGND sky130_ef_sc_hd__decap_12
XFILLER_140_1270 VPWR VGND VPWR VGND sky130_ef_sc_hd__decap_12
XFILLER_101_1232 VPWR VGND VPWR VGND sky130_ef_sc_hd__decap_12
XFILLER_4_416 VGND VGND VPWR VPWR sky130_fd_sc_hd__fill_2
XTAP_TAPCELL_ROW_44_2_3264 VGND VPWR sky130_fd_sc_hd__tapvpwrvgnd_1
XFILLER_4_438 VGND VGND VPWR VPWR sky130_fd_sc_hd__fill_1
XFILLER_101_1298 VPWR VGND VPWR VGND sky130_ef_sc_hd__decap_12
XFILLER_69_57 VPWR VGND VPWR VGND sky130_ef_sc_hd__decap_12
XFILLER_175_1399 VGND VGND VPWR VPWR sky130_fd_sc_hd__fill_1
XFILLER_0_622 VGND VGND VPWR VPWR sky130_fd_sc_hd__fill_1
XFILLER_216_1341 VPWR VGND VPWR VGND sky130_ef_sc_hd__decap_12
XFILLER_212_1205 VPWR VGND VPWR VGND sky130_ef_sc_hd__decap_12
XFILLER_0_633 VGND VGND VPWR VPWR sky130_fd_sc_hd__decap_4
XFILLER_0_655 VGND VGND VPWR VPWR sky130_fd_sc_hd__fill_1
XFILLER_216_1385 VPWR VGND VPWR VGND sky130_ef_sc_hd__decap_12
XFILLER_47_125 VGND VGND VPWR VPWR sky130_fd_sc_hd__fill_2
XTAP_TAPCELL_ROW_184_1990 VGND VPWR sky130_fd_sc_hd__tapvpwrvgnd_1
XFILLER_112_1350 VGND VGND VPWR VPWR sky130_fd_sc_hd__decap_6
XFILLER_21_1244 VPWR VGND VPWR VGND sky130_ef_sc_hd__decap_12
XFILLER_60_1282 VPWR VGND VPWR VGND sky130_ef_sc_hd__decap_12
XTAP_TAPCELL_ROW_180_1876 VGND VPWR sky130_fd_sc_hd__tapvpwrvgnd_1
XTAP_TAPCELL_ROW_180_1865 VGND VPWR sky130_fd_sc_hd__tapvpwrvgnd_1
XFILLER_141_51 VGND VGND VPWR VPWR sky130_fd_sc_hd__decap_4
XFILLER_112_1394 VPWR VGND VPWR VGND sky130_ef_sc_hd__decap_12
XFILLER_204_613 VPWR VGND VPWR VGND sky130_ef_sc_hd__decap_12
XFILLER_182_1315 VGND VGND VPWR VPWR sky130_fd_sc_hd__fill_1
XFILLER_95_1378 VGND VGND VPWR VPWR sky130_fd_sc_hd__decap_6
XFILLER_204_657 VPWR VGND VPWR VGND sky130_ef_sc_hd__decap_12
XFILLER_203_167 VGND VGND VPWR VPWR sky130_fd_sc_hd__fill_1
XFILLER_169_561 VPWR VGND VPWR VGND sky130_ef_sc_hd__decap_12
XFILLER_160_1602 VGND VGND VPWR VPWR sky130_fd_sc_hd__decap_3
XTAP_TAPCELL_ROW_129_1_1276 VGND VPWR sky130_fd_sc_hd__tapvpwrvgnd_1
XFILLER_34_71 VPWR VGND VPWR VGND sky130_ef_sc_hd__decap_12
XFILLER_180_1061 VPWR VGND VPWR VGND sky130_ef_sc_hd__decap_12
XFILLER_184_531 VGND VGND VPWR VPWR sky130_fd_sc_hd__fill_1
XTAP_TAPCELL_ROW_141_2_3892 VGND VPWR sky130_fd_sc_hd__tapvpwrvgnd_1
XFILLER_172_737 VPWR VGND VPWR VGND sky130_ef_sc_hd__decap_12
XFILLER_123_1490 VGND VGND VPWR VPWR sky130_fd_sc_hd__decap_6
XFILLER_171_225 VPWR VGND VPWR VGND sky130_ef_sc_hd__decap_12
XFILLER_7_276 VGND VGND VPWR VPWR sky130_fd_sc_hd__decap_4
XFILLER_193_1455 VGND VGND VPWR VPWR sky130_fd_sc_hd__fill_1
XFILLER_154_1406 VGND VGND VPWR VPWR sky130_fd_sc_hd__decap_6
XFILLER_180_781 VPWR VGND VPWR VGND sky130_ef_sc_hd__decap_12
XTAP_TAPCELL_ROW_88_2_3551 VGND VPWR sky130_fd_sc_hd__tapvpwrvgnd_1
XFILLER_117_1272 VGND VGND VPWR VPWR sky130_fd_sc_hd__fill_1
XFILLER_6_1205 VPWR VGND VPWR VGND sky130_ef_sc_hd__decap_12
XFILLER_15_3 VPWR VGND VPWR VGND sky130_ef_sc_hd__decap_12
XFILLER_130_1450 VPWR VGND VPWR VGND sky130_ef_sc_hd__decap_12
XFILLER_130_1494 VPWR VGND VPWR VGND sky130_ef_sc_hd__decap_12
XTAP_TAPCELL_ROW_81_2_3505 VGND VPWR sky130_fd_sc_hd__tapvpwrvgnd_1
XFILLER_207_473 VPWR VGND VPWR VGND sky130_ef_sc_hd__decap_12
XFILLER_165_1513 VPWR VGND VPWR VGND sky130_ef_sc_hd__decap_12
XFILLER_206_1521 VPWR VGND VPWR VGND sky130_ef_sc_hd__decap_12
XFILLER_206_1565 VPWR VGND VPWR VGND sky130_ef_sc_hd__decap_12
XFILLER_188_881 VPWR VGND VPWR VGND sky130_ef_sc_hd__decap_12
XFILLER_124_1232 VPWR VGND VPWR VGND sky130_ef_sc_hd__decap_12
XFILLER_202_1429 VPWR VGND VPWR VGND sky130_ef_sc_hd__decap_12
XFILLER_187_391 VGND VGND VPWR VPWR sky130_fd_sc_hd__fill_1
XFILLER_175_553 VGND VGND VPWR VPWR sky130_fd_sc_hd__decap_6
XTAP_TAPCELL_ROW_29_2_3166 VGND VPWR sky130_fd_sc_hd__tapvpwrvgnd_1
XTAP_TAPCELL_ROW_30_2_3172 VGND VPWR sky130_fd_sc_hd__tapvpwrvgnd_1
XTAP_TAPCELL_ROW_190_2161 VGND VPWR sky130_fd_sc_hd__tapvpwrvgnd_1
XTAP_TAPCELL_ROW_190_2150 VGND VPWR sky130_fd_sc_hd__tapvpwrvgnd_1
XFILLER_190_501 VPWR VGND VPWR VGND sky130_ef_sc_hd__decap_12
XFILLER_141_1590 VPWR VGND VPWR VGND sky130_ef_sc_hd__decap_12
XFILLER_50_1462 VGND VGND VPWR VPWR sky130_fd_sc_hd__decap_6
XFILLER_190_545 VPWR VGND VPWR VGND sky130_ef_sc_hd__decap_12
XFILLER_175_597 VPWR VGND VPWR VGND sky130_ef_sc_hd__decap_12
XFILLER_159_1328 VGND VGND VPWR VPWR sky130_fd_sc_hd__fill_1
XFILLER_146_29 VPWR VGND VPWR VGND sky130_ef_sc_hd__decap_12
XFILLER_102_1574 VGND VGND VPWR VPWR sky130_fd_sc_hd__decap_6
XTAP_TAPCELL_ROW_211_2754 VGND VPWR sky130_fd_sc_hd__tapvpwrvgnd_1
XTAP_TAPCELL_ROW_211_2743 VGND VPWR sky130_fd_sc_hd__tapvpwrvgnd_1
XFILLER_200_1197 VGND VGND VPWR VPWR sky130_fd_sc_hd__decap_6
XFILLER_190_589 VPWR VGND VPWR VGND sky130_ef_sc_hd__decap_12
XTAP_TAPCELL_ROW_211_2765 VGND VPWR sky130_fd_sc_hd__tapvpwrvgnd_1
XTAP_TAPCELL_ROW_188_2090 VGND VPWR sky130_fd_sc_hd__tapvpwrvgnd_1
XFILLER_172_1539 VGND VGND VPWR VPWR sky130_fd_sc_hd__fill_1
XFILLER_39_27 VPWR VGND VPWR VGND sky130_ef_sc_hd__decap_12
XFILLER_213_1525 VPWR VGND VPWR VGND sky130_ef_sc_hd__decap_12
XFILLER_170_1241 VPWR VGND VPWR VGND sky130_ef_sc_hd__decap_12
XFILLER_44_1244 VGND VGND VPWR VPWR sky130_fd_sc_hd__fill_1
XFILLER_213_1569 VPWR VGND VPWR VGND sky130_ef_sc_hd__decap_12
XFILLER_170_1285 VPWR VGND VPWR VGND sky130_ef_sc_hd__decap_12
XFILLER_29_125 VGND VGND VPWR VPWR sky130_fd_sc_hd__fill_2
XFILLER_218_749 VGND VGND VPWR VPWR sky130_fd_sc_hd__decap_6
XFILLER_217_237 VPWR VGND VPWR VGND sky130_ef_sc_hd__decap_12
XTAP_TAPCELL_ROW_209_2694 VGND VPWR sky130_fd_sc_hd__tapvpwrvgnd_1
XTAP_TAPCELL_ROW_209_2683 VGND VPWR sky130_fd_sc_hd__tapvpwrvgnd_1
XTAP_TAPCELL_ROW_205_2569 VGND VPWR sky130_fd_sc_hd__tapvpwrvgnd_1
XTAP_TAPCELL_ROW_40_1_1097 VGND VPWR sky130_fd_sc_hd__tapvpwrvgnd_1
XFILLER_198_601 VPWR VGND VPWR VGND sky130_ef_sc_hd__decap_12
XFILLER_198_645 VPWR VGND VPWR VGND sky130_ef_sc_hd__decap_12
XTAP_TAPCELL_ROW_197_2359 VGND VPWR sky130_fd_sc_hd__tapvpwrvgnd_1
XTAP_TAPCELL_ROW_197_2348 VGND VPWR sky130_fd_sc_hd__tapvpwrvgnd_1
XFILLER_197_111 VGND VGND VPWR VPWR sky130_fd_sc_hd__fill_1
XFILLER_92_1518 VGND VGND VPWR VPWR sky130_fd_sc_hd__decap_6
XFILLER_90_1220 VPWR VGND VPWR VGND sky130_ef_sc_hd__decap_12
XFILLER_16_1302 VPWR VGND VPWR VGND sky130_ef_sc_hd__decap_12
XFILLER_199_1119 VGND VGND VPWR VPWR sky130_fd_sc_hd__fill_1
XFILLER_185_317 VPWR VGND VPWR VGND sky130_ef_sc_hd__decap_12
XFILLER_181_1381 VPWR VGND VPWR VGND sky130_ef_sc_hd__decap_12
XTAP_TAPCELL_ROW_126_2_3794 VGND VPWR sky130_fd_sc_hd__tapvpwrvgnd_1
XPHY_EDGE_ROW_80_2_Right_137 VGND VGND VPWR VPWR sky130_fd_sc_hd__decap_3
XFILLER_71_69 VPWR VGND VPWR VGND sky130_ef_sc_hd__decap_12
XFILLER_55_1384 VGND VGND VPWR VPWR sky130_fd_sc_hd__fill_1
XFILLER_187_69 VPWR VGND VPWR VGND sky130_ef_sc_hd__decap_12
XFILLER_166_531 VGND VGND VPWR VPWR sky130_fd_sc_hd__fill_1
XFILLER_217_3 VPWR VGND VPWR VGND sky130_ef_sc_hd__decap_12
XFILLER_193_361 VPWR VGND VPWR VGND sky130_ef_sc_hd__decap_12
XFILLER_107_1496 VGND VGND VPWR VPWR sky130_fd_sc_hd__fill_1
XTAP_TAPCELL_ROW_173_1680 VGND VPWR sky130_fd_sc_hd__tapvpwrvgnd_1
XTAP_TAPCELL_ROW_106_2_3670 VGND VPWR sky130_fd_sc_hd__tapvpwrvgnd_1
XFILLER_5_725 VGND VGND VPWR VPWR sky130_fd_sc_hd__decap_3
XPHY_EDGE_ROW_104_2_Left_536 VGND VGND VPWR VPWR sky130_fd_sc_hd__decap_3
XFILLER_121_111 VGND VGND VPWR VPWR sky130_fd_sc_hd__fill_1
XFILLER_1_953 VPWR VGND VPWR VGND sky130_ef_sc_hd__decap_12
XFILLER_62_1300 VGND VGND VPWR VPWR sky130_fd_sc_hd__fill_1
XFILLER_114_1412 VGND VGND VPWR VPWR sky130_fd_sc_hd__fill_1
XFILLER_96_77 VGND VGND VPWR VPWR sky130_fd_sc_hd__decap_6
XFILLER_7_1525 VPWR VGND VPWR VGND sky130_ef_sc_hd__decap_12
XFILLER_27_1442 VPWR VGND VPWR VGND sky130_ef_sc_hd__decap_12
XFILLER_212_1035 VGND VGND VPWR VPWR sky130_fd_sc_hd__fill_1
XFILLER_209_727 VGND VGND VPWR VPWR sky130_fd_sc_hd__fill_1
XTAP_TAPCELL_ROW_182_1927 VGND VPWR sky130_fd_sc_hd__tapvpwrvgnd_1
XTAP_TAPCELL_ROW_182_1916 VGND VPWR sky130_fd_sc_hd__tapvpwrvgnd_1
XFILLER_7_1569 VPWR VGND VPWR VGND sky130_ef_sc_hd__decap_12
XFILLER_23_1328 VGND VGND VPWR VPWR sky130_fd_sc_hd__fill_1
XTAP_TAPCELL_ROW_182_1938 VGND VPWR sky130_fd_sc_hd__tapvpwrvgnd_1
XTAP_TAPCELL_ROW_167_1495 VGND VPWR sky130_fd_sc_hd__tapvpwrvgnd_1
XTAP_TAPCELL_ROW_66_2_3407 VGND VPWR sky130_fd_sc_hd__tapvpwrvgnd_1
XTAP_TAPCELL_ROW_163_1359 VGND VPWR sky130_fd_sc_hd__tapvpwrvgnd_1
XTAP_TAPCELL_ROW_163_1348 VGND VPWR sky130_fd_sc_hd__tapvpwrvgnd_1
XFILLER_152_83 VGND VGND VPWR VPWR sky130_fd_sc_hd__fill_1
XFILLER_1_1113 VGND VGND VPWR VPWR sky130_fd_sc_hd__decap_6
XFILLER_205_933 VPWR VGND VPWR VGND sky130_ef_sc_hd__decap_12
XFILLER_1_1157 VPWR VGND VPWR VGND sky130_ef_sc_hd__decap_12
XFILLER_205_977 VPWR VGND VPWR VGND sky130_ef_sc_hd__decap_12
XFILLER_204_421 VPWR VGND VPWR VGND sky130_ef_sc_hd__decap_12
XFILLER_147_1232 VPWR VGND VPWR VGND sky130_ef_sc_hd__decap_12
X_597_ clknet_3_4_0_clk _031_ VGND VGND VPWR VPWR net84 sky130_fd_sc_hd__dfxtp_1
XFILLER_45_92 VPWR VGND VPWR VGND sky130_ef_sc_hd__decap_12
XFILLER_50_109 VPWR VGND VPWR VGND sky130_ef_sc_hd__decap_12
XFILLER_188_133 VGND VGND VPWR VPWR sky130_fd_sc_hd__decap_6
XFILLER_73_1440 VGND VGND VPWR VPWR sky130_fd_sc_hd__fill_1
XPHY_EDGE_ROW_33_2_Right_90 VGND VGND VPWR VPWR sky130_fd_sc_hd__decap_3
XFILLER_188_177 VPWR VGND VPWR VGND sky130_ef_sc_hd__decap_12
XFILLER_147_1298 VPWR VGND VPWR VGND sky130_ef_sc_hd__decap_12
XTAP_TAPCELL_ROW_15_2_3074 VGND VPWR sky130_fd_sc_hd__tapvpwrvgnd_1
XFILLER_38_1582 VPWR VGND VPWR VGND sky130_ef_sc_hd__decap_12
XFILLER_169_391 VGND VGND VPWR VPWR sky130_fd_sc_hd__fill_1
XFILLER_125_1552 VGND VGND VPWR VPWR sky130_fd_sc_hd__fill_1
XTAP_TAPCELL_ROW_65_1_1148 VGND VPWR sky130_fd_sc_hd__tapvpwrvgnd_1
XFILLER_34_1468 VGND VGND VPWR VPWR sky130_fd_sc_hd__fill_1
XFILLER_200_693 VGND VGND VPWR VPWR sky130_fd_sc_hd__decap_6
XFILLER_185_895 VGND VGND VPWR VPWR sky130_fd_sc_hd__fill_1
XFILLER_172_501 VPWR VGND VPWR VGND sky130_ef_sc_hd__decap_12
XFILLER_172_545 VPWR VGND VPWR VGND sky130_ef_sc_hd__decap_12
XPHY_EDGE_ROW_36_2_Left_468 VGND VGND VPWR VPWR sky130_fd_sc_hd__decap_3
XFILLER_158_1350 VGND VGND VPWR VPWR sky130_fd_sc_hd__decap_6
XFILLER_172_589 VPWR VGND VPWR VGND sky130_ef_sc_hd__decap_12
XFILLER_67_1244 VPWR VGND VPWR VGND sky130_ef_sc_hd__decap_12
XFILLER_158_1394 VPWR VGND VPWR VGND sky130_ef_sc_hd__decap_12
XFILLER_171_1561 VGND VGND VPWR VPWR sky130_fd_sc_hd__decap_6
XFILLER_154_1258 VPWR VGND VPWR VGND sky130_ef_sc_hd__decap_12
XFILLER_119_1378 VGND VGND VPWR VPWR sky130_fd_sc_hd__decap_6
XFILLER_84_1580 VGND VGND VPWR VPWR sky130_fd_sc_hd__fill_1
XPHY_EDGE_ROW_98_2_Left_530 VGND VGND VPWR VPWR sky130_fd_sc_hd__decap_3
XFILLER_6_1035 VGND VGND VPWR VPWR sky130_fd_sc_hd__fill_1
XFILLER_187_1001 VGND VGND VPWR VPWR sky130_fd_sc_hd__decap_6
XPHY_EDGE_ROW_150_2_Left_582 VGND VGND VPWR VPWR sky130_fd_sc_hd__decap_3
XTAP_TAPCELL_ROW_7_1030 VGND VPWR sky130_fd_sc_hd__tapvpwrvgnd_1
XFILLER_187_1045 VPWR VGND VPWR VGND sky130_ef_sc_hd__decap_12
XFILLER_212_53 VPWR VGND VPWR VGND sky130_ef_sc_hd__decap_12
XFILLER_208_793 VPWR VGND VPWR VGND sky130_ef_sc_hd__decap_12
XFILLER_187_1089 VPWR VGND VPWR VGND sky130_ef_sc_hd__decap_12
XFILLER_212_97 VPWR VGND VPWR VGND sky130_ef_sc_hd__decap_12
XFILLER_207_281 VPWR VGND VPWR VGND sky130_ef_sc_hd__decap_12
XTAP_TAPCELL_ROW_200_2444 VGND VPWR sky130_fd_sc_hd__tapvpwrvgnd_1
XTAP_TAPCELL_ROW_200_2433 VGND VPWR sky130_fd_sc_hd__tapvpwrvgnd_1
XFILLER_179_111 VGND VGND VPWR VPWR sky130_fd_sc_hd__fill_1
XFILLER_165_1343 VGND VGND VPWR VPWR sky130_fd_sc_hd__fill_1
XFILLER_210_413 VGND VGND VPWR VPWR sky130_fd_sc_hd__decap_6
XFILLER_195_615 VGND VGND VPWR VPWR sky130_fd_sc_hd__fill_1
XTAP_TAPCELL_ROW_192_2223 VGND VPWR sky130_fd_sc_hd__tapvpwrvgnd_1
XTAP_TAPCELL_ROW_192_2212 VGND VPWR sky130_fd_sc_hd__tapvpwrvgnd_1
XTAP_TAPCELL_ROW_192_2201 VGND VPWR sky130_fd_sc_hd__tapvpwrvgnd_1
XFILLER_167_317 VPWR VGND VPWR VGND sky130_ef_sc_hd__decap_12
XFILLER_126_1338 VPWR VGND VPWR VGND sky130_ef_sc_hd__decap_12
XFILLER_52_1524 VGND VGND VPWR VPWR sky130_fd_sc_hd__fill_1
XTAP_TAPCELL_ROW_217_2930 VGND VPWR sky130_fd_sc_hd__tapvpwrvgnd_1
XFILLER_210_457 VPWR VGND VPWR VGND sky130_ef_sc_hd__decap_12
XFILLER_206_1373 VPWR VGND VPWR VGND sky130_ef_sc_hd__decap_12
XFILLER_41_39 VPWR VGND VPWR VGND sky130_ef_sc_hd__decap_12
XTAP_TAPCELL_ROW_213_2816 VGND VPWR sky130_fd_sc_hd__tapvpwrvgnd_1
XTAP_TAPCELL_ROW_213_2805 VGND VPWR sky130_fd_sc_hd__tapvpwrvgnd_1
XFILLER_202_1259 VGND VGND VPWR VPWR sky130_fd_sc_hd__fill_1
XFILLER_198_1141 VGND VGND VPWR VPWR sky130_fd_sc_hd__decap_6
XFILLER_182_309 VPWR VGND VPWR VGND sky130_ef_sc_hd__decap_12
XFILLER_175_361 VPWR VGND VPWR VGND sky130_ef_sc_hd__decap_12
XFILLER_163_501 VGND VGND VPWR VPWR sky130_fd_sc_hd__decap_3
XFILLER_157_39 VPWR VGND VPWR VGND sky130_ef_sc_hd__decap_12
XFILLER_194_1005 VPWR VGND VPWR VGND sky130_ef_sc_hd__decap_12
XFILLER_191_821 VPWR VGND VPWR VGND sky130_ef_sc_hd__decap_12
XFILLER_163_545 VPWR VGND VPWR VGND sky130_ef_sc_hd__decap_12
XFILLER_11_1232 VPWR VGND VPWR VGND sky130_ef_sc_hd__decap_12
XFILLER_50_1270 VPWR VGND VPWR VGND sky130_ef_sc_hd__decap_12
XFILLER_198_1185 VPWR VGND VPWR VGND sky130_ef_sc_hd__decap_12
XFILLER_194_1049 VPWR VGND VPWR VGND sky130_ef_sc_hd__decap_12
XFILLER_191_865 VPWR VGND VPWR VGND sky130_ef_sc_hd__decap_12
XFILLER_102_1382 VPWR VGND VPWR VGND sky130_ef_sc_hd__decap_12
XFILLER_85_1322 VGND VGND VPWR VPWR sky130_fd_sc_hd__decap_6
XTAP_TAPCELL_ROW_59_2_3361 VGND VPWR sky130_fd_sc_hd__tapvpwrvgnd_1
XFILLER_163_589 VPWR VGND VPWR VGND sky130_ef_sc_hd__decap_12
XFILLER_11_1298 VPWR VGND VPWR VGND sky130_ef_sc_hd__decap_12
XTAP_TAPCELL_ROW_186_2049 VGND VPWR sky130_fd_sc_hd__tapvpwrvgnd_1
XTAP_TAPCELL_ROW_186_2038 VGND VPWR sky130_fd_sc_hd__tapvpwrvgnd_1
XTAP_TAPCELL_ROW_186_2027 VGND VPWR sky130_fd_sc_hd__tapvpwrvgnd_1
XFILLER_176_1483 VGND VGND VPWR VPWR sky130_fd_sc_hd__fill_1
XFILLER_173_27 VPWR VGND VPWR VGND sky130_ef_sc_hd__decap_12
XFILLER_137_1434 VGND VGND VPWR VPWR sky130_fd_sc_hd__decap_6
XFILLER_103_111 VGND VGND VPWR VPWR sky130_fd_sc_hd__fill_1
XFILLER_85_1366 VPWR VGND VPWR VGND sky130_ef_sc_hd__decap_12
XFILLER_1_238 VPWR VGND VPWR VGND sky130_ef_sc_hd__decap_12
XFILLER_137_1478 VPWR VGND VPWR VGND sky130_ef_sc_hd__decap_12
XFILLER_218_513 VPWR VGND VPWR VGND sky130_ef_sc_hd__decap_12
XFILLER_106_65 VPWR VGND VPWR VGND sky130_ef_sc_hd__decap_12
XTAP_TAPCELL_ROW_52_2_3315 VGND VPWR sky130_fd_sc_hd__tapvpwrvgnd_1
XFILLER_170_1093 VPWR VGND VPWR VGND sky130_ef_sc_hd__decap_12
XFILLER_218_557 VPWR VGND VPWR VGND sky130_ef_sc_hd__decap_12
XFILLER_213_1399 VGND VGND VPWR VPWR sky130_fd_sc_hd__fill_1
X_520_ net66 net123 VGND VGND VPWR VPWR _234_ sky130_fd_sc_hd__or2_1
XFILLER_22_1350 VGND VGND VPWR VPWR sky130_fd_sc_hd__decap_6
XFILLER_199_921 VPWR VGND VPWR VGND sky130_ef_sc_hd__decap_12
XFILLER_166_1129 VPWR VGND VPWR VGND sky130_ef_sc_hd__decap_12
XFILLER_122_53 VPWR VGND VPWR VGND sky130_ef_sc_hd__decap_12
XFILLER_22_1394 VPWR VGND VPWR VGND sky130_ef_sc_hd__decap_12
XFILLER_167_3 VPWR VGND VPWR VGND sky130_ef_sc_hd__decap_12
XFILLER_122_97 VPWR VGND VPWR VGND sky130_ef_sc_hd__decap_12
XFILLER_96_1462 VGND VGND VPWR VPWR sky130_fd_sc_hd__decap_6
XFILLER_92_1326 VPWR VGND VPWR VGND sky130_ef_sc_hd__decap_12
X_451_ net147 net119 VGND VGND VPWR VPWR _183_ sky130_fd_sc_hd__xnor2_1
XFILLER_2_1477 VGND VGND VPWR VPWR sky130_fd_sc_hd__decap_6
XFILLER_202_925 VPWR VGND VPWR VGND sky130_ef_sc_hd__decap_12
XFILLER_199_965 VPWR VGND VPWR VGND sky130_ef_sc_hd__decap_12
XFILLER_148_1574 VGND VGND VPWR VPWR sky130_fd_sc_hd__decap_6
X_382_ b_addr\[1\] _084_ _103_ VGND VGND VPWR VPWR _121_ sky130_fd_sc_hd__and3_1
XFILLER_213_273 VGND VGND VPWR VPWR sky130_fd_sc_hd__decap_6
XFILLER_198_475 VGND VGND VPWR VPWR sky130_fd_sc_hd__fill_1
XFILLER_186_637 VGND VGND VPWR VPWR sky130_fd_sc_hd__decap_6
XFILLER_144_1438 VPWR VGND VPWR VGND sky130_ef_sc_hd__decap_12
XFILLER_70_1602 VGND VGND VPWR VPWR sky130_fd_sc_hd__decap_3
XFILLER_15_51 VGND VGND VPWR VPWR sky130_fd_sc_hd__decap_4
XFILLER_185_125 VPWR VGND VPWR VGND sky130_ef_sc_hd__decap_12
XTAP_TAPCELL_ROW_175_1731 VGND VPWR sky130_fd_sc_hd__tapvpwrvgnd_1
XTAP_TAPCELL_ROW_175_1720 VGND VPWR sky130_fd_sc_hd__tapvpwrvgnd_1
XFILLER_185_169 VPWR VGND VPWR VGND sky130_ef_sc_hd__decap_12
XTAP_TAPCELL_ROW_171_1606 VGND VPWR sky130_fd_sc_hd__tapvpwrvgnd_1
XPHY_EDGE_ROW_81_2_Right_138 VGND VGND VPWR VPWR sky130_fd_sc_hd__decap_3
XFILLER_194_681 VPWR VGND VPWR VGND sky130_ef_sc_hd__decap_12
XFILLER_177_1225 VGND VGND VPWR VPWR sky130_fd_sc_hd__decap_6
XTAP_TAPCELL_ROW_171_1617 VGND VPWR sky130_fd_sc_hd__tapvpwrvgnd_1
XFILLER_167_895 VGND VGND VPWR VPWR sky130_fd_sc_hd__fill_1
XFILLER_5_511 VGND VGND VPWR VPWR sky130_fd_sc_hd__fill_2
XFILLER_33_1490 VGND VGND VPWR VPWR sky130_fd_sc_hd__decap_6
XPHY_EDGE_ROW_146_1_Left_365 VGND VGND VPWR VPWR sky130_fd_sc_hd__decap_3
XFILLER_5_533 VGND VGND VPWR VPWR sky130_fd_sc_hd__decap_6
Xclkbuf_3_3_0_clk clknet_0_clk VGND VGND VPWR VPWR clknet_3_3_0_clk sky130_fd_sc_hd__clkbuf_8
XFILLER_177_1269 VPWR VGND VPWR VGND sky130_ef_sc_hd__decap_12
XFILLER_120_1482 VPWR VGND VPWR VGND sky130_ef_sc_hd__decap_12
XFILLER_64_1406 VGND VGND VPWR VPWR sky130_fd_sc_hd__decap_6
XFILLER_155_1534 VPWR VGND VPWR VGND sky130_ef_sc_hd__decap_12
Xoutput50 net50 VGND VGND VPWR VPWR bist_fail_addr[1] sky130_fd_sc_hd__buf_2
Xoutput61 net61 VGND VGND VPWR VPWR bist_fail_bits[13] sky130_fd_sc_hd__buf_2
XTAP_TAPCELL_ROW_169_1557 VGND VPWR sky130_fd_sc_hd__tapvpwrvgnd_1
XTAP_TAPCELL_ROW_169_1546 VGND VPWR sky130_fd_sc_hd__tapvpwrvgnd_1
XFILLER_155_1578 VPWR VGND VPWR VGND sky130_ef_sc_hd__decap_12
XTAP_TAPCELL_ROW_148_2_3937 VGND VPWR sky130_fd_sc_hd__tapvpwrvgnd_1
XFILLER_116_1518 VGND VGND VPWR VPWR sky130_fd_sc_hd__decap_6
XPHY_EDGE_ROW_83_1_Left_302 VGND VGND VPWR VPWR sky130_fd_sc_hd__decap_3
Xoutput72 net72 VGND VGND VPWR VPWR bist_fail_bits[23] sky130_fd_sc_hd__buf_2
Xoutput83 net83 VGND VGND VPWR VPWR bist_fail_bits[4] sky130_fd_sc_hd__buf_2
Xoutput94 net94 VGND VGND VPWR VPWR func_rdata[14] sky130_fd_sc_hd__buf_2
XTAP_TAPCELL_ROW_169_1568 VGND VPWR sky130_fd_sc_hd__tapvpwrvgnd_1
XFILLER_114_1220 VPWR VGND VPWR VGND sky130_ef_sc_hd__decap_12
XFILLER_1_794 VGND VGND VPWR VPWR sky130_fd_sc_hd__decap_4
XFILLER_1_783 VGND VGND VPWR VPWR sky130_fd_sc_hd__fill_1
XFILLER_27_1272 VGND VGND VPWR VPWR sky130_fd_sc_hd__fill_1
XFILLER_0_293 VGND VGND VPWR VPWR sky130_fd_sc_hd__fill_1
XTAP_TAPCELL_ROW_128_2_3813 VGND VPWR sky130_fd_sc_hd__tapvpwrvgnd_1
XFILLER_40_1450 VPWR VGND VPWR VGND sky130_ef_sc_hd__decap_12
XFILLER_188_1365 VGND VGND VPWR VPWR sky130_fd_sc_hd__decap_6
XFILLER_40_1494 VPWR VGND VPWR VGND sky130_ef_sc_hd__decap_12
XFILLER_205_741 VPWR VGND VPWR VGND sky130_ef_sc_hd__decap_12
XFILLER_184_1229 VPWR VGND VPWR VGND sky130_ef_sc_hd__decap_12
XTAP_TAPCELL_ROW_96_2_3602 VGND VPWR sky130_fd_sc_hd__tapvpwrvgnd_1
XFILLER_205_785 VPWR VGND VPWR VGND sky130_ef_sc_hd__decap_12
XFILLER_204_251 VGND VGND VPWR VPWR sky130_fd_sc_hd__fill_1
XFILLER_75_1546 VGND VGND VPWR VPWR sky130_fd_sc_hd__decap_6
XFILLER_189_497 VGND VGND VPWR VPWR sky130_fd_sc_hd__decap_6
XFILLER_177_615 VGND VGND VPWR VPWR sky130_fd_sc_hd__fill_1
XFILLER_162_1538 VPWR VGND VPWR VGND sky130_ef_sc_hd__decap_12
XFILLER_203_1513 VPWR VGND VPWR VGND sky130_ef_sc_hd__decap_12
XTAP_TAPCELL_ROW_96_1_1209 VGND VPWR sky130_fd_sc_hd__tapvpwrvgnd_1
XFILLER_82_3 VPWR VGND VPWR VGND sky130_ef_sc_hd__decap_12
XFILLER_34_1232 VPWR VGND VPWR VGND sky130_ef_sc_hd__decap_12
XFILLER_164_309 VPWR VGND VPWR VGND sky130_ef_sc_hd__decap_12
XFILLER_173_821 VPWR VGND VPWR VGND sky130_ef_sc_hd__decap_12
XPHY_EDGE_ROW_78_1_Left_297 VGND VGND VPWR VPWR sky130_fd_sc_hd__decap_3
XFILLER_201_1281 VGND VGND VPWR VPWR sky130_fd_sc_hd__decap_6
XFILLER_195_1325 VPWR VGND VPWR VGND sky130_ef_sc_hd__decap_12
XFILLER_173_865 VPWR VGND VPWR VGND sky130_ef_sc_hd__decap_12
XFILLER_121_1268 VGND VGND VPWR VPWR sky130_fd_sc_hd__decap_4
XFILLER_69_1328 VGND VGND VPWR VPWR sky130_fd_sc_hd__fill_1
XFILLER_12_1574 VGND VGND VPWR VPWR sky130_fd_sc_hd__decap_6
XFILLER_51_1590 VPWR VGND VPWR VGND sky130_ef_sc_hd__decap_12
XFILLER_195_1369 VPWR VGND VPWR VGND sky130_ef_sc_hd__decap_12
XFILLER_82_1506 VPWR VGND VPWR VGND sky130_ef_sc_hd__decap_12
XPHY_EDGE_ROW_43_2_Right_100 VGND VGND VPWR VPWR sky130_fd_sc_hd__decap_3
XTAP_TAPCELL_ROW_37_2_3217 VGND VPWR sky130_fd_sc_hd__tapvpwrvgnd_1
XTAP_TAPCELL_ROW_206_2620 VGND VPWR sky130_fd_sc_hd__tapvpwrvgnd_1
XFILLER_210_1539 VGND VGND VPWR VPWR sky130_fd_sc_hd__fill_1
XFILLER_215_505 VPWR VGND VPWR VGND sky130_ef_sc_hd__decap_12
XTAP_TAPCELL_ROW_202_2506 VGND VPWR sky130_fd_sc_hd__tapvpwrvgnd_1
XFILLER_199_217 VGND VGND VPWR VPWR sky130_fd_sc_hd__decap_6
XFILLER_167_1449 VGND VGND VPWR VPWR sky130_fd_sc_hd__decap_6
XFILLER_93_1602 VGND VGND VPWR VPWR sky130_fd_sc_hd__decap_3
XFILLER_210_221 VPWR VGND VPWR VGND sky130_ef_sc_hd__decap_12
XFILLER_168_637 VGND VGND VPWR VPWR sky130_fd_sc_hd__decap_6
XTAP_TAPCELL_ROW_143_1_1304 VGND VPWR sky130_fd_sc_hd__tapvpwrvgnd_1
XFILLER_22_120 VGND VGND VPWR VPWR sky130_fd_sc_hd__decap_6
XFILLER_211_777 VGND VGND VPWR VPWR sky130_fd_sc_hd__decap_6
XFILLER_196_979 VGND VGND VPWR VPWR sky130_fd_sc_hd__fill_1
XFILLER_168_27 VGND VGND VPWR VPWR sky130_fd_sc_hd__fill_1
XFILLER_167_125 VPWR VGND VPWR VGND sky130_ef_sc_hd__decap_12
XFILLER_210_265 VPWR VGND VPWR VGND sky130_ef_sc_hd__decap_12
XFILLER_183_629 VPWR VGND VPWR VGND sky130_ef_sc_hd__decap_12
XFILLER_167_169 VPWR VGND VPWR VGND sky130_ef_sc_hd__decap_12
XFILLER_108_1580 VGND VGND VPWR VPWR sky130_fd_sc_hd__fill_1
XFILLER_7_809 VGND VGND VPWR VPWR sky130_fd_sc_hd__decap_3
XFILLER_182_139 VGND VGND VPWR VPWR sky130_fd_sc_hd__fill_1
XFILLER_176_681 VPWR VGND VPWR VGND sky130_ef_sc_hd__decap_12
XFILLER_17_1496 VGND VGND VPWR VPWR sky130_fd_sc_hd__fill_1
XFILLER_184_15 VPWR VGND VPWR VGND sky130_ef_sc_hd__decap_12
XFILLER_191_673 VPWR VGND VPWR VGND sky130_ef_sc_hd__decap_12
XFILLER_178_1589 VGND VGND VPWR VPWR sky130_fd_sc_hd__decap_6
XFILLER_174_1409 VPWR VGND VPWR VGND sky130_ef_sc_hd__decap_12
XFILLER_219_1553 VPWR VGND VPWR VGND sky130_ef_sc_hd__decap_12
XFILLER_137_1220 VPWR VGND VPWR VGND sky130_ef_sc_hd__decap_12
XFILLER_219_1597 VGND VGND VPWR VPWR sky130_fd_sc_hd__decap_8
XFILLER_137_1286 VPWR VGND VPWR VGND sky130_ef_sc_hd__decap_12
XFILLER_77_57 VPWR VGND VPWR VGND sky130_ef_sc_hd__decap_12
XFILLER_24_1412 VGND VGND VPWR VPWR sky130_fd_sc_hd__fill_1
XFILLER_218_321 VPWR VGND VPWR VGND sky130_ef_sc_hd__decap_12
XTAP_TAPCELL_ROW_164_1421 VGND VPWR sky130_fd_sc_hd__tapvpwrvgnd_1
XTAP_TAPCELL_ROW_164_1410 VGND VPWR sky130_fd_sc_hd__tapvpwrvgnd_1
XTAP_TAPCELL_ROW_114_2_3721 VGND VPWR sky130_fd_sc_hd__tapvpwrvgnd_1
XANTENNA__279__D b_addr\[4\] VGND VGND VPWR VPWR sky130_fd_sc_hd__diode_2
XFILLER_98_1524 VGND VGND VPWR VPWR sky130_fd_sc_hd__fill_1
XTAP_TAPCELL_ROW_89_1_1196 VGND VPWR sky130_fd_sc_hd__tapvpwrvgnd_1
XFILLER_4_1539 VGND VGND VPWR VPWR sky130_fd_sc_hd__fill_1
XFILLER_218_365 VPWR VGND VPWR VGND sky130_ef_sc_hd__decap_12
XFILLER_185_1505 VGND VGND VPWR VPWR sky130_fd_sc_hd__decap_6
XTAP_TAPCELL_ROW_82_2_3510 VGND VPWR sky130_fd_sc_hd__tapvpwrvgnd_1
XFILLER_2_1241 VPWR VGND VPWR VGND sky130_ef_sc_hd__decap_12
XFILLER_185_1549 VPWR VGND VPWR VGND sky130_ef_sc_hd__decap_12
X_503_ net151 _181_ net129 net138 _225_ VGND VGND VPWR VPWR _035_ sky130_fd_sc_hd__o311a_1
XFILLER_96_1270 VPWR VGND VPWR VGND sky130_ef_sc_hd__decap_12
XFILLER_2_1285 VPWR VGND VPWR VGND sky130_ef_sc_hd__decap_12
X_434_ _108_ _165_ _166_ _117_ VGND VGND VPWR VPWR _167_ sky130_fd_sc_hd__a31o_1
XFILLER_57_1232 VPWR VGND VPWR VGND sky130_ef_sc_hd__decap_12
XFILLER_186_401 VPWR VGND VPWR VGND sky130_ef_sc_hd__decap_12
XFILLER_148_1382 VPWR VGND VPWR VGND sky130_ef_sc_hd__decap_12
XFILLER_109_1322 VGND VGND VPWR VPWR sky130_fd_sc_hd__decap_6
XFILLER_202_755 VGND VGND VPWR VPWR sky130_fd_sc_hd__fill_1
XFILLER_186_445 VPWR VGND VPWR VGND sky130_ef_sc_hd__decap_12
XFILLER_144_1246 VPWR VGND VPWR VGND sky130_ef_sc_hd__decap_12
XFILLER_109_1366 VPWR VGND VPWR VGND sky130_ef_sc_hd__decap_12
XFILLER_9_124 VGND VGND VPWR VPWR sky130_fd_sc_hd__fill_1
X_365_ _079_ _107_ _104_ VGND VGND VPWR VPWR _108_ sky130_fd_sc_hd__mux2_4
XFILLER_57_1298 VPWR VGND VPWR VGND sky130_ef_sc_hd__decap_12
XFILLER_186_489 VPWR VGND VPWR VGND sky130_ef_sc_hd__decap_12
X_296_ net37 net141 net131 VGND VGND VPWR VPWR s_wdata\[3\] sky130_fd_sc_hd__a21o_1
XFILLER_35_1552 VGND VGND VPWR VPWR sky130_fd_sc_hd__fill_1
XPHY_EDGE_ROW_82_2_Right_139 VGND VGND VPWR VPWR sky130_fd_sc_hd__decap_3
XFILLER_177_1033 VPWR VGND VPWR VGND sky130_ef_sc_hd__decap_12
XFILLER_192_1509 VPWR VGND VPWR VGND sky130_ef_sc_hd__decap_12
XFILLER_181_161 VGND VGND VPWR VPWR sky130_fd_sc_hd__decap_6
XFILLER_170_813 VPWR VGND VPWR VGND sky130_ef_sc_hd__decap_12
XFILLER_177_1077 VPWR VGND VPWR VGND sky130_ef_sc_hd__decap_12
XFILLER_68_1350 VGND VGND VPWR VPWR sky130_fd_sc_hd__decap_6
XFILLER_155_1342 VPWR VGND VPWR VGND sky130_ef_sc_hd__decap_12
XFILLER_68_1394 VPWR VGND VPWR VGND sky130_ef_sc_hd__decap_12
XTAP_TAPCELL_ROW_23_2_3125 VGND VPWR sky130_fd_sc_hd__tapvpwrvgnd_1
XFILLER_218_1085 VGND VGND VPWR VPWR sky130_fd_sc_hd__decap_6
XFILLER_155_1386 VPWR VGND VPWR VGND sky130_ef_sc_hd__decap_12
XFILLER_116_1326 VPWR VGND VPWR VGND sky130_ef_sc_hd__decap_12
XFILLER_64_1258 VPWR VGND VPWR VGND sky130_ef_sc_hd__decap_12
XFILLER_29_1378 VGND VGND VPWR VPWR sky130_fd_sc_hd__decap_6
XFILLER_188_1173 VPWR VGND VPWR VGND sky130_ef_sc_hd__decap_12
XFILLER_184_1037 VPWR VGND VPWR VGND sky130_ef_sc_hd__decap_12
XFILLER_75_1310 VPWR VGND VPWR VGND sky130_ef_sc_hd__decap_12
XFILLER_79_1490 VGND VGND VPWR VPWR sky130_fd_sc_hd__decap_6
XFILLER_196_209 VPWR VGND VPWR VGND sky130_ef_sc_hd__decap_12
XFILLER_189_261 VPWR VGND VPWR VGND sky130_ef_sc_hd__decap_12
XFILLER_162_1302 VPWR VGND VPWR VGND sky130_ef_sc_hd__decap_12
XFILLER_127_1422 VPWR VGND VPWR VGND sky130_ef_sc_hd__decap_12
XFILLER_75_1354 VPWR VGND VPWR VGND sky130_ef_sc_hd__decap_12
XFILLER_178_979 VGND VGND VPWR VPWR sky130_fd_sc_hd__fill_1
XFILLER_149_125 VGND VGND VPWR VPWR sky130_fd_sc_hd__fill_2
XFILLER_127_1466 VPWR VGND VPWR VGND sky130_ef_sc_hd__decap_12
XFILLER_75_1398 VPWR VGND VPWR VGND sky130_ef_sc_hd__decap_12
XFILLER_36_1338 VPWR VGND VPWR VGND sky130_ef_sc_hd__decap_12
XFILLER_165_629 VPWR VGND VPWR VGND sky130_ef_sc_hd__decap_12
XFILLER_203_1343 VGND VGND VPWR VPWR sky130_fd_sc_hd__fill_1
XFILLER_164_139 VGND VGND VPWR VPWR sky130_fd_sc_hd__fill_1
XTAP_TAPCELL_ROW_140_2_3888 VGND VPWR sky130_fd_sc_hd__tapvpwrvgnd_1
XANTENNA__335__A2 net140 VGND VGND VPWR VPWR sky130_fd_sc_hd__diode_2
XFILLER_218_41 VPWR VGND VPWR VGND sky130_ef_sc_hd__decap_12
XFILLER_195_1133 VPWR VGND VPWR VGND sky130_ef_sc_hd__decap_12
XFILLER_173_673 VPWR VGND VPWR VGND sky130_ef_sc_hd__decap_12
XFILLER_12_1382 VPWR VGND VPWR VGND sky130_ef_sc_hd__decap_12
XFILLER_218_85 VPWR VGND VPWR VGND sky130_ef_sc_hd__decap_12
XFILLER_195_1177 VPWR VGND VPWR VGND sky130_ef_sc_hd__decap_12
XFILLER_86_1450 VPWR VGND VPWR VGND sky130_ef_sc_hd__decap_12
XFILLER_154_29 VPWR VGND VPWR VGND sky130_ef_sc_hd__decap_12
XFILLER_138_1562 VPWR VGND VPWR VGND sky130_ef_sc_hd__decap_12
XFILLER_86_1494 VPWR VGND VPWR VGND sky130_ef_sc_hd__decap_12
XFILLER_82_1314 VPWR VGND VPWR VGND sky130_ef_sc_hd__decap_12
XFILLER_47_1434 VGND VGND VPWR VPWR sky130_fd_sc_hd__decap_6
XFILLER_134_1426 VPWR VGND VPWR VGND sky130_ef_sc_hd__decap_12
XFILLER_82_1358 VPWR VGND VPWR VGND sky130_ef_sc_hd__decap_12
Xfanout136 net139 VGND VGND VPWR VPWR net136 sky130_fd_sc_hd__buf_2
Xfanout125 net126 VGND VGND VPWR VPWR net125 sky130_fd_sc_hd__clkbuf_2
Xfanout147 u_ctrl.cmp_exp\[0\] VGND VGND VPWR VPWR net147 sky130_fd_sc_hd__buf_4
XFILLER_47_1478 VPWR VGND VPWR VGND sky130_ef_sc_hd__decap_12
XPHY_EDGE_ROW_44_2_Right_101 VGND VGND VPWR VPWR sky130_fd_sc_hd__decap_3
XFILLER_47_27 VPWR VGND VPWR VGND sky130_ef_sc_hd__decap_12
XFILLER_214_1483 VGND VGND VPWR VPWR sky130_fd_sc_hd__fill_1
XTAP_TAPCELL_ROW_67_2_3412 VGND VPWR sky130_fd_sc_hd__tapvpwrvgnd_1
XFILLER_216_825 VPWR VGND VPWR VGND sky130_ef_sc_hd__decap_12
XTAP_TAPCELL_ROW_3_889 VGND VPWR sky130_fd_sc_hd__tapvpwrvgnd_1
XTAP_TAPCELL_ROW_3_878 VGND VPWR sky130_fd_sc_hd__tapvpwrvgnd_1
XTAP_TAPCELL_ROW_3_867 VGND VPWR sky130_fd_sc_hd__tapvpwrvgnd_1
XFILLER_216_869 VPWR VGND VPWR VGND sky130_ef_sc_hd__decap_12
XFILLER_215_335 VGND VGND VPWR VPWR sky130_fd_sc_hd__fill_1
XFILLER_167_1213 VPWR VGND VPWR VGND sky130_ef_sc_hd__decap_12
XFILLER_103_55 VGND VGND VPWR VPWR sky130_fd_sc_hd__fill_1
XFILLER_63_15 VPWR VGND VPWR VGND sky130_ef_sc_hd__decap_12
XFILLER_3_1561 VGND VGND VPWR VPWR sky130_fd_sc_hd__decap_6
XFILLER_179_15 VPWR VGND VPWR VGND sky130_ef_sc_hd__decap_12
XFILLER_167_1257 VPWR VGND VPWR VGND sky130_ef_sc_hd__decap_12
XPHY_EDGE_ROW_113_2_Left_545 VGND VGND VPWR VPWR sky130_fd_sc_hd__decap_3
XFILLER_110_1470 VPWR VGND VPWR VGND sky130_ef_sc_hd__decap_12
XFILLER_97_1590 VPWR VGND VPWR VGND sky130_ef_sc_hd__decap_12
XFILLER_93_1410 VPWR VGND VPWR VGND sky130_ef_sc_hd__decap_12
XFILLER_168_401 VPWR VGND VPWR VGND sky130_ef_sc_hd__decap_12
XFILLER_145_1522 VPWR VGND VPWR VGND sky130_ef_sc_hd__decap_12
XFILLER_93_1454 VPWR VGND VPWR VGND sky130_ef_sc_hd__decap_12
XFILLER_58_1574 VGND VGND VPWR VPWR sky130_fd_sc_hd__decap_6
XFILLER_211_541 VPWR VGND VPWR VGND sky130_ef_sc_hd__decap_12
XFILLER_168_445 VPWR VGND VPWR VGND sky130_ef_sc_hd__decap_12
XFILLER_145_1566 VPWR VGND VPWR VGND sky130_ef_sc_hd__decap_12
XFILLER_106_1506 VPWR VGND VPWR VGND sky130_ef_sc_hd__decap_12
XFILLER_93_1498 VPWR VGND VPWR VGND sky130_ef_sc_hd__decap_12
XFILLER_54_1438 VPWR VGND VPWR VGND sky130_ef_sc_hd__decap_12
XFILLER_211_585 VPWR VGND VPWR VGND sky130_ef_sc_hd__decap_12
XFILLER_204_1129 VPWR VGND VPWR VGND sky130_ef_sc_hd__decap_12
XFILLER_184_905 VPWR VGND VPWR VGND sky130_ef_sc_hd__decap_12
XFILLER_184_949 VPWR VGND VPWR VGND sky130_ef_sc_hd__decap_12
XFILLER_168_489 VPWR VGND VPWR VGND sky130_ef_sc_hd__decap_12
XFILLER_7_628 VPWR VGND VPWR VGND sky130_ef_sc_hd__decap_12
XFILLER_195_69 VPWR VGND VPWR VGND sky130_ef_sc_hd__decap_12
XFILLER_6_149 VGND VGND VPWR VPWR sky130_fd_sc_hd__fill_1
XFILLER_192_993 VPWR VGND VPWR VGND sky130_ef_sc_hd__decap_12
XFILLER_178_1353 VPWR VGND VPWR VGND sky130_ef_sc_hd__decap_12
XFILLER_170_109 VPWR VGND VPWR VGND sky130_ef_sc_hd__decap_12
XFILLER_128_41 VPWR VGND VPWR VGND sky130_ef_sc_hd__decap_12
XFILLER_12_85 VGND VGND VPWR VPWR sky130_fd_sc_hd__decap_4
XFILLER_178_1397 VPWR VGND VPWR VGND sky130_ef_sc_hd__decap_12
XFILLER_174_1217 VPWR VGND VPWR VGND sky130_ef_sc_hd__decap_12
XFILLER_128_85 VPWR VGND VPWR VGND sky130_ef_sc_hd__decap_12
XFILLER_30_1482 VPWR VGND VPWR VGND sky130_ef_sc_hd__decap_12
XFILLER_117_1602 VGND VGND VPWR VPWR sky130_fd_sc_hd__decap_3
XFILLER_65_1534 VPWR VGND VPWR VGND sky130_ef_sc_hd__decap_12
XFILLER_215_1225 VGND VGND VPWR VPWR sky130_fd_sc_hd__decap_6
XFILLER_152_1526 VPWR VGND VPWR VGND sky130_ef_sc_hd__decap_12
XFILLER_65_1578 VPWR VGND VPWR VGND sky130_ef_sc_hd__decap_12
XFILLER_26_1518 VGND VGND VPWR VPWR sky130_fd_sc_hd__decap_6
XFILLER_215_1269 VPWR VGND VPWR VGND sky130_ef_sc_hd__decap_12
XFILLER_8_1450 VPWR VGND VPWR VGND sky130_ef_sc_hd__decap_12
XFILLER_24_1220 VPWR VGND VPWR VGND sky130_ef_sc_hd__decap_12
XFILLER_219_641 VGND VGND VPWR VPWR sky130_fd_sc_hd__decap_3
XFILLER_8_1494 VPWR VGND VPWR VGND sky130_ef_sc_hd__decap_12
XFILLER_219_685 VPWR VGND VPWR VGND sky130_ef_sc_hd__decap_12
XFILLER_150_1294 VGND VGND VPWR VPWR sky130_fd_sc_hd__decap_6
XFILLER_218_195 VGND VGND VPWR VPWR sky130_fd_sc_hd__fill_1
XFILLER_189_1493 VPWR VGND VPWR VGND sky130_ef_sc_hd__decap_12
XFILLER_185_1313 VPWR VGND VPWR VGND sky130_ef_sc_hd__decap_12
XTAP_TAPCELL_ROW_158_2_4005 VGND VPWR sky130_fd_sc_hd__tapvpwrvgnd_1
XFILLER_111_1256 VPWR VGND VPWR VGND sky130_ef_sc_hd__decap_12
XFILLER_37_93 VPWR VGND VPWR VGND sky130_ef_sc_hd__decap_12
XPHY_EDGE_ROW_45_2_Left_477 VGND VGND VPWR VPWR sky130_fd_sc_hd__decap_3
XFILLER_209_1007 VGND VGND VPWR VPWR sky130_fd_sc_hd__fill_1
XFILLER_206_357 VGND VGND VPWR VPWR sky130_fd_sc_hd__decap_6
XFILLER_185_1357 VPWR VGND VPWR VGND sky130_ef_sc_hd__decap_12
XFILLER_160_83 VGND VGND VPWR VPWR sky130_fd_sc_hd__fill_1
XFILLER_178_209 VPWR VGND VPWR VGND sky130_ef_sc_hd__decap_12
XFILLER_2_1093 VPWR VGND VPWR VGND sky130_ef_sc_hd__decap_12
XFILLER_187_721 VGND VGND VPWR VPWR sky130_fd_sc_hd__decap_6
XFILLER_72_1538 VPWR VGND VPWR VGND sky130_ef_sc_hd__decap_12
XANTENNA__526__S net125 VGND VGND VPWR VPWR sky130_fd_sc_hd__diode_2
X_417_ _140_ _145_ _151_ VGND VGND VPWR VPWR _152_ sky130_fd_sc_hd__o21ai_1
XFILLER_53_81 VPWR VGND VPWR VGND sky130_ef_sc_hd__decap_12
XFILLER_187_765 VPWR VGND VPWR VGND sky130_ef_sc_hd__decap_12
XFILLER_186_253 VPWR VGND VPWR VGND sky130_ef_sc_hd__decap_12
XFILLER_169_81 VPWR VGND VPWR VGND sky130_ef_sc_hd__decap_12
X_348_ u_ctrl.cmp_addr\[5\] b_addr\[5\] net152 VGND VGND VPWR VPWR _095_ sky130_fd_sc_hd__mux2_1
X_279_ b_addr\[7\] b_addr\[6\] b_addr\[5\] b_addr\[4\] VGND VGND VPWR VPWR _077_ sky130_fd_sc_hd__and4_1
XFILLER_196_1453 VPWR VGND VPWR VGND sky130_ef_sc_hd__decap_12
XFILLER_31_1268 VGND VGND VPWR VPWR sky130_fd_sc_hd__decap_4
XFILLER_196_1497 VPWR VGND VPWR VGND sky130_ef_sc_hd__decap_12
XFILLER_192_1317 VPWR VGND VPWR VGND sky130_ef_sc_hd__decap_12
XFILLER_170_643 VGND VGND VPWR VPWR sky130_fd_sc_hd__fill_1
XTAP_TAPCELL_ROW_73_2_3455 VGND VPWR sky130_fd_sc_hd__tapvpwrvgnd_1
XFILLER_45_3 VPWR VGND VPWR VGND sky130_ef_sc_hd__decap_12
XPHY_EDGE_ROW_109_1_Left_328 VGND VGND VPWR VPWR sky130_fd_sc_hd__decap_3
XFILLER_190_1085 VGND VGND VPWR VPWR sky130_fd_sc_hd__decap_6
XTAP_TAPCELL_ROW_53_2_3320 VGND VPWR sky130_fd_sc_hd__tapvpwrvgnd_1
XFILLER_204_65 VPWR VGND VPWR VGND sky130_ef_sc_hd__decap_12
XTAP_TAPCELL_ROW_0_804 VGND VPWR sky130_fd_sc_hd__tapvpwrvgnd_1
XFILLER_168_1533 VGND VGND VPWR VPWR sky130_fd_sc_hd__decap_6
XFILLER_168_1577 VPWR VGND VPWR VGND sky130_ef_sc_hd__decap_12
XFILLER_213_839 VGND VGND VPWR VPWR sky130_fd_sc_hd__fill_1
XFILLER_197_529 VPWR VGND VPWR VGND sky130_ef_sc_hd__decap_12
XFILLER_205_1449 VGND VGND VPWR VPWR sky130_fd_sc_hd__decap_6
XFILLER_166_905 VPWR VGND VPWR VGND sky130_ef_sc_hd__decap_12
XFILLER_127_1274 VPWR VGND VPWR VGND sky130_ef_sc_hd__decap_12
XFILLER_166_949 VPWR VGND VPWR VGND sky130_ef_sc_hd__decap_12
XFILLER_18_1580 VGND VGND VPWR VPWR sky130_fd_sc_hd__fill_1
XFILLER_192_245 VGND VGND VPWR VPWR sky130_fd_sc_hd__decap_6
XFILLER_192_289 VPWR VGND VPWR VGND sky130_ef_sc_hd__decap_12
XFILLER_174_993 VPWR VGND VPWR VGND sky130_ef_sc_hd__decap_12
XFILLER_152_109 VPWR VGND VPWR VGND sky130_ef_sc_hd__decap_12
XFILLER_175_1537 VPWR VGND VPWR VGND sky130_ef_sc_hd__decap_12
XFILLER_165_39 VPWR VGND VPWR VGND sky130_ef_sc_hd__decap_12
XFILLER_3_119 VGND VGND VPWR VPWR sky130_fd_sc_hd__fill_1
XFILLER_47_1220 VPWR VGND VPWR VGND sky130_ef_sc_hd__decap_12
XFILLER_138_1370 VPWR VGND VPWR VGND sky130_ef_sc_hd__decap_12
XFILLER_0_837 VGND VGND VPWR VPWR sky130_fd_sc_hd__decap_3
XFILLER_58_15 VPWR VGND VPWR VGND sky130_ef_sc_hd__decap_12
XFILLER_216_1589 VGND VGND VPWR VPWR sky130_fd_sc_hd__decap_6
XFILLER_212_1409 VPWR VGND VPWR VGND sky130_ef_sc_hd__decap_12
XFILLER_181_27 VPWR VGND VPWR VGND sky130_ef_sc_hd__decap_12
XFILLER_47_1286 VPWR VGND VPWR VGND sky130_ef_sc_hd__decap_12
XPHY_EDGE_ROW_45_2_Right_102 VGND VGND VPWR VPWR sky130_fd_sc_hd__decap_3
XFILLER_114_65 VPWR VGND VPWR VGND sky130_ef_sc_hd__decap_12
XFILLER_167_1021 VPWR VGND VPWR VGND sky130_ef_sc_hd__decap_12
XTAP_TAPCELL_ROW_23_1_1063 VGND VPWR sky130_fd_sc_hd__tapvpwrvgnd_1
XPHY_EDGE_ROW_30_1_Left_249 VGND VGND VPWR VPWR sky130_fd_sc_hd__decap_3
XFILLER_216_699 VGND VGND VPWR VPWR sky130_fd_sc_hd__fill_1
XFILLER_203_305 VPWR VGND VPWR VGND sky130_ef_sc_hd__decap_12
XFILLER_167_1065 VPWR VGND VPWR VGND sky130_ef_sc_hd__decap_12
XPHY_EDGE_ROW_155_1_Left_374 VGND VGND VPWR VPWR sky130_fd_sc_hd__decap_3
XFILLER_130_53 VPWR VGND VPWR VGND sky130_ef_sc_hd__decap_12
XFILLER_203_349 VPWR VGND VPWR VGND sky130_ef_sc_hd__decap_12
XFILLER_169_721 VGND VGND VPWR VPWR sky130_fd_sc_hd__decap_6
XFILLER_145_1330 VPWR VGND VPWR VGND sky130_ef_sc_hd__decap_12
XFILLER_130_97 VPWR VGND VPWR VGND sky130_ef_sc_hd__decap_12
XTAP_TAPCELL_ROW_111_2_3698 VGND VPWR sky130_fd_sc_hd__tapvpwrvgnd_1
XFILLER_19_1322 VGND VGND VPWR VPWR sky130_fd_sc_hd__decap_6
XFILLER_58_1382 VPWR VGND VPWR VGND sky130_ef_sc_hd__decap_12
XFILLER_212_861 VGND VGND VPWR VPWR sky130_fd_sc_hd__decap_6
XFILLER_208_1073 VPWR VGND VPWR VGND sky130_ef_sc_hd__decap_12
XFILLER_169_765 VPWR VGND VPWR VGND sky130_ef_sc_hd__decap_12
XFILLER_168_253 VPWR VGND VPWR VGND sky130_ef_sc_hd__decap_12
XTAP_TAPCELL_ROW_111_1_1239 VGND VPWR sky130_fd_sc_hd__tapvpwrvgnd_1
XFILLER_106_1314 VPWR VGND VPWR VGND sky130_ef_sc_hd__decap_12
XFILLER_19_1366 VPWR VGND VPWR VGND sky130_ef_sc_hd__decap_12
XFILLER_54_1246 VPWR VGND VPWR VGND sky130_ef_sc_hd__decap_12
XFILLER_211_393 VPWR VGND VPWR VGND sky130_ef_sc_hd__decap_12
XFILLER_184_713 VPWR VGND VPWR VGND sky130_ef_sc_hd__decap_12
XFILLER_106_1358 VPWR VGND VPWR VGND sky130_ef_sc_hd__decap_12
XPHY_EDGE_ROW_92_1_Left_311 VGND VGND VPWR VPWR sky130_fd_sc_hd__decap_3
XFILLER_23_51 VGND VGND VPWR VPWR sky130_fd_sc_hd__decap_4
XFILLER_184_757 VPWR VGND VPWR VGND sky130_ef_sc_hd__decap_12
XFILLER_183_223 VGND VGND VPWR VPWR sky130_fd_sc_hd__fill_1
XFILLER_139_51 VGND VGND VPWR VPWR sky130_fd_sc_hd__decap_4
XFILLER_171_429 VPWR VGND VPWR VGND sky130_ef_sc_hd__decap_12
XFILLER_99_55 VGND VGND VPWR VPWR sky130_fd_sc_hd__fill_1
XFILLER_178_1161 VPWR VGND VPWR VGND sky130_ef_sc_hd__decap_12
XTAP_TAPCELL_ROW_58_2_3357 VGND VPWR sky130_fd_sc_hd__tapvpwrvgnd_1
XFILLER_156_1470 VPWR VGND VPWR VGND sky130_ef_sc_hd__decap_12
XFILLER_117_1410 VPWR VGND VPWR VGND sky130_ef_sc_hd__decap_12
XFILLER_65_1342 VPWR VGND VPWR VGND sky130_ef_sc_hd__decap_12
XFILLER_2_141 VGND VGND VPWR VPWR sky130_fd_sc_hd__fill_1
XFILLER_215_1033 VPWR VGND VPWR VGND sky130_ef_sc_hd__decap_12
XFILLER_117_1454 VPWR VGND VPWR VGND sky130_ef_sc_hd__decap_12
XFILLER_65_1386 VPWR VGND VPWR VGND sky130_ef_sc_hd__decap_12
XFILLER_6_1409 VPWR VGND VPWR VGND sky130_ef_sc_hd__decap_12
XFILLER_26_1326 VPWR VGND VPWR VGND sky130_ef_sc_hd__decap_12
XTAP_TAPCELL_ROW_38_2_3222 VGND VPWR sky130_fd_sc_hd__tapvpwrvgnd_1
XFILLER_215_1077 VPWR VGND VPWR VGND sky130_ef_sc_hd__decap_12
XFILLER_152_1356 VGND VGND VPWR VPWR sky130_fd_sc_hd__fill_1
XFILLER_117_1498 VPWR VGND VPWR VGND sky130_ef_sc_hd__decap_12
XTAP_TAPCELL_ROW_7_981 VGND VPWR sky130_fd_sc_hd__tapvpwrvgnd_1
XTAP_TAPCELL_ROW_7_992 VGND VPWR sky130_fd_sc_hd__tapvpwrvgnd_1
XFILLER_206_121 VPWR VGND VPWR VGND sky130_ef_sc_hd__decap_12
XFILLER_171_93 VPWR VGND VPWR VGND sky130_ef_sc_hd__decap_12
XFILLER_185_1121 VPWR VGND VPWR VGND sky130_ef_sc_hd__decap_12
XFILLER_0_66 VPWR VGND VPWR VGND sky130_ef_sc_hd__decap_12
XFILLER_206_165 VPWR VGND VPWR VGND sky130_ef_sc_hd__decap_12
XFILLER_181_1007 VGND VGND VPWR VPWR sky130_fd_sc_hd__fill_1
XFILLER_179_529 VPWR VGND VPWR VGND sky130_ef_sc_hd__decap_12
XANTENNA__582__CLK clknet_3_2_0_clk VGND VGND VPWR VPWR sky130_fd_sc_hd__diode_2
XFILLER_163_1441 VPWR VGND VPWR VGND sky130_ef_sc_hd__decap_12
XFILLER_128_1550 VPWR VGND VPWR VGND sky130_ef_sc_hd__decap_12
XFILLER_76_1482 VPWR VGND VPWR VGND sky130_ef_sc_hd__decap_12
XFILLER_72_1302 VPWR VGND VPWR VGND sky130_ef_sc_hd__decap_12
XFILLER_37_1422 VPWR VGND VPWR VGND sky130_ef_sc_hd__decap_12
XFILLER_128_1594 VGND VGND VPWR VPWR sky130_fd_sc_hd__decap_8
XFILLER_124_1414 VPWR VGND VPWR VGND sky130_ef_sc_hd__decap_12
XFILLER_37_1466 VPWR VGND VPWR VGND sky130_ef_sc_hd__decap_12
XFILLER_187_573 VPWR VGND VPWR VGND sky130_ef_sc_hd__decap_12
XFILLER_163_1485 VPWR VGND VPWR VGND sky130_ef_sc_hd__decap_12
XTAP_TAPCELL_ROW_48_1_1114 VGND VPWR sky130_fd_sc_hd__tapvpwrvgnd_1
XFILLER_174_245 VGND VGND VPWR VPWR sky130_fd_sc_hd__decap_6
XFILLER_174_289 VPWR VGND VPWR VGND sky130_ef_sc_hd__decap_12
XTAP_TAPCELL_ROW_155_2_3985 VGND VPWR sky130_fd_sc_hd__tapvpwrvgnd_1
XFILLER_134_109 VPWR VGND VPWR VGND sky130_ef_sc_hd__decap_12
XFILLER_196_1261 VPWR VGND VPWR VGND sky130_ef_sc_hd__decap_12
XFILLER_190_749 VGND VGND VPWR VPWR sky130_fd_sc_hd__decap_6
XFILLER_7_981 VPWR VGND VPWR VGND sky130_ef_sc_hd__decap_12
XFILLER_192_1147 VGND VGND VPWR VPWR sky130_fd_sc_hd__fill_1
XFILLER_157_1256 VPWR VGND VPWR VGND sky130_ef_sc_hd__decap_12
XFILLER_6_491 VPWR VGND VPWR VGND sky130_ef_sc_hd__decap_12
XFILLER_135_1510 VPWR VGND VPWR VGND sky130_ef_sc_hd__decap_12
XFILLER_83_1442 VPWR VGND VPWR VGND sky130_ef_sc_hd__decap_12
XFILLER_48_1562 VPWR VGND VPWR VGND sky130_ef_sc_hd__decap_12
XFILLER_135_1554 VPWR VGND VPWR VGND sky130_ef_sc_hd__decap_12
XTAP_TAPCELL_ROW_5_929 VGND VPWR sky130_fd_sc_hd__tapvpwrvgnd_1
XFILLER_44_1426 VPWR VGND VPWR VGND sky130_ef_sc_hd__decap_12
XFILLER_28_29 VPWR VGND VPWR VGND sky130_ef_sc_hd__decap_12
XFILLER_56_126 VGND VGND VPWR VPWR sky130_fd_sc_hd__fill_1
XFILLER_198_805 VGND VGND VPWR VPWR sky130_fd_sc_hd__decap_6
XFILLER_168_1341 VPWR VGND VPWR VGND sky130_ef_sc_hd__decap_12
XFILLER_168_1385 VPWR VGND VPWR VGND sky130_ef_sc_hd__decap_12
XFILLER_164_1205 VPWR VGND VPWR VGND sky130_ef_sc_hd__decap_12
XFILLER_77_1268 VGND VGND VPWR VPWR sky130_fd_sc_hd__decap_4
XFILLER_0_1553 VPWR VGND VPWR VGND sky130_ef_sc_hd__decap_12
XFILLER_20_1470 VPWR VGND VPWR VGND sky130_ef_sc_hd__decap_12
XFILLER_201_809 VPWR VGND VPWR VGND sky130_ef_sc_hd__decap_12
XFILLER_198_849 VPWR VGND VPWR VGND sky130_ef_sc_hd__decap_12
XFILLER_197_337 VPWR VGND VPWR VGND sky130_ef_sc_hd__decap_12
XFILLER_94_1582 VPWR VGND VPWR VGND sky130_ef_sc_hd__decap_12
XFILLER_0_1597 VGND VGND VPWR VPWR sky130_fd_sc_hd__decap_8
XFILLER_55_1522 VPWR VGND VPWR VGND sky130_ef_sc_hd__decap_12
XFILLER_209_1393 VGND VGND VPWR VPWR sky130_fd_sc_hd__decap_6
XFILLER_205_1213 VPWR VGND VPWR VGND sky130_ef_sc_hd__decap_12
XFILLER_16_1506 VPWR VGND VPWR VGND sky130_ef_sc_hd__decap_12
XFILLER_55_1566 VPWR VGND VPWR VGND sky130_ef_sc_hd__decap_12
XFILLER_205_1257 VPWR VGND VPWR VGND sky130_ef_sc_hd__decap_12
XTAP_TAPCELL_ROW_195_2298 VGND VPWR sky130_fd_sc_hd__tapvpwrvgnd_1
XTAP_TAPCELL_ROW_195_2287 VGND VPWR sky130_fd_sc_hd__tapvpwrvgnd_1
XFILLER_166_713 VPWR VGND VPWR VGND sky130_ef_sc_hd__decap_12
XFILLER_90_1468 VGND VGND VPWR VPWR sky130_fd_sc_hd__fill_1
XFILLER_60_27 VGND VGND VPWR VPWR sky130_fd_sc_hd__fill_1
XFILLER_176_27 VGND VGND VPWR VPWR sky130_fd_sc_hd__fill_1
XFILLER_166_757 VPWR VGND VPWR VGND sky130_ef_sc_hd__decap_12
XFILLER_165_223 VGND VGND VPWR VPWR sky130_fd_sc_hd__fill_1
XFILLER_181_727 VGND VGND VPWR VPWR sky130_fd_sc_hd__fill_1
XFILLER_140_1282 VPWR VGND VPWR VGND sky130_ef_sc_hd__decap_12
XTAP_TAPCELL_ROW_44_2_3265 VGND VPWR sky130_fd_sc_hd__tapvpwrvgnd_1
XFILLER_179_1481 VPWR VGND VPWR VGND sky130_ef_sc_hd__decap_12
XFILLER_175_1301 VPWR VGND VPWR VGND sky130_ef_sc_hd__decap_12
XFILLER_101_1244 VPWR VGND VPWR VGND sky130_ef_sc_hd__decap_12
XFILLER_192_15 VPWR VGND VPWR VGND sky130_ef_sc_hd__decap_12
XFILLER_175_1345 VPWR VGND VPWR VGND sky130_ef_sc_hd__decap_12
XFILLER_69_69 VPWR VGND VPWR VGND sky130_ef_sc_hd__decap_12
XFILLER_0_612 VGND VGND VPWR VPWR sky130_fd_sc_hd__decap_4
XFILLER_27_1602 VGND VGND VPWR VPWR sky130_fd_sc_hd__decap_3
XFILLER_216_1353 VPWR VGND VPWR VGND sky130_ef_sc_hd__decap_12
XFILLER_62_1526 VPWR VGND VPWR VGND sky130_ef_sc_hd__decap_12
XFILLER_216_1397 VPWR VGND VPWR VGND sky130_ef_sc_hd__decap_12
XFILLER_212_1217 VPWR VGND VPWR VGND sky130_ef_sc_hd__decap_12
XFILLER_209_909 VPWR VGND VPWR VGND sky130_ef_sc_hd__decap_12
XFILLER_197_3 VPWR VGND VPWR VGND sky130_ef_sc_hd__decap_12
XFILLER_208_419 VGND VGND VPWR VPWR sky130_fd_sc_hd__fill_1
XFILLER_85_57 VPWR VGND VPWR VGND sky130_ef_sc_hd__decap_12
XTAP_TAPCELL_ROW_184_1991 VGND VPWR sky130_fd_sc_hd__tapvpwrvgnd_1
XTAP_TAPCELL_ROW_184_1980 VGND VPWR sky130_fd_sc_hd__tapvpwrvgnd_1
XPHY_EDGE_ROW_46_2_Right_103 VGND VGND VPWR VPWR sky130_fd_sc_hd__decap_3
XFILLER_60_1294 VGND VGND VPWR VPWR sky130_fd_sc_hd__decap_6
XFILLER_217_953 VPWR VGND VPWR VGND sky130_ef_sc_hd__decap_12
XFILLER_186_1441 VPWR VGND VPWR VGND sky130_ef_sc_hd__decap_12
XTAP_TAPCELL_ROW_180_1866 VGND VPWR sky130_fd_sc_hd__tapvpwrvgnd_1
XFILLER_21_1256 VPWR VGND VPWR VGND sky130_ef_sc_hd__decap_12
XFILLER_204_625 VPWR VGND VPWR VGND sky130_ef_sc_hd__decap_12
XFILLER_203_113 VPWR VGND VPWR VGND sky130_ef_sc_hd__decap_12
XFILLER_186_1485 VPWR VGND VPWR VGND sky130_ef_sc_hd__decap_12
XTAP_TAPCELL_ROW_180_1877 VGND VPWR sky130_fd_sc_hd__tapvpwrvgnd_1
XFILLER_204_669 VPWR VGND VPWR VGND sky130_ef_sc_hd__decap_12
XPHY_EDGE_ROW_130_1_Right_716 VGND VGND VPWR VPWR sky130_fd_sc_hd__decap_3
XFILLER_34_61 VGND VGND VPWR VPWR sky130_fd_sc_hd__fill_1
XFILLER_180_1073 VPWR VGND VPWR VGND sky130_ef_sc_hd__decap_12
XFILLER_169_573 VPWR VGND VPWR VGND sky130_ef_sc_hd__decap_12
XFILLER_34_83 VGND VGND VPWR VPWR sky130_fd_sc_hd__fill_1
XTAP_TAPCELL_ROW_141_2_3893 VGND VPWR sky130_fd_sc_hd__tapvpwrvgnd_1
XFILLER_184_587 VGND VGND VPWR VPWR sky130_fd_sc_hd__fill_1
XFILLER_116_109 VPWR VGND VPWR VGND sky130_ef_sc_hd__decap_12
XFILLER_197_1581 VPWR VGND VPWR VGND sky130_ef_sc_hd__decap_12
XFILLER_193_1401 VPWR VGND VPWR VGND sky130_ef_sc_hd__decap_12
XFILLER_172_749 VGND VGND VPWR VPWR sky130_fd_sc_hd__decap_6
XFILLER_171_237 VPWR VGND VPWR VGND sky130_ef_sc_hd__decap_12
XFILLER_4_962 VPWR VGND VPWR VGND sky130_ef_sc_hd__decap_12
XFILLER_180_793 VPWR VGND VPWR VGND sky130_ef_sc_hd__decap_12
XTAP_TAPCELL_ROW_88_2_3552 VGND VPWR sky130_fd_sc_hd__tapvpwrvgnd_1
XFILLER_3_461 VPWR VGND VPWR VGND sky130_ef_sc_hd__decap_12
XFILLER_6_1217 VPWR VGND VPWR VGND sky130_ef_sc_hd__decap_12
XFILLER_207_441 VGND VGND VPWR VPWR sky130_fd_sc_hd__decap_6
XFILLER_130_1462 VGND VGND VPWR VPWR sky130_fd_sc_hd__decap_6
XTAP_TAPCELL_ROW_81_2_3506 VGND VPWR sky130_fd_sc_hd__tapvpwrvgnd_1
XFILLER_207_485 VPWR VGND VPWR VGND sky130_ef_sc_hd__decap_12
XFILLER_165_1525 VPWR VGND VPWR VGND sky130_ef_sc_hd__decap_12
XANTENNA__494__B net122 VGND VGND VPWR VPWR sky130_fd_sc_hd__diode_2
XFILLER_201_55 VGND VGND VPWR VPWR sky130_fd_sc_hd__fill_1
XFILLER_179_337 VPWR VGND VPWR VGND sky130_ef_sc_hd__decap_12
XFILLER_165_1569 VPWR VGND VPWR VGND sky130_ef_sc_hd__decap_12
XFILLER_206_1533 VGND VGND VPWR VPWR sky130_fd_sc_hd__decap_6
XFILLER_206_1577 VPWR VGND VPWR VGND sky130_ef_sc_hd__decap_12
XFILLER_194_307 VGND VGND VPWR VPWR sky130_fd_sc_hd__fill_1
XFILLER_188_893 VPWR VGND VPWR VGND sky130_ef_sc_hd__decap_12
XFILLER_37_1274 VPWR VGND VPWR VGND sky130_ef_sc_hd__decap_12
XFILLER_124_1244 VGND VGND VPWR VPWR sky130_fd_sc_hd__fill_1
XTAP_TAPCELL_ROW_29_2_3167 VGND VPWR sky130_fd_sc_hd__tapvpwrvgnd_1
XTAP_TAPCELL_ROW_30_2_3173 VGND VPWR sky130_fd_sc_hd__tapvpwrvgnd_1
XTAP_TAPCELL_ROW_190_2162 VGND VPWR sky130_fd_sc_hd__tapvpwrvgnd_1
XTAP_TAPCELL_ROW_190_2151 VGND VPWR sky130_fd_sc_hd__tapvpwrvgnd_1
XFILLER_190_513 VPWR VGND VPWR VGND sky130_ef_sc_hd__decap_12
XTAP_TAPCELL_ROW_215_2880 VGND VPWR sky130_fd_sc_hd__tapvpwrvgnd_1
XTAP_TAPCELL_ROW_211_2755 VGND VPWR sky130_fd_sc_hd__tapvpwrvgnd_1
XTAP_TAPCELL_ROW_211_2744 VGND VPWR sky130_fd_sc_hd__tapvpwrvgnd_1
XPHY_EDGE_ROW_203_Left_422 VGND VGND VPWR VPWR sky130_fd_sc_hd__decap_3
XFILLER_196_1091 VGND VGND VPWR VPWR sky130_fd_sc_hd__fill_1
XFILLER_190_557 VPWR VGND VPWR VGND sky130_ef_sc_hd__decap_12
XTAP_TAPCELL_ROW_211_2766 VGND VPWR sky130_fd_sc_hd__tapvpwrvgnd_1
XTAP_TAPCELL_ROW_188_2091 VGND VPWR sky130_fd_sc_hd__tapvpwrvgnd_1
XPHY_EDGE_ROW_122_2_Left_554 VGND VGND VPWR VPWR sky130_fd_sc_hd__decap_3
XFILLER_39_39 VPWR VGND VPWR VGND sky130_ef_sc_hd__decap_12
XFILLER_48_1370 VPWR VGND VPWR VGND sky130_ef_sc_hd__decap_12
XFILLER_213_1537 VPWR VGND VPWR VGND sky130_ef_sc_hd__decap_12
XFILLER_170_1253 VGND VGND VPWR VPWR sky130_fd_sc_hd__decap_6
XFILLER_162_29 VPWR VGND VPWR VGND sky130_ef_sc_hd__decap_12
XFILLER_83_1272 VGND VGND VPWR VPWR sky130_fd_sc_hd__fill_1
XFILLER_217_205 VPWR VGND VPWR VGND sky130_ef_sc_hd__decap_12
XFILLER_135_1384 VGND VGND VPWR VPWR sky130_fd_sc_hd__fill_1
XTAP_TAPCELL_ROW_209_2695 VGND VPWR sky130_fd_sc_hd__tapvpwrvgnd_1
XTAP_TAPCELL_ROW_209_2684 VGND VPWR sky130_fd_sc_hd__tapvpwrvgnd_1
XFILLER_170_1297 VPWR VGND VPWR VGND sky130_ef_sc_hd__decap_12
XTAP_TAPCELL_ROW_135_1_1287 VGND VPWR sky130_fd_sc_hd__tapvpwrvgnd_1
XPHY_EDGE_ROW_2_Right_2 VGND VGND VPWR VPWR sky130_fd_sc_hd__decap_3
XFILLER_217_249 VPWR VGND VPWR VGND sky130_ef_sc_hd__decap_12
XPHY_EDGE_ROW_212_Left_431 VGND VGND VPWR VPWR sky130_fd_sc_hd__decap_3
XTAP_TAPCELL_ROW_159_2_4010 VGND VPWR sky130_fd_sc_hd__tapvpwrvgnd_1
XTAP_TAPCELL_ROW_40_1_1098 VGND VPWR sky130_fd_sc_hd__tapvpwrvgnd_1
XFILLER_214_923 VGND VGND VPWR VPWR sky130_fd_sc_hd__fill_1
XFILLER_198_613 VPWR VGND VPWR VGND sky130_ef_sc_hd__decap_12
XTAP_TAPCELL_ROW_197_2349 VGND VPWR sky130_fd_sc_hd__tapvpwrvgnd_1
XFILLER_164_1035 VGND VGND VPWR VPWR sky130_fd_sc_hd__fill_1
XFILLER_111_55 VGND VGND VPWR VPWR sky130_fd_sc_hd__fill_1
XFILLER_201_617 VPWR VGND VPWR VGND sky130_ef_sc_hd__decap_12
XFILLER_198_657 VPWR VGND VPWR VGND sky130_ef_sc_hd__decap_12
XFILLER_90_1232 VPWR VGND VPWR VGND sky130_ef_sc_hd__decap_12
XFILLER_71_15 VPWR VGND VPWR VGND sky130_ef_sc_hd__decap_12
XFILLER_55_1330 VPWR VGND VPWR VGND sky130_ef_sc_hd__decap_12
XFILLER_205_1021 VPWR VGND VPWR VGND sky130_ef_sc_hd__decap_12
XFILLER_197_167 VGND VGND VPWR VPWR sky130_fd_sc_hd__fill_1
XFILLER_187_15 VPWR VGND VPWR VGND sky130_ef_sc_hd__decap_12
XFILLER_185_329 VGND VGND VPWR VPWR sky130_fd_sc_hd__decap_6
XFILLER_142_1300 VGND VGND VPWR VPWR sky130_fd_sc_hd__fill_1
XTAP_TAPCELL_ROW_126_2_3795 VGND VPWR sky130_fd_sc_hd__tapvpwrvgnd_1
XFILLER_107_1442 VPWR VGND VPWR VGND sky130_ef_sc_hd__decap_12
XFILLER_16_1314 VPWR VGND VPWR VGND sky130_ef_sc_hd__decap_12
XFILLER_205_1065 VPWR VGND VPWR VGND sky130_ef_sc_hd__decap_12
XFILLER_181_1393 VGND VGND VPWR VPWR sky130_fd_sc_hd__decap_6
XFILLER_16_1358 VPWR VGND VPWR VGND sky130_ef_sc_hd__decap_12
XFILLER_166_587 VGND VGND VPWR VPWR sky130_fd_sc_hd__fill_1
XFILLER_103_1328 VGND VGND VPWR VPWR sky130_fd_sc_hd__fill_1
XFILLER_193_373 VPWR VGND VPWR VGND sky130_ef_sc_hd__decap_12
XTAP_TAPCELL_ROW_173_1681 VGND VPWR sky130_fd_sc_hd__tapvpwrvgnd_1
XTAP_TAPCELL_ROW_173_1670 VGND VPWR sky130_fd_sc_hd__tapvpwrvgnd_1
XFILLER_112_3 VPWR VGND VPWR VGND sky130_ef_sc_hd__decap_12
XFILLER_5_737 VPWR VGND VPWR VGND sky130_ef_sc_hd__decap_12
XTAP_TAPCELL_ROW_74_2_3460 VGND VPWR sky130_fd_sc_hd__tapvpwrvgnd_1
XFILLER_20_41 VGND VGND VPWR VPWR sky130_fd_sc_hd__fill_1
XFILLER_136_41 VPWR VGND VPWR VGND sky130_ef_sc_hd__decap_12
XPHY_EDGE_ROW_54_2_Left_486 VGND VGND VPWR VPWR sky130_fd_sc_hd__decap_3
XFILLER_175_1175 VGND VGND VPWR VPWR sky130_fd_sc_hd__fill_1
XFILLER_136_85 VPWR VGND VPWR VGND sky130_ef_sc_hd__decap_12
XFILLER_66_1470 VPWR VGND VPWR VGND sky130_ef_sc_hd__decap_12
XFILLER_0_431 VGND VGND VPWR VPWR sky130_fd_sc_hd__decap_3
XFILLER_27_1410 VPWR VGND VPWR VGND sky130_ef_sc_hd__decap_12
XFILLER_216_1161 VPWR VGND VPWR VGND sky130_ef_sc_hd__decap_12
XFILLER_153_1440 VGND VGND VPWR VPWR sky130_fd_sc_hd__fill_1
XFILLER_118_1582 VPWR VGND VPWR VGND sky130_ef_sc_hd__decap_12
XFILLER_1_965 VPWR VGND VPWR VGND sky130_ef_sc_hd__decap_12
XFILLER_0_453 VGND VGND VPWR VPWR sky130_fd_sc_hd__fill_2
XFILLER_7_1537 VGND VGND VPWR VPWR sky130_fd_sc_hd__decap_3
XFILLER_27_1454 VPWR VGND VPWR VGND sky130_ef_sc_hd__decap_12
XTAP_TAPCELL_ROW_182_1917 VGND VPWR sky130_fd_sc_hd__tapvpwrvgnd_1
XANTENNA_input32_A func_wdata[28] VGND VGND VPWR VPWR sky130_fd_sc_hd__diode_2
XFILLER_0_486 VGND VGND VPWR VPWR sky130_fd_sc_hd__fill_2
XFILLER_27_1498 VPWR VGND VPWR VGND sky130_ef_sc_hd__decap_12
XFILLER_62_1356 VGND VGND VPWR VPWR sky130_fd_sc_hd__fill_1
XTAP_TAPCELL_ROW_182_1939 VGND VPWR sky130_fd_sc_hd__tapvpwrvgnd_1
XTAP_TAPCELL_ROW_182_1928 VGND VPWR sky130_fd_sc_hd__tapvpwrvgnd_1
XTAP_TAPCELL_ROW_167_1496 VGND VPWR sky130_fd_sc_hd__tapvpwrvgnd_1
XFILLER_114_1468 VGND VGND VPWR VPWR sky130_fd_sc_hd__fill_1
XTAP_TAPCELL_ROW_163_1349 VGND VPWR sky130_fd_sc_hd__tapvpwrvgnd_1
XTAP_TAPCELL_ROW_66_2_3408 VGND VPWR sky130_fd_sc_hd__tapvpwrvgnd_1
XPHY_EDGE_ROW_47_2_Right_104 VGND VGND VPWR VPWR sky130_fd_sc_hd__decap_3
XFILLER_217_783 VGND VGND VPWR VPWR sky130_fd_sc_hd__fill_1
XFILLER_205_945 VGND VGND VPWR VPWR sky130_fd_sc_hd__decap_6
XFILLER_204_433 VPWR VGND VPWR VGND sky130_ef_sc_hd__decap_12
XFILLER_147_1244 VPWR VGND VPWR VGND sky130_ef_sc_hd__decap_12
X_596_ clknet_3_4_0_clk _030_ VGND VGND VPWR VPWR net83 sky130_fd_sc_hd__dfxtp_1
XFILLER_1_1169 VGND VGND VPWR VPWR sky130_fd_sc_hd__decap_6
XFILLER_205_989 VPWR VGND VPWR VGND sky130_ef_sc_hd__decap_12
XFILLER_204_477 VPWR VGND VPWR VGND sky130_ef_sc_hd__decap_12
XPHY_EDGE_ROW_131_1_Right_717 VGND VGND VPWR VPWR sky130_fd_sc_hd__decap_3
XFILLER_38_1550 VPWR VGND VPWR VGND sky130_ef_sc_hd__decap_12
XFILLER_188_189 VGND VGND VPWR VPWR sky130_fd_sc_hd__decap_6
XFILLER_176_307 VGND VGND VPWR VPWR sky130_fd_sc_hd__fill_1
XTAP_TAPCELL_ROW_15_2_3075 VGND VPWR sky130_fd_sc_hd__tapvpwrvgnd_1
XFILLER_34_1414 VPWR VGND VPWR VGND sky130_ef_sc_hd__decap_12
XFILLER_38_1594 VGND VGND VPWR VPWR sky130_fd_sc_hd__decap_8
XFILLER_185_841 VPWR VGND VPWR VGND sky130_ef_sc_hd__decap_12
XPHY_EDGE_ROW_118_1_Left_337 VGND VGND VPWR VPWR sky130_fd_sc_hd__decap_3
XFILLER_73_1496 VGND VGND VPWR VPWR sky130_fd_sc_hd__fill_1
XANTENNA__620__CLK clknet_3_3_0_clk VGND VGND VPWR VPWR sky130_fd_sc_hd__diode_2
XFILLER_61_81 VPWR VGND VPWR VGND sky130_ef_sc_hd__decap_12
XFILLER_177_81 VPWR VGND VPWR VGND sky130_ef_sc_hd__decap_12
XFILLER_172_513 VPWR VGND VPWR VGND sky130_ef_sc_hd__decap_12
XFILLER_172_557 VPWR VGND VPWR VGND sky130_ef_sc_hd__decap_12
XFILLER_193_1231 VGND VGND VPWR VPWR sky130_fd_sc_hd__fill_1
XFILLER_67_1256 VPWR VGND VPWR VGND sky130_ef_sc_hd__decap_12
XFILLER_45_1510 VPWR VGND VPWR VGND sky130_ef_sc_hd__decap_12
XFILLER_80_1412 VGND VGND VPWR VPWR sky130_fd_sc_hd__fill_1
XFILLER_45_1554 VPWR VGND VPWR VGND sky130_ef_sc_hd__decap_12
XFILLER_132_1524 VGND VGND VPWR VPWR sky130_fd_sc_hd__fill_1
XTAP_TAPCELL_ROW_7_1020 VGND VPWR sky130_fd_sc_hd__tapvpwrvgnd_1
XTAP_TAPCELL_ROW_7_1031 VGND VPWR sky130_fd_sc_hd__tapvpwrvgnd_1
XFILLER_215_709 VPWR VGND VPWR VGND sky130_ef_sc_hd__decap_12
XFILLER_212_65 VPWR VGND VPWR VGND sky130_ef_sc_hd__decap_12
XFILLER_187_1057 VGND VGND VPWR VPWR sky130_fd_sc_hd__decap_6
XFILLER_130_1270 VPWR VGND VPWR VGND sky130_ef_sc_hd__decap_12
XFILLER_207_293 VPWR VGND VPWR VGND sky130_ef_sc_hd__decap_12
XTAP_TAPCELL_ROW_200_2434 VGND VPWR sky130_fd_sc_hd__tapvpwrvgnd_1
XTAP_TAPCELL_ROW_200_2445 VGND VPWR sky130_fd_sc_hd__tapvpwrvgnd_1
XFILLER_206_1341 VPWR VGND VPWR VGND sky130_ef_sc_hd__decap_12
XTAP_TAPCELL_ROW_192_2224 VGND VPWR sky130_fd_sc_hd__tapvpwrvgnd_1
XTAP_TAPCELL_ROW_192_2213 VGND VPWR sky130_fd_sc_hd__tapvpwrvgnd_1
XTAP_TAPCELL_ROW_192_2202 VGND VPWR sky130_fd_sc_hd__tapvpwrvgnd_1
XFILLER_179_167 VGND VGND VPWR VPWR sky130_fd_sc_hd__fill_1
XFILLER_167_329 VGND VGND VPWR VPWR sky130_fd_sc_hd__decap_6
XFILLER_165_1399 VGND VGND VPWR VPWR sky130_fd_sc_hd__fill_1
XFILLER_91_1552 VGND VGND VPWR VPWR sky130_fd_sc_hd__fill_1
XTAP_TAPCELL_ROW_217_2931 VGND VPWR sky130_fd_sc_hd__tapvpwrvgnd_1
XTAP_TAPCELL_ROW_217_2920 VGND VPWR sky130_fd_sc_hd__tapvpwrvgnd_1
XFILLER_210_469 VGND VGND VPWR VPWR sky130_fd_sc_hd__decap_6
XFILLER_206_1385 VPWR VGND VPWR VGND sky130_ef_sc_hd__decap_12
XFILLER_202_1205 VPWR VGND VPWR VGND sky130_ef_sc_hd__decap_12
XTAP_TAPCELL_ROW_213_2806 VGND VPWR sky130_fd_sc_hd__tapvpwrvgnd_1
XTAP_TAPCELL_ROW_16_1_1049 VGND VPWR sky130_fd_sc_hd__tapvpwrvgnd_1
XTAP_TAPCELL_ROW_213_2817 VGND VPWR sky130_fd_sc_hd__tapvpwrvgnd_1
XFILLER_191_833 VGND VGND VPWR VPWR sky130_fd_sc_hd__decap_6
XFILLER_190_321 VPWR VGND VPWR VGND sky130_ef_sc_hd__decap_12
XFILLER_175_373 VPWR VGND VPWR VGND sky130_ef_sc_hd__decap_12
XFILLER_198_1197 VGND VGND VPWR VPWR sky130_fd_sc_hd__decap_6
XFILLER_194_1017 VPWR VGND VPWR VGND sky130_ef_sc_hd__decap_12
XFILLER_191_877 VPWR VGND VPWR VGND sky130_ef_sc_hd__decap_12
XFILLER_163_557 VGND VGND VPWR VPWR sky130_fd_sc_hd__decap_3
XFILLER_102_1350 VGND VGND VPWR VPWR sky130_fd_sc_hd__decap_6
XFILLER_11_1244 VPWR VGND VPWR VGND sky130_ef_sc_hd__decap_12
XFILLER_50_1282 VPWR VGND VPWR VGND sky130_ef_sc_hd__decap_12
XTAP_TAPCELL_ROW_59_2_3362 VGND VPWR sky130_fd_sc_hd__tapvpwrvgnd_1
XFILLER_190_365 VPWR VGND VPWR VGND sky130_ef_sc_hd__decap_12
XFILLER_102_1394 VPWR VGND VPWR VGND sky130_ef_sc_hd__decap_12
XFILLER_2_718 VGND VGND VPWR VPWR sky130_fd_sc_hd__decap_8
XTAP_TAPCELL_ROW_186_2039 VGND VPWR sky130_fd_sc_hd__tapvpwrvgnd_1
XTAP_TAPCELL_ROW_186_2028 VGND VPWR sky130_fd_sc_hd__tapvpwrvgnd_1
XFILLER_173_39 VPWR VGND VPWR VGND sky130_ef_sc_hd__decap_12
XFILLER_172_1315 VGND VGND VPWR VPWR sky130_fd_sc_hd__fill_1
XFILLER_85_1378 VGND VGND VPWR VPWR sky130_fd_sc_hd__decap_6
XFILLER_217_1481 VPWR VGND VPWR VGND sky130_ef_sc_hd__decap_12
XFILLER_213_1301 VPWR VGND VPWR VGND sky130_ef_sc_hd__decap_12
XFILLER_150_1602 VGND VGND VPWR VPWR sky130_fd_sc_hd__decap_3
XFILLER_213_1345 VPWR VGND VPWR VGND sky130_ef_sc_hd__decap_12
XFILLER_170_1061 VPWR VGND VPWR VGND sky130_ef_sc_hd__decap_12
XFILLER_106_77 VGND VGND VPWR VPWR sky130_fd_sc_hd__decap_6
XFILLER_66_15 VPWR VGND VPWR VGND sky130_ef_sc_hd__decap_12
XFILLER_218_525 VGND VGND VPWR VPWR sky130_fd_sc_hd__decap_6
XTAP_TAPCELL_ROW_52_2_3316 VGND VPWR sky130_fd_sc_hd__tapvpwrvgnd_1
XFILLER_218_569 VPWR VGND VPWR VGND sky130_ef_sc_hd__decap_12
XTAP_TAPCELL_ROW_71_1_1159 VGND VPWR sky130_fd_sc_hd__tapvpwrvgnd_1
XFILLER_122_65 VPWR VGND VPWR VGND sky130_ef_sc_hd__decap_12
XFILLER_113_1490 VGND VGND VPWR VPWR sky130_fd_sc_hd__decap_6
XFILLER_199_933 VPWR VGND VPWR VGND sky130_ef_sc_hd__decap_12
XFILLER_198_421 VPWR VGND VPWR VGND sky130_ef_sc_hd__decap_12
X_450_ net145 net102 VGND VGND VPWR VPWR _182_ sky130_fd_sc_hd__xor2_1
XANTENNA__565__D net157 VGND VGND VPWR VPWR sky130_fd_sc_hd__diode_2
XFILLER_199_977 VPWR VGND VPWR VGND sky130_ef_sc_hd__decap_12
XFILLER_183_1455 VGND VGND VPWR VPWR sky130_fd_sc_hd__fill_1
XFILLER_144_1406 VGND VGND VPWR VPWR sky130_fd_sc_hd__decap_6
XFILLER_92_1338 VPWR VGND VPWR VGND sky130_ef_sc_hd__decap_12
X_381_ _084_ _103_ b_addr\[1\] VGND VGND VPWR VPWR _120_ sky130_fd_sc_hd__a21o_1
XFILLER_202_937 VPWR VGND VPWR VGND sky130_ef_sc_hd__decap_12
XFILLER_40_121 VGND VGND VPWR VPWR sky130_fd_sc_hd__decap_6
XFILLER_201_447 VGND VGND VPWR VPWR sky130_fd_sc_hd__fill_1
XFILLER_185_137 VPWR VGND VPWR VGND sky130_ef_sc_hd__decap_12
XTAP_TAPCELL_ROW_175_1732 VGND VPWR sky130_fd_sc_hd__tapvpwrvgnd_1
XTAP_TAPCELL_ROW_175_1721 VGND VPWR sky130_fd_sc_hd__tapvpwrvgnd_1
XFILLER_167_841 VPWR VGND VPWR VGND sky130_ef_sc_hd__decap_12
XFILLER_210_981 VPWR VGND VPWR VGND sky130_ef_sc_hd__decap_12
XFILLER_182_811 VGND VGND VPWR VPWR sky130_fd_sc_hd__fill_1
XTAP_TAPCELL_ROW_156_2_3990 VGND VPWR sky130_fd_sc_hd__tapvpwrvgnd_1
XFILLER_107_1272 VGND VGND VPWR VPWR sky130_fd_sc_hd__fill_1
XFILLER_194_693 VGND VGND VPWR VPWR sky130_fd_sc_hd__decap_6
XTAP_TAPCELL_ROW_171_1618 VGND VPWR sky130_fd_sc_hd__tapvpwrvgnd_1
XTAP_TAPCELL_ROW_171_1607 VGND VPWR sky130_fd_sc_hd__tapvpwrvgnd_1
XFILLER_193_181 VPWR VGND VPWR VGND sky130_ef_sc_hd__decap_12
XFILLER_147_51 VGND VGND VPWR VPWR sky130_fd_sc_hd__decap_4
XFILLER_120_1450 VPWR VGND VPWR VGND sky130_ef_sc_hd__decap_12
XFILLER_5_545 VGND VGND VPWR VPWR sky130_fd_sc_hd__fill_1
XFILLER_120_1494 VPWR VGND VPWR VGND sky130_ef_sc_hd__decap_12
XFILLER_194_1595 VGND VGND VPWR VPWR sky130_fd_sc_hd__fill_1
XFILLER_155_1546 VGND VGND VPWR VPWR sky130_fd_sc_hd__decap_6
Xoutput51 net51 VGND VGND VPWR VPWR bist_fail_addr[2] sky130_fd_sc_hd__buf_2
XTAP_TAPCELL_ROW_169_1558 VGND VPWR sky130_fd_sc_hd__tapvpwrvgnd_1
XTAP_TAPCELL_ROW_169_1547 VGND VPWR sky130_fd_sc_hd__tapvpwrvgnd_1
Xoutput73 net73 VGND VGND VPWR VPWR bist_fail_bits[24] sky130_fd_sc_hd__buf_2
Xoutput62 net62 VGND VGND VPWR VPWR bist_fail_bits[14] sky130_fd_sc_hd__buf_2
Xoutput84 net84 VGND VGND VPWR VPWR bist_fail_bits[5] sky130_fd_sc_hd__buf_2
XFILLER_7_1301 VPWR VGND VPWR VGND sky130_ef_sc_hd__decap_12
XFILLER_209_503 VGND VGND VPWR VPWR sky130_fd_sc_hd__fill_1
XTAP_TAPCELL_ROW_169_1569 VGND VPWR sky130_fd_sc_hd__tapvpwrvgnd_1
XTAP_TAPCELL_ROW_148_2_3938 VGND VPWR sky130_fd_sc_hd__tapvpwrvgnd_1
XFILLER_0_250 VGND VGND VPWR VPWR sky130_fd_sc_hd__fill_2
Xoutput95 net95 VGND VGND VPWR VPWR func_rdata[15] sky130_fd_sc_hd__buf_2
XFILLER_7_1345 VPWR VGND VPWR VGND sky130_ef_sc_hd__decap_12
XFILLER_114_1232 VPWR VGND VPWR VGND sky130_ef_sc_hd__decap_12
XFILLER_149_1328 VGND VGND VPWR VPWR sky130_fd_sc_hd__fill_1
XFILLER_131_1590 VPWR VGND VPWR VGND sky130_ef_sc_hd__decap_12
XFILLER_40_1462 VGND VGND VPWR VPWR sky130_fd_sc_hd__decap_6
XTAP_TAPCELL_ROW_96_2_3603 VGND VPWR sky130_fd_sc_hd__tapvpwrvgnd_1
XPHY_EDGE_ROW_48_2_Right_105 VGND VGND VPWR VPWR sky130_fd_sc_hd__decap_3
XFILLER_205_753 VPWR VGND VPWR VGND sky130_ef_sc_hd__decap_12
XFILLER_162_1506 VPWR VGND VPWR VGND sky130_ef_sc_hd__decap_12
XFILLER_205_797 VPWR VGND VPWR VGND sky130_ef_sc_hd__decap_12
X_579_ clknet_3_1_0_clk _003_ VGND VGND VPWR VPWR net47 sky130_fd_sc_hd__dfxtp_1
XPHY_EDGE_ROW_132_1_Right_718 VGND VGND VPWR VPWR sky130_fd_sc_hd__decap_3
XFILLER_203_1525 VPWR VGND VPWR VGND sky130_ef_sc_hd__decap_12
XFILLER_75_3 VPWR VGND VPWR VGND sky130_ef_sc_hd__decap_12
XFILLER_34_1244 VGND VGND VPWR VPWR sky130_fd_sc_hd__fill_1
XFILLER_203_1569 VPWR VGND VPWR VGND sky130_ef_sc_hd__decap_12
XFILLER_185_671 VGND VGND VPWR VPWR sky130_fd_sc_hd__fill_1
XFILLER_173_833 VGND VGND VPWR VPWR sky130_fd_sc_hd__decap_6
XTAP_TAPCELL_ROW_45_2_3270 VGND VPWR sky130_fd_sc_hd__tapvpwrvgnd_1
XFILLER_219_1009 VPWR VGND VPWR VGND sky130_ef_sc_hd__decap_12
XFILLER_195_1337 VGND VGND VPWR VPWR sky130_fd_sc_hd__decap_6
XFILLER_173_877 VPWR VGND VPWR VGND sky130_ef_sc_hd__decap_12
XFILLER_172_321 VPWR VGND VPWR VGND sky130_ef_sc_hd__decap_12
XFILLER_172_365 VPWR VGND VPWR VGND sky130_ef_sc_hd__decap_12
XFILLER_98_121 VGND VGND VPWR VPWR sky130_fd_sc_hd__decap_6
XFILLER_82_1518 VGND VGND VPWR VPWR sky130_fd_sc_hd__decap_6
XFILLER_80_1220 VPWR VGND VPWR VGND sky130_ef_sc_hd__decap_12
XTAP_TAPCELL_ROW_37_2_3218 VGND VPWR sky130_fd_sc_hd__tapvpwrvgnd_1
XTAP_TAPCELL_ROW_206_2621 VGND VPWR sky130_fd_sc_hd__tapvpwrvgnd_1
XTAP_TAPCELL_ROW_206_2610 VGND VPWR sky130_fd_sc_hd__tapvpwrvgnd_1
XFILLER_189_1119 VGND VGND VPWR VPWR sky130_fd_sc_hd__fill_1
XFILLER_171_1381 VPWR VGND VPWR VGND sky130_ef_sc_hd__decap_12
XFILLER_45_1384 VGND VGND VPWR VPWR sky130_fd_sc_hd__fill_1
XFILLER_215_517 VPWR VGND VPWR VGND sky130_ef_sc_hd__decap_12
XTAP_TAPCELL_ROW_202_2507 VGND VPWR sky130_fd_sc_hd__tapvpwrvgnd_1
XFILLER_36_29 VPWR VGND VPWR VGND sky130_ef_sc_hd__decap_12
XFILLER_196_925 VPWR VGND VPWR VGND sky130_ef_sc_hd__decap_12
XFILLER_210_233 VPWR VGND VPWR VGND sky130_ef_sc_hd__decap_12
XFILLER_167_137 VPWR VGND VPWR VGND sky130_ef_sc_hd__decap_12
XFILLER_17_1442 VPWR VGND VPWR VGND sky130_ef_sc_hd__decap_12
XFILLER_52_1300 VGND VGND VPWR VPWR sky130_fd_sc_hd__fill_1
XFILLER_210_277 VPWR VGND VPWR VGND sky130_ef_sc_hd__decap_12
XFILLER_104_1412 VGND VGND VPWR VPWR sky130_fd_sc_hd__fill_1
XFILLER_202_1035 VGND VGND VPWR VPWR sky130_fd_sc_hd__fill_1
XFILLER_176_693 VGND VGND VPWR VPWR sky130_fd_sc_hd__decap_6
XFILLER_164_811 VGND VGND VPWR VPWR sky130_fd_sc_hd__fill_1
XFILLER_6_309 VPWR VGND VPWR VGND sky130_ef_sc_hd__decap_12
XFILLER_13_1328 VGND VGND VPWR VPWR sky130_fd_sc_hd__fill_1
XFILLER_191_641 VPWR VGND VPWR VGND sky130_ef_sc_hd__decap_12
XFILLER_184_27 VGND VGND VPWR VPWR sky130_fd_sc_hd__fill_1
XFILLER_175_181 VPWR VGND VPWR VGND sky130_ef_sc_hd__decap_12
XFILLER_163_321 VPWR VGND VPWR VGND sky130_ef_sc_hd__decap_12
XFILLER_191_685 VPWR VGND VPWR VGND sky130_ef_sc_hd__decap_12
XFILLER_163_365 VPWR VGND VPWR VGND sky130_ef_sc_hd__decap_12
XFILLER_219_1565 VGND VGND VPWR VPWR sky130_fd_sc_hd__decap_3
XFILLER_190_195 VGND VGND VPWR VPWR sky130_fd_sc_hd__fill_1
XFILLER_137_1232 VPWR VGND VPWR VGND sky130_ef_sc_hd__decap_12
XTAP_TAPCELL_ROW_134_2_3846 VGND VPWR sky130_fd_sc_hd__tapvpwrvgnd_1
XFILLER_137_1298 VPWR VGND VPWR VGND sky130_ef_sc_hd__decap_12
XFILLER_77_69 VPWR VGND VPWR VGND sky130_ef_sc_hd__decap_12
XFILLER_63_1440 VGND VGND VPWR VPWR sky130_fd_sc_hd__fill_1
XFILLER_28_1582 VPWR VGND VPWR VGND sky130_ef_sc_hd__decap_12
XTAP_TAPCELL_ROW_164_1411 VGND VPWR sky130_fd_sc_hd__tapvpwrvgnd_1
XTAP_TAPCELL_ROW_164_1400 VGND VPWR sky130_fd_sc_hd__tapvpwrvgnd_1
XFILLER_115_1552 VGND VGND VPWR VPWR sky130_fd_sc_hd__fill_1
XFILLER_218_333 VPWR VGND VPWR VGND sky130_ef_sc_hd__decap_12
XFILLER_213_1175 VGND VGND VPWR VPWR sky130_fd_sc_hd__fill_1
XTAP_TAPCELL_ROW_164_1422 VGND VPWR sky130_fd_sc_hd__tapvpwrvgnd_1
XPHY_EDGE_ROW_163_Left_382 VGND VGND VPWR VPWR sky130_fd_sc_hd__decap_3
XTAP_TAPCELL_ROW_114_2_3722 VGND VPWR sky130_fd_sc_hd__tapvpwrvgnd_1
XFILLER_24_1468 VGND VGND VPWR VPWR sky130_fd_sc_hd__fill_1
XFILLER_218_377 VPWR VGND VPWR VGND sky130_ef_sc_hd__decap_12
XFILLER_93_57 VPWR VGND VPWR VGND sky130_ef_sc_hd__decap_12
XTAP_TAPCELL_ROW_82_2_3511 VGND VPWR sky130_fd_sc_hd__tapvpwrvgnd_1
XFILLER_2_1253 VGND VGND VPWR VPWR sky130_fd_sc_hd__decap_6
X_502_ net175 net125 VGND VGND VPWR VPWR _225_ sky130_fd_sc_hd__or2_1
XFILLER_202_701 VPWR VGND VPWR VGND sky130_ef_sc_hd__decap_12
XFILLER_199_741 VPWR VGND VPWR VGND sky130_ef_sc_hd__decap_12
XFILLER_148_1350 VGND VGND VPWR VPWR sky130_fd_sc_hd__decap_6
XFILLER_96_1282 VPWR VGND VPWR VGND sky130_ef_sc_hd__decap_12
XFILLER_2_1297 VPWR VGND VPWR VGND sky130_ef_sc_hd__decap_12
XFILLER_26_73 VGND VGND VPWR VPWR sky130_fd_sc_hd__decap_8
X_433_ _157_ _160_ _164_ VGND VGND VPWR VPWR _166_ sky130_fd_sc_hd__or3_1
XFILLER_57_1244 VPWR VGND VPWR VGND sky130_ef_sc_hd__decap_12
XFILLER_199_785 VPWR VGND VPWR VGND sky130_ef_sc_hd__decap_12
XFILLER_198_251 VGND VGND VPWR VPWR sky130_fd_sc_hd__fill_1
XFILLER_186_413 VGND VGND VPWR VPWR sky130_fd_sc_hd__decap_6
XFILLER_148_1394 VPWR VGND VPWR VGND sky130_ef_sc_hd__decap_12
XFILLER_13_110 VGND VGND VPWR VPWR sky130_fd_sc_hd__fill_2
XFILLER_144_1258 VPWR VGND VPWR VGND sky130_ef_sc_hd__decap_12
XFILLER_109_1378 VGND VGND VPWR VPWR sky130_fd_sc_hd__decap_6
XFILLER_74_1580 VGND VGND VPWR VPWR sky130_fd_sc_hd__fill_1
X_364_ _105_ _106_ VGND VGND VPWR VPWR _107_ sky130_fd_sc_hd__or2_1
XANTENNA__329__A0 b_addr\[4\] VGND VGND VPWR VPWR sky130_fd_sc_hd__diode_2
XFILLER_186_457 VPWR VGND VPWR VGND sky130_ef_sc_hd__decap_12
X_295_ net34 net141 net131 VGND VGND VPWR VPWR s_wdata\[2\] sky130_fd_sc_hd__a21o_1
XPHY_EDGE_ROW_172_Left_391 VGND VGND VPWR VPWR sky130_fd_sc_hd__decap_3
XFILLER_167_671 VGND VGND VPWR VPWR sky130_fd_sc_hd__fill_1
XFILLER_42_83 VGND VGND VPWR VPWR sky130_fd_sc_hd__fill_1
XFILLER_177_1001 VGND VGND VPWR VPWR sky130_fd_sc_hd__decap_6
XFILLER_158_83 VGND VGND VPWR VPWR sky130_fd_sc_hd__fill_1
XFILLER_177_1045 VPWR VGND VPWR VGND sky130_ef_sc_hd__decap_12
XFILLER_170_825 VPWR VGND VPWR VGND sky130_ef_sc_hd__decap_12
XPHY_EDGE_ROW_14_2_Right_71 VGND VGND VPWR VPWR sky130_fd_sc_hd__decap_3
XFILLER_54_8 VPWR VGND VPWR VGND sky130_ef_sc_hd__decap_12
XFILLER_177_1089 VPWR VGND VPWR VGND sky130_ef_sc_hd__decap_12
XFILLER_170_869 VPWR VGND VPWR VGND sky130_ef_sc_hd__decap_12
XFILLER_159_1490 VGND VGND VPWR VPWR sky130_fd_sc_hd__decap_6
XFILLER_155_1310 VPWR VGND VPWR VGND sky130_ef_sc_hd__decap_12
XFILLER_155_1354 VPWR VGND VPWR VGND sky130_ef_sc_hd__decap_12
XANTENNA__501__B1 net135 VGND VGND VPWR VPWR sky130_fd_sc_hd__diode_2
XTAP_TAPCELL_ROW_23_2_3126 VGND VPWR sky130_fd_sc_hd__tapvpwrvgnd_1
XFILLER_155_1398 VPWR VGND VPWR VGND sky130_ef_sc_hd__decap_12
XFILLER_116_1338 VPWR VGND VPWR VGND sky130_ef_sc_hd__decap_12
XFILLER_95_113 VPWR VGND VPWR VGND sky130_ef_sc_hd__decap_12
XFILLER_3_55 VGND VGND VPWR VPWR sky130_fd_sc_hd__fill_1
XFILLER_1_581 VGND VGND VPWR VPWR sky130_fd_sc_hd__fill_2
XPHY_EDGE_ROW_17_2_Left_449 VGND VGND VPWR VPWR sky130_fd_sc_hd__decap_3
XFILLER_42_1524 VGND VGND VPWR VPWR sky130_fd_sc_hd__fill_1
XFILLER_188_1141 VGND VGND VPWR VPWR sky130_fd_sc_hd__decap_6
XFILLER_188_1185 VPWR VGND VPWR VGND sky130_ef_sc_hd__decap_12
XFILLER_184_1005 VPWR VGND VPWR VGND sky130_ef_sc_hd__decap_12
XFILLER_40_1270 VPWR VGND VPWR VGND sky130_ef_sc_hd__decap_12
XFILLER_205_561 VPWR VGND VPWR VGND sky130_ef_sc_hd__decap_12
XFILLER_184_1049 VPWR VGND VPWR VGND sky130_ef_sc_hd__decap_12
XFILLER_75_1322 VGND VGND VPWR VPWR sky130_fd_sc_hd__decap_6
XPHY_EDGE_ROW_49_2_Right_106 VGND VGND VPWR VPWR sky130_fd_sc_hd__decap_3
XFILLER_178_925 VPWR VGND VPWR VGND sky130_ef_sc_hd__decap_12
XFILLER_166_1483 VGND VGND VPWR VPWR sky130_fd_sc_hd__fill_1
XFILLER_162_1314 VPWR VGND VPWR VGND sky130_ef_sc_hd__decap_12
XFILLER_127_1434 VGND VGND VPWR VPWR sky130_fd_sc_hd__decap_6
XPHY_EDGE_ROW_79_2_Left_511 VGND VGND VPWR VPWR sky130_fd_sc_hd__decap_3
XFILLER_75_1366 VPWR VGND VPWR VGND sky130_ef_sc_hd__decap_12
XFILLER_189_273 VGND VGND VPWR VPWR sky130_fd_sc_hd__decap_6
XFILLER_162_1358 VPWR VGND VPWR VGND sky130_ef_sc_hd__decap_12
XPHY_EDGE_ROW_131_2_Left_563 VGND VGND VPWR VPWR sky130_fd_sc_hd__decap_3
XFILLER_127_1478 VPWR VGND VPWR VGND sky130_ef_sc_hd__decap_12
XPHY_EDGE_ROW_133_1_Right_719 VGND VGND VPWR VPWR sky130_fd_sc_hd__decap_3
XTAP_TAPCELL_ROW_140_2_3889 VGND VPWR sky130_fd_sc_hd__tapvpwrvgnd_1
XFILLER_203_1399 VGND VGND VPWR VPWR sky130_fd_sc_hd__fill_1
XFILLER_199_1281 VGND VGND VPWR VPWR sky130_fd_sc_hd__decap_6
XFILLER_195_1101 VPWR VGND VPWR VGND sky130_ef_sc_hd__decap_12
XFILLER_173_641 VPWR VGND VPWR VGND sky130_ef_sc_hd__decap_12
XFILLER_218_53 VPWR VGND VPWR VGND sky130_ef_sc_hd__decap_12
XFILLER_195_1145 VPWR VGND VPWR VGND sky130_ef_sc_hd__decap_12
XFILLER_173_685 VPWR VGND VPWR VGND sky130_ef_sc_hd__decap_12
XFILLER_12_1350 VGND VGND VPWR VPWR sky130_fd_sc_hd__decap_6
XFILLER_218_97 VPWR VGND VPWR VGND sky130_ef_sc_hd__decap_12
XFILLER_195_1189 VPWR VGND VPWR VGND sky130_ef_sc_hd__decap_12
XFILLER_191_1009 VPWR VGND VPWR VGND sky130_ef_sc_hd__decap_12
XFILLER_172_195 VGND VGND VPWR VPWR sky130_fd_sc_hd__fill_1
XFILLER_86_1462 VGND VGND VPWR VPWR sky130_fd_sc_hd__decap_6
XFILLER_12_1394 VPWR VGND VPWR VGND sky130_ef_sc_hd__decap_12
XFILLER_138_1574 VGND VGND VPWR VPWR sky130_fd_sc_hd__decap_6
XFILLER_82_1326 VPWR VGND VPWR VGND sky130_ef_sc_hd__decap_12
XFILLER_134_1438 VPWR VGND VPWR VGND sky130_ef_sc_hd__decap_12
Xfanout126 _214_ VGND VGND VPWR VPWR net126 sky130_fd_sc_hd__dlymetal6s2s_1
Xfanout137 net138 VGND VGND VPWR VPWR net137 sky130_fd_sc_hd__buf_2
XTAP_TAPCELL_ROW_100_2_3630 VGND VPWR sky130_fd_sc_hd__tapvpwrvgnd_1
Xfanout148 u_ctrl.cmp_exp\[0\] VGND VGND VPWR VPWR net148 sky130_fd_sc_hd__clkbuf_4
XFILLER_60_1602 VGND VGND VPWR VPWR sky130_fd_sc_hd__decap_3
XFILLER_210_1315 VGND VGND VPWR VPWR sky130_fd_sc_hd__fill_1
XFILLER_170_29 VPWR VGND VPWR VGND sky130_ef_sc_hd__decap_12
XTAP_TAPCELL_ROW_67_2_3413 VGND VPWR sky130_fd_sc_hd__tapvpwrvgnd_1
XFILLER_47_39 VPWR VGND VPWR VGND sky130_ef_sc_hd__decap_12
XTAP_TAPCELL_ROW_3_879 VGND VPWR sky130_fd_sc_hd__tapvpwrvgnd_1
XTAP_TAPCELL_ROW_3_868 VGND VPWR sky130_fd_sc_hd__tapvpwrvgnd_1
XFILLER_216_837 VPWR VGND VPWR VGND sky130_ef_sc_hd__decap_12
XFILLER_167_1225 VGND VGND VPWR VPWR sky130_fd_sc_hd__decap_6
XFILLER_23_1490 VGND VGND VPWR VPWR sky130_fd_sc_hd__decap_6
XFILLER_167_1269 VPWR VGND VPWR VGND sky130_ef_sc_hd__decap_12
XFILLER_110_1482 VPWR VGND VPWR VGND sky130_ef_sc_hd__decap_12
XFILLER_93_1422 VPWR VGND VPWR VGND sky130_ef_sc_hd__decap_12
XFILLER_63_27 VPWR VGND VPWR VGND sky130_ef_sc_hd__decap_12
Xclkbuf_3_2_0_clk clknet_0_clk VGND VGND VPWR VPWR clknet_3_2_0_clk sky130_fd_sc_hd__clkbuf_8
XFILLER_179_27 VPWR VGND VPWR VGND sky130_ef_sc_hd__decap_12
XFILLER_145_1534 VPWR VGND VPWR VGND sky130_ef_sc_hd__decap_12
XFILLER_93_1466 VPWR VGND VPWR VGND sky130_ef_sc_hd__decap_12
XPHY_EDGE_ROW_63_2_Left_495 VGND VGND VPWR VPWR sky130_fd_sc_hd__decap_3
XFILLER_54_1406 VGND VGND VPWR VPWR sky130_fd_sc_hd__decap_6
XFILLER_211_553 VGND VGND VPWR VPWR sky130_fd_sc_hd__decap_6
XFILLER_168_413 VGND VGND VPWR VPWR sky130_fd_sc_hd__decap_6
XFILLER_106_1518 VGND VGND VPWR VPWR sky130_fd_sc_hd__decap_6
XTAP_TAPCELL_ROW_16_2_3080 VGND VPWR sky130_fd_sc_hd__tapvpwrvgnd_1
XFILLER_196_755 VGND VGND VPWR VPWR sky130_fd_sc_hd__fill_1
XFILLER_184_917 VGND VGND VPWR VPWR sky130_fd_sc_hd__decap_6
XFILLER_183_405 VPWR VGND VPWR VGND sky130_ef_sc_hd__decap_12
XFILLER_168_457 VPWR VGND VPWR VGND sky130_ef_sc_hd__decap_12
XFILLER_145_1578 VPWR VGND VPWR VGND sky130_ef_sc_hd__decap_12
XFILLER_211_597 VPWR VGND VPWR VGND sky130_ef_sc_hd__decap_12
XFILLER_195_15 VPWR VGND VPWR VGND sky130_ef_sc_hd__decap_12
XFILLER_104_1220 VPWR VGND VPWR VGND sky130_ef_sc_hd__decap_12
XFILLER_17_1272 VGND VGND VPWR VPWR sky130_fd_sc_hd__fill_1
XFILLER_192_961 VPWR VGND VPWR VGND sky130_ef_sc_hd__decap_12
XFILLER_183_449 VPWR VGND VPWR VGND sky130_ef_sc_hd__decap_12
XFILLER_6_139 VGND VGND VPWR VPWR sky130_fd_sc_hd__fill_1
XFILLER_178_1365 VGND VGND VPWR VPWR sky130_fd_sc_hd__decap_6
XFILLER_128_53 VPWR VGND VPWR VGND sky130_ef_sc_hd__decap_12
XFILLER_30_1450 VPWR VGND VPWR VGND sky130_ef_sc_hd__decap_12
XFILLER_174_1229 VPWR VGND VPWR VGND sky130_ef_sc_hd__decap_12
XFILLER_128_97 VPWR VGND VPWR VGND sky130_ef_sc_hd__decap_12
XFILLER_30_1494 VPWR VGND VPWR VGND sky130_ef_sc_hd__decap_12
XFILLER_219_1373 VPWR VGND VPWR VGND sky130_ef_sc_hd__decap_12
XFILLER_65_1546 VGND VGND VPWR VPWR sky130_fd_sc_hd__decap_6
XFILLER_5_3 VPWR VGND VPWR VGND sky130_ef_sc_hd__decap_12
XFILLER_144_41 VPWR VGND VPWR VGND sky130_ef_sc_hd__decap_12
XFILLER_77_113 VPWR VGND VPWR VGND sky130_ef_sc_hd__decap_12
XFILLER_152_1538 VPWR VGND VPWR VGND sky130_ef_sc_hd__decap_12
XFILLER_144_85 VPWR VGND VPWR VGND sky130_ef_sc_hd__decap_12
XPHY_EDGE_ROW_127_1_Left_346 VGND VGND VPWR VPWR sky130_fd_sc_hd__decap_3
XFILLER_98_1300 VGND VGND VPWR VPWR sky130_fd_sc_hd__fill_1
XFILLER_4_1315 VGND VGND VPWR VPWR sky130_fd_sc_hd__fill_1
XFILLER_8_1462 VGND VGND VPWR VPWR sky130_fd_sc_hd__decap_6
XFILLER_24_1232 VPWR VGND VPWR VGND sky130_ef_sc_hd__decap_12
XFILLER_218_141 VPWR VGND VPWR VGND sky130_ef_sc_hd__decap_12
XFILLER_219_697 VGND VGND VPWR VPWR sky130_fd_sc_hd__decap_3
XFILLER_185_1325 VPWR VGND VPWR VGND sky130_ef_sc_hd__decap_12
XTAP_TAPCELL_ROW_158_2_4006 VGND VPWR sky130_fd_sc_hd__tapvpwrvgnd_1
XFILLER_111_1268 VGND VGND VPWR VPWR sky130_fd_sc_hd__decap_4
XFILLER_41_1590 VPWR VGND VPWR VGND sky130_ef_sc_hd__decap_12
XFILLER_59_1328 VGND VGND VPWR VPWR sky130_fd_sc_hd__fill_1
XFILLER_185_1369 VPWR VGND VPWR VGND sky130_ef_sc_hd__decap_12
XFILLER_2_1061 VPWR VGND VPWR VGND sky130_ef_sc_hd__decap_12
XFILLER_72_1506 VPWR VGND VPWR VGND sky130_ef_sc_hd__decap_12
XFILLER_202_531 VGND VGND VPWR VPWR sky130_fd_sc_hd__fill_1
XFILLER_186_221 VPWR VGND VPWR VGND sky130_ef_sc_hd__decap_12
X_416_ _149_ _150_ VGND VGND VPWR VPWR _151_ sky130_fd_sc_hd__or2_1
XFILLER_187_777 VGND VGND VPWR VPWR sky130_fd_sc_hd__decap_6
X_347_ net157 _094_ VGND VGND VPWR VPWR _010_ sky130_fd_sc_hd__and2_1
XFILLER_53_93 VPWR VGND VPWR VGND sky130_ef_sc_hd__decap_12
XFILLER_186_265 VPWR VGND VPWR VGND sky130_ef_sc_hd__decap_12
XFILLER_169_93 VPWR VGND VPWR VGND sky130_ef_sc_hd__decap_12
XFILLER_200_1539 VGND VGND VPWR VPWR sky130_fd_sc_hd__fill_1
XFILLER_196_1421 VGND VGND VPWR VPWR sky130_fd_sc_hd__decap_6
X_278_ net47 u_ctrl.state\[0\] net2 VGND VGND VPWR VPWR _076_ sky130_fd_sc_hd__o21ai_1
XFILLER_196_1465 VPWR VGND VPWR VGND sky130_ef_sc_hd__decap_12
XFILLER_192_1329 VPWR VGND VPWR VGND sky130_ef_sc_hd__decap_12
XFILLER_185_81 VPWR VGND VPWR VGND sky130_ef_sc_hd__decap_12
XFILLER_83_1602 VGND VGND VPWR VPWR sky130_fd_sc_hd__decap_3
XFILLER_5_161 VGND VGND VPWR VPWR sky130_fd_sc_hd__decap_6
XFILLER_170_699 VGND VGND VPWR VPWR sky130_fd_sc_hd__fill_1
XFILLER_38_3 VPWR VGND VPWR VGND sky130_ef_sc_hd__decap_12
XTAP_TAPCELL_ROW_53_2_3321 VGND VPWR sky130_fd_sc_hd__tapvpwrvgnd_1
XPHY_EDGE_ROW_59_1_Left_278 VGND VGND VPWR VPWR sky130_fd_sc_hd__decap_3
XFILLER_83_105 VGND VGND VPWR VPWR sky130_fd_sc_hd__decap_6
XFILLER_204_77 VGND VGND VPWR VPWR sky130_fd_sc_hd__decap_6
XTAP_TAPCELL_ROW_0_805 VGND VPWR sky130_fd_sc_hd__tapvpwrvgnd_1
XFILLER_164_1409 VPWR VGND VPWR VGND sky130_ef_sc_hd__decap_12
XFILLER_206_881 VPWR VGND VPWR VGND sky130_ef_sc_hd__decap_12
XFILLER_168_1589 VGND VGND VPWR VPWR sky130_fd_sc_hd__decap_6
XFILLER_205_391 VGND VGND VPWR VPWR sky130_fd_sc_hd__fill_1
XFILLER_127_1220 VPWR VGND VPWR VGND sky130_ef_sc_hd__decap_12
XFILLER_178_755 VGND VGND VPWR VPWR sky130_fd_sc_hd__fill_1
XFILLER_166_917 VGND VGND VPWR VPWR sky130_fd_sc_hd__decap_6
XFILLER_127_1286 VPWR VGND VPWR VGND sky130_ef_sc_hd__decap_12
XFILLER_165_405 VPWR VGND VPWR VGND sky130_ef_sc_hd__decap_12
XANTENNA_fanout132_A _087_ VGND VGND VPWR VPWR sky130_fd_sc_hd__diode_2
XFILLER_14_1412 VGND VGND VPWR VPWR sky130_fd_sc_hd__fill_1
XFILLER_181_909 VPWR VGND VPWR VGND sky130_ef_sc_hd__decap_12
XFILLER_165_449 VPWR VGND VPWR VGND sky130_ef_sc_hd__decap_12
XFILLER_88_1524 VGND VGND VPWR VPWR sky130_fd_sc_hd__fill_1
XFILLER_180_419 VGND VGND VPWR VPWR sky130_fd_sc_hd__fill_1
XFILLER_175_1505 VGND VGND VPWR VPWR sky130_fd_sc_hd__decap_6
XFILLER_174_961 VPWR VGND VPWR VGND sky130_ef_sc_hd__decap_12
XFILLER_175_1549 VPWR VGND VPWR VGND sky130_ef_sc_hd__decap_12
XFILLER_160_121 VGND VGND VPWR VPWR sky130_fd_sc_hd__decap_6
XFILLER_86_1270 VPWR VGND VPWR VGND sky130_ef_sc_hd__decap_12
XFILLER_47_1232 VPWR VGND VPWR VGND sky130_ef_sc_hd__decap_12
XFILLER_138_1382 VPWR VGND VPWR VGND sky130_ef_sc_hd__decap_12
XFILLER_58_27 VGND VGND VPWR VPWR sky130_fd_sc_hd__fill_1
XFILLER_181_39 VPWR VGND VPWR VGND sky130_ef_sc_hd__decap_12
XFILLER_134_1246 VPWR VGND VPWR VGND sky130_ef_sc_hd__decap_12
XFILLER_47_1298 VPWR VGND VPWR VGND sky130_ef_sc_hd__decap_12
XFILLER_59_113 VPWR VGND VPWR VGND sky130_ef_sc_hd__decap_12
XFILLER_25_1552 VGND VGND VPWR VPWR sky130_fd_sc_hd__fill_1
XFILLER_216_601 VPWR VGND VPWR VGND sky130_ef_sc_hd__decap_12
XTAP_TAPCELL_ROW_118_1_1253 VGND VPWR sky130_fd_sc_hd__tapvpwrvgnd_1
XFILLER_74_15 VPWR VGND VPWR VGND sky130_ef_sc_hd__decap_12
XFILLER_216_645 VPWR VGND VPWR VGND sky130_ef_sc_hd__decap_12
XFILLER_215_111 VGND VGND VPWR VPWR sky130_fd_sc_hd__fill_1
XFILLER_114_77 VGND VGND VPWR VPWR sky130_fd_sc_hd__decap_6
XTAP_TAPCELL_ROW_23_1_1064 VGND VPWR sky130_fd_sc_hd__tapvpwrvgnd_1
XFILLER_167_1033 VPWR VGND VPWR VGND sky130_ef_sc_hd__decap_12
XFILLER_3_1381 VPWR VGND VPWR VGND sky130_ef_sc_hd__decap_12
XFILLER_203_317 VPWR VGND VPWR VGND sky130_ef_sc_hd__decap_12
XFILLER_182_1509 VPWR VGND VPWR VGND sky130_ef_sc_hd__decap_12
XFILLER_167_1077 VPWR VGND VPWR VGND sky130_ef_sc_hd__decap_12
XFILLER_58_1350 VGND VGND VPWR VPWR sky130_fd_sc_hd__decap_6
XFILLER_145_1342 VPWR VGND VPWR VGND sky130_ef_sc_hd__decap_12
XFILLER_130_65 VPWR VGND VPWR VGND sky130_ef_sc_hd__decap_12
XTAP_TAPCELL_ROW_111_2_3699 VGND VPWR sky130_fd_sc_hd__tapvpwrvgnd_1
XFILLER_93_1274 VPWR VGND VPWR VGND sky130_ef_sc_hd__decap_12
XFILLER_58_1394 VPWR VGND VPWR VGND sky130_ef_sc_hd__decap_12
XFILLER_211_361 VPWR VGND VPWR VGND sky130_ef_sc_hd__decap_12
XFILLER_208_1085 VGND VGND VPWR VPWR sky130_fd_sc_hd__decap_6
XFILLER_169_777 VGND VGND VPWR VPWR sky130_fd_sc_hd__decap_6
XFILLER_168_221 VPWR VGND VPWR VGND sky130_ef_sc_hd__decap_12
XFILLER_142_3 VPWR VGND VPWR VGND sky130_ef_sc_hd__decap_12
XFILLER_106_1326 VPWR VGND VPWR VGND sky130_ef_sc_hd__decap_12
XFILLER_19_1378 VGND VGND VPWR VPWR sky130_fd_sc_hd__decap_6
XFILLER_54_1258 VPWR VGND VPWR VGND sky130_ef_sc_hd__decap_12
XFILLER_184_725 VPWR VGND VPWR VGND sky130_ef_sc_hd__decap_12
XFILLER_168_265 VPWR VGND VPWR VGND sky130_ef_sc_hd__decap_12
XFILLER_145_1386 VPWR VGND VPWR VGND sky130_ef_sc_hd__decap_12
XFILLER_184_769 VPWR VGND VPWR VGND sky130_ef_sc_hd__decap_12
XFILLER_183_279 VGND VGND VPWR VPWR sky130_fd_sc_hd__fill_1
XFILLER_178_1173 VPWR VGND VPWR VGND sky130_ef_sc_hd__decap_12
XTAP_TAPCELL_ROW_58_2_3358 VGND VPWR sky130_fd_sc_hd__tapvpwrvgnd_1
XFILLER_174_1037 VPWR VGND VPWR VGND sky130_ef_sc_hd__decap_12
XFILLER_155_51 VGND VGND VPWR VPWR sky130_fd_sc_hd__decap_4
XFILLER_69_1490 VGND VGND VPWR VPWR sky130_fd_sc_hd__decap_6
XFILLER_65_1310 VPWR VGND VPWR VGND sky130_ef_sc_hd__decap_12
XFILLER_215_1001 VGND VGND VPWR VPWR sky130_fd_sc_hd__decap_6
XFILLER_152_1302 VPWR VGND VPWR VGND sky130_ef_sc_hd__decap_12
XFILLER_117_1422 VPWR VGND VPWR VGND sky130_ef_sc_hd__decap_12
XFILLER_65_1354 VPWR VGND VPWR VGND sky130_ef_sc_hd__decap_12
XFILLER_215_1045 VPWR VGND VPWR VGND sky130_ef_sc_hd__decap_12
XFILLER_156_1482 VPWR VGND VPWR VGND sky130_ef_sc_hd__decap_12
XFILLER_117_1466 VPWR VGND VPWR VGND sky130_ef_sc_hd__decap_12
XFILLER_65_1398 VPWR VGND VPWR VGND sky130_ef_sc_hd__decap_12
XFILLER_26_1338 VPWR VGND VPWR VGND sky130_ef_sc_hd__decap_12
XTAP_TAPCELL_ROW_38_2_3223 VGND VPWR sky130_fd_sc_hd__tapvpwrvgnd_1
XFILLER_215_1089 VPWR VGND VPWR VGND sky130_ef_sc_hd__decap_12
XFILLER_65_105 VGND VGND VPWR VPWR sky130_fd_sc_hd__decap_6
XTAP_TAPCELL_ROW_7_982 VGND VPWR sky130_fd_sc_hd__tapvpwrvgnd_1
XTAP_TAPCELL_ROW_7_993 VGND VPWR sky130_fd_sc_hd__tapvpwrvgnd_1
XFILLER_8_1270 VPWR VGND VPWR VGND sky130_ef_sc_hd__decap_12
XFILLER_219_461 VPWR VGND VPWR VGND sky130_ef_sc_hd__decap_12
XFILLER_0_1009 VPWR VGND VPWR VGND sky130_ef_sc_hd__decap_12
XFILLER_206_133 VGND VGND VPWR VPWR sky130_fd_sc_hd__decap_6
XFILLER_185_1133 VPWR VGND VPWR VGND sky130_ef_sc_hd__decap_12
XFILLER_0_78 VGND VGND VPWR VPWR sky130_fd_sc_hd__decap_6
XFILLER_0_45 VGND VGND VPWR VPWR sky130_fd_sc_hd__decap_8
XFILLER_206_177 VPWR VGND VPWR VGND sky130_ef_sc_hd__decap_12
XFILLER_185_1177 VPWR VGND VPWR VGND sky130_ef_sc_hd__decap_12
XFILLER_76_1450 VPWR VGND VPWR VGND sky130_ef_sc_hd__decap_12
XFILLER_72_1314 VPWR VGND VPWR VGND sky130_ef_sc_hd__decap_12
XFILLER_37_1434 VGND VGND VPWR VPWR sky130_fd_sc_hd__decap_6
XFILLER_187_541 VPWR VGND VPWR VGND sky130_ef_sc_hd__decap_12
XFILLER_163_1453 VGND VGND VPWR VPWR sky130_fd_sc_hd__decap_3
XFILLER_128_1562 VPWR VGND VPWR VGND sky130_ef_sc_hd__decap_12
XFILLER_124_1426 VPWR VGND VPWR VGND sky130_ef_sc_hd__decap_12
XFILLER_76_1494 VPWR VGND VPWR VGND sky130_ef_sc_hd__decap_12
XFILLER_72_1358 VPWR VGND VPWR VGND sky130_ef_sc_hd__decap_12
XFILLER_37_1478 VPWR VGND VPWR VGND sky130_ef_sc_hd__decap_12
XFILLER_203_895 VGND VGND VPWR VPWR sky130_fd_sc_hd__fill_1
XFILLER_187_585 VPWR VGND VPWR VGND sky130_ef_sc_hd__decap_12
XFILLER_163_1497 VPWR VGND VPWR VGND sky130_ef_sc_hd__decap_12
XFILLER_9_76 VPWR VGND VPWR VGND sky130_ef_sc_hd__decap_12
XFILLER_204_1483 VGND VGND VPWR VPWR sky130_fd_sc_hd__fill_1
XFILLER_163_909 VPWR VGND VPWR VGND sky130_ef_sc_hd__decap_12
XTAP_TAPCELL_ROW_155_2_3986 VGND VPWR sky130_fd_sc_hd__tapvpwrvgnd_1
XFILLER_196_1273 VPWR VGND VPWR VGND sky130_ef_sc_hd__decap_12
XFILLER_7_993 VPWR VGND VPWR VGND sky130_ef_sc_hd__decap_12
XFILLER_171_953 VPWR VGND VPWR VGND sky130_ef_sc_hd__decap_12
XFILLER_142_121 VGND VGND VPWR VPWR sky130_fd_sc_hd__decap_6
XFILLER_100_1470 VPWR VGND VPWR VGND sky130_ef_sc_hd__decap_12
XFILLER_83_1410 VPWR VGND VPWR VGND sky130_ef_sc_hd__decap_12
XFILLER_157_1268 VGND VGND VPWR VPWR sky130_fd_sc_hd__decap_4
XFILLER_135_1522 VPWR VGND VPWR VGND sky130_ef_sc_hd__decap_12
XFILLER_87_1590 VPWR VGND VPWR VGND sky130_ef_sc_hd__decap_12
XFILLER_83_1454 VPWR VGND VPWR VGND sky130_ef_sc_hd__decap_12
XFILLER_48_1574 VGND VGND VPWR VPWR sky130_fd_sc_hd__decap_6
XFILLER_44_1438 VPWR VGND VPWR VGND sky130_ef_sc_hd__decap_12
XFILLER_135_1566 VPWR VGND VPWR VGND sky130_ef_sc_hd__decap_12
XFILLER_83_1498 VPWR VGND VPWR VGND sky130_ef_sc_hd__decap_12
XPHY_EDGE_ROW_206_Right_51 VGND VGND VPWR VPWR sky130_fd_sc_hd__decap_3
XFILLER_168_1353 VPWR VGND VPWR VGND sky130_ef_sc_hd__decap_12
XFILLER_213_615 VGND VGND VPWR VPWR sky130_fd_sc_hd__fill_1
XFILLER_197_305 VPWR VGND VPWR VGND sky130_ef_sc_hd__decap_12
XFILLER_164_1217 VPWR VGND VPWR VGND sky130_ef_sc_hd__decap_12
XFILLER_20_1482 VPWR VGND VPWR VGND sky130_ef_sc_hd__decap_12
XFILLER_44_29 VPWR VGND VPWR VGND sky130_ef_sc_hd__decap_12
XFILLER_168_1397 VPWR VGND VPWR VGND sky130_ef_sc_hd__decap_12
XFILLER_107_1602 VGND VGND VPWR VPWR sky130_fd_sc_hd__decap_3
XFILLER_94_1550 VPWR VGND VPWR VGND sky130_ef_sc_hd__decap_12
XFILLER_90_1414 VPWR VGND VPWR VGND sky130_ef_sc_hd__decap_12
XFILLER_0_1565 VGND VGND VPWR VPWR sky130_fd_sc_hd__decap_3
XFILLER_55_1534 VPWR VGND VPWR VGND sky130_ef_sc_hd__decap_12
XFILLER_205_1225 VGND VGND VPWR VPWR sky130_fd_sc_hd__decap_6
XFILLER_200_309 VPWR VGND VPWR VGND sky130_ef_sc_hd__decap_12
XFILLER_197_349 VPWR VGND VPWR VGND sky130_ef_sc_hd__decap_12
XFILLER_94_1594 VGND VGND VPWR VPWR sky130_fd_sc_hd__decap_8
XFILLER_16_1518 VGND VGND VPWR VPWR sky130_fd_sc_hd__decap_6
XFILLER_205_1269 VPWR VGND VPWR VGND sky130_ef_sc_hd__decap_12
XTAP_TAPCELL_ROW_195_2299 VGND VPWR sky130_fd_sc_hd__tapvpwrvgnd_1
XTAP_TAPCELL_ROW_195_2288 VGND VPWR sky130_fd_sc_hd__tapvpwrvgnd_1
XFILLER_166_725 VPWR VGND VPWR VGND sky130_ef_sc_hd__decap_12
XFILLER_142_1526 VPWR VGND VPWR VGND sky130_ef_sc_hd__decap_12
XANTENNA_fanout135_X net135 VGND VGND VPWR VPWR sky130_fd_sc_hd__diode_2
XFILLER_55_1578 VPWR VGND VPWR VGND sky130_ef_sc_hd__decap_12
XPHY_EDGE_ROW_215_Right_60 VGND VGND VPWR VPWR sky130_fd_sc_hd__decap_3
XFILLER_166_769 VPWR VGND VPWR VGND sky130_ef_sc_hd__decap_12
XFILLER_14_1220 VPWR VGND VPWR VGND sky130_ef_sc_hd__decap_12
XFILLER_165_279 VGND VGND VPWR VPWR sky130_fd_sc_hd__fill_1
XTAP_TAPCELL_ROW_44_2_3266 VGND VPWR sky130_fd_sc_hd__tapvpwrvgnd_1
XFILLER_175_1313 VPWR VGND VPWR VGND sky130_ef_sc_hd__decap_12
XFILLER_140_1294 VGND VGND VPWR VPWR sky130_fd_sc_hd__decap_6
XFILLER_109_55 VGND VGND VPWR VPWR sky130_fd_sc_hd__fill_1
XFILLER_101_1256 VPWR VGND VPWR VGND sky130_ef_sc_hd__decap_12
XFILLER_179_1493 VPWR VGND VPWR VGND sky130_ef_sc_hd__decap_12
XFILLER_69_15 VPWR VGND VPWR VGND sky130_ef_sc_hd__decap_12
XFILLER_192_27 VGND VGND VPWR VPWR sky130_fd_sc_hd__fill_1
XFILLER_175_1357 VPWR VGND VPWR VGND sky130_ef_sc_hd__decap_12
XTAP_TAPCELL_ROW_24_2_3131 VGND VPWR sky130_fd_sc_hd__tapvpwrvgnd_1
XFILLER_216_1365 VGND VGND VPWR VPWR sky130_fd_sc_hd__decap_6
XFILLER_212_1229 VPWR VGND VPWR VGND sky130_ef_sc_hd__decap_12
XFILLER_62_1538 VPWR VGND VPWR VGND sky130_ef_sc_hd__decap_12
XFILLER_9_1590 VPWR VGND VPWR VGND sky130_ef_sc_hd__decap_12
XFILLER_47_105 VGND VGND VPWR VPWR sky130_fd_sc_hd__decap_6
XFILLER_217_921 VPWR VGND VPWR VGND sky130_ef_sc_hd__decap_12
XTAP_TAPCELL_ROW_184_1992 VGND VPWR sky130_fd_sc_hd__tapvpwrvgnd_1
XTAP_TAPCELL_ROW_184_1981 VGND VPWR sky130_fd_sc_hd__tapvpwrvgnd_1
XTAP_TAPCELL_ROW_184_1970 VGND VPWR sky130_fd_sc_hd__tapvpwrvgnd_1
XFILLER_85_69 VPWR VGND VPWR VGND sky130_ef_sc_hd__decap_12
XFILLER_18_41 VPWR VGND VPWR VGND sky130_ef_sc_hd__decap_12
XTAP_TAPCELL_ROW_54_1_1125 VGND VPWR sky130_fd_sc_hd__tapvpwrvgnd_1
XFILLER_217_965 VPWR VGND VPWR VGND sky130_ef_sc_hd__decap_12
XTAP_TAPCELL_ROW_180_1867 VGND VPWR sky130_fd_sc_hd__tapvpwrvgnd_1
XTAP_TAPCELL_ROW_180_1856 VGND VPWR sky130_fd_sc_hd__tapvpwrvgnd_1
XFILLER_18_74 VGND VGND VPWR VPWR sky130_fd_sc_hd__decap_8
XFILLER_18_85 VPWR VGND VPWR VGND sky130_ef_sc_hd__decap_12
XFILLER_21_1268 VGND VGND VPWR VPWR sky130_fd_sc_hd__decap_4
XFILLER_216_475 VGND VGND VPWR VPWR sky130_fd_sc_hd__fill_1
XFILLER_186_1453 VPWR VGND VPWR VGND sky130_ef_sc_hd__decap_12
XFILLER_182_1317 VPWR VGND VPWR VGND sky130_ef_sc_hd__decap_12
XTAP_TAPCELL_ROW_180_1878 VGND VPWR sky130_fd_sc_hd__tapvpwrvgnd_1
XPHY_EDGE_ROW_23_2_Right_80 VGND VGND VPWR VPWR sky130_fd_sc_hd__decap_3
XFILLER_204_637 VGND VGND VPWR VPWR sky130_fd_sc_hd__decap_6
XFILLER_203_125 VPWR VGND VPWR VGND sky130_ef_sc_hd__decap_12
XFILLER_189_839 VGND VGND VPWR VPWR sky130_fd_sc_hd__fill_1
XFILLER_186_1497 VPWR VGND VPWR VGND sky130_ef_sc_hd__decap_12
XFILLER_203_169 VPWR VGND VPWR VGND sky130_ef_sc_hd__decap_12
XFILLER_169_541 VPWR VGND VPWR VGND sky130_ef_sc_hd__decap_12
XFILLER_212_681 VPWR VGND VPWR VGND sky130_ef_sc_hd__decap_12
XFILLER_169_585 VPWR VGND VPWR VGND sky130_ef_sc_hd__decap_12
XFILLER_184_533 VPWR VGND VPWR VGND sky130_ef_sc_hd__decap_12
XFILLER_180_1085 VGND VGND VPWR VPWR sky130_fd_sc_hd__decap_6
XTAP_TAPCELL_ROW_141_2_3894 VGND VPWR sky130_fd_sc_hd__tapvpwrvgnd_1
XPHY_EDGE_ROW_26_2_Left_458 VGND VGND VPWR VPWR sky130_fd_sc_hd__decap_3
XFILLER_171_205 VPWR VGND VPWR VGND sky130_ef_sc_hd__decap_12
XFILLER_50_83 VGND VGND VPWR VPWR sky130_fd_sc_hd__fill_1
XFILLER_197_1593 VPWR VGND VPWR VGND sky130_ef_sc_hd__decap_12
XFILLER_193_1413 VPWR VGND VPWR VGND sky130_ef_sc_hd__decap_12
XFILLER_171_249 VPWR VGND VPWR VGND sky130_ef_sc_hd__decap_12
XFILLER_166_83 VGND VGND VPWR VPWR sky130_fd_sc_hd__fill_1
XFILLER_124_121 VGND VGND VPWR VPWR sky130_fd_sc_hd__decap_6
XFILLER_193_1457 VPWR VGND VPWR VGND sky130_ef_sc_hd__decap_12
XFILLER_4_974 VGND VGND VPWR VPWR sky130_fd_sc_hd__decap_6
XTAP_TAPCELL_ROW_88_2_3553 VGND VPWR sky130_fd_sc_hd__tapvpwrvgnd_1
XPHY_EDGE_ROW_88_2_Left_520 VGND VGND VPWR VPWR sky130_fd_sc_hd__decap_3
XFILLER_3_495 VGND VGND VPWR VPWR sky130_fd_sc_hd__decap_4
XFILLER_3_473 VGND VGND VPWR VPWR sky130_fd_sc_hd__decap_8
XFILLER_117_1274 VPWR VGND VPWR VGND sky130_ef_sc_hd__decap_12
XFILLER_6_1229 VPWR VGND VPWR VGND sky130_ef_sc_hd__decap_12
XFILLER_59_81 VPWR VGND VPWR VGND sky130_ef_sc_hd__decap_12
XPHY_EDGE_ROW_140_2_Left_572 VGND VGND VPWR VPWR sky130_fd_sc_hd__decap_3
XTAP_TAPCELL_ROW_101_1_1220 VGND VPWR sky130_fd_sc_hd__tapvpwrvgnd_1
XTAP_TAPCELL_ROW_81_2_3507 VGND VPWR sky130_fd_sc_hd__tapvpwrvgnd_1
XFILLER_179_305 VPWR VGND VPWR VGND sky130_ef_sc_hd__decap_12
XFILLER_207_497 VGND VGND VPWR VPWR sky130_fd_sc_hd__decap_6
XFILLER_165_1537 VPWR VGND VPWR VGND sky130_ef_sc_hd__decap_12
XFILLER_195_809 VPWR VGND VPWR VGND sky130_ef_sc_hd__decap_12
XFILLER_188_861 VGND VGND VPWR VPWR sky130_fd_sc_hd__decap_6
XFILLER_179_349 VPWR VGND VPWR VGND sky130_ef_sc_hd__decap_12
XFILLER_37_1220 VPWR VGND VPWR VGND sky130_ef_sc_hd__decap_12
XFILLER_163_1261 VPWR VGND VPWR VGND sky130_ef_sc_hd__decap_12
XFILLER_128_1370 VPWR VGND VPWR VGND sky130_ef_sc_hd__decap_12
XFILLER_37_1286 VPWR VGND VPWR VGND sky130_ef_sc_hd__decap_12
XFILLER_206_1589 VGND VGND VPWR VPWR sky130_fd_sc_hd__decap_6
XFILLER_202_1409 VPWR VGND VPWR VGND sky130_ef_sc_hd__decap_12
XFILLER_187_393 VPWR VGND VPWR VGND sky130_ef_sc_hd__decap_12
XTAP_TAPCELL_ROW_30_2_3174 VGND VPWR sky130_fd_sc_hd__tapvpwrvgnd_1
XTAP_TAPCELL_ROW_190_2163 VGND VPWR sky130_fd_sc_hd__tapvpwrvgnd_1
XTAP_TAPCELL_ROW_190_2152 VGND VPWR sky130_fd_sc_hd__tapvpwrvgnd_1
XTAP_TAPCELL_ROW_190_2141 VGND VPWR sky130_fd_sc_hd__tapvpwrvgnd_1
XTAP_TAPCELL_ROW_29_2_3168 VGND VPWR sky130_fd_sc_hd__tapvpwrvgnd_1
XTAP_TAPCELL_ROW_215_2881 VGND VPWR sky130_fd_sc_hd__tapvpwrvgnd_1
XTAP_TAPCELL_ROW_215_2870 VGND VPWR sky130_fd_sc_hd__tapvpwrvgnd_1
XFILLER_190_525 VGND VGND VPWR VPWR sky130_fd_sc_hd__decap_6
XTAP_TAPCELL_ROW_211_2745 VGND VPWR sky130_fd_sc_hd__tapvpwrvgnd_1
XFILLER_190_569 VPWR VGND VPWR VGND sky130_ef_sc_hd__decap_12
XTAP_TAPCELL_ROW_211_2767 VGND VPWR sky130_fd_sc_hd__tapvpwrvgnd_1
XTAP_TAPCELL_ROW_211_2756 VGND VPWR sky130_fd_sc_hd__tapvpwrvgnd_1
XFILLER_171_783 VGND VGND VPWR VPWR sky130_fd_sc_hd__fill_1
XTAP_TAPCELL_ROW_188_2092 VGND VPWR sky130_fd_sc_hd__tapvpwrvgnd_1
XFILLER_135_1330 VPWR VGND VPWR VGND sky130_ef_sc_hd__decap_12
XFILLER_48_1382 VPWR VGND VPWR VGND sky130_ef_sc_hd__decap_12
XFILLER_213_1505 VGND VGND VPWR VPWR sky130_fd_sc_hd__decap_6
XFILLER_44_1246 VPWR VGND VPWR VGND sky130_ef_sc_hd__decap_12
XFILLER_213_1549 VPWR VGND VPWR VGND sky130_ef_sc_hd__decap_12
XFILLER_217_217 VGND VGND VPWR VPWR sky130_fd_sc_hd__decap_6
XTAP_TAPCELL_ROW_209_2696 VGND VPWR sky130_fd_sc_hd__tapvpwrvgnd_1
XTAP_TAPCELL_ROW_209_2685 VGND VPWR sky130_fd_sc_hd__tapvpwrvgnd_1
XTAP_TAPCELL_ROW_135_1_1288 VGND VPWR sky130_fd_sc_hd__tapvpwrvgnd_1
XTAP_TAPCELL_ROW_159_2_4011 VGND VPWR sky130_fd_sc_hd__tapvpwrvgnd_1
XFILLER_168_1161 VPWR VGND VPWR VGND sky130_ef_sc_hd__decap_12
XFILLER_198_625 VPWR VGND VPWR VGND sky130_ef_sc_hd__decap_12
XFILLER_197_113 VPWR VGND VPWR VGND sky130_ef_sc_hd__decap_12
XFILLER_0_1373 VPWR VGND VPWR VGND sky130_ef_sc_hd__decap_12
XFILLER_214_979 VGND VGND VPWR VPWR sky130_fd_sc_hd__fill_1
XFILLER_198_669 VPWR VGND VPWR VGND sky130_ef_sc_hd__decap_12
XFILLER_107_1410 VPWR VGND VPWR VGND sky130_ef_sc_hd__decap_12
XFILLER_71_27 VPWR VGND VPWR VGND sky130_ef_sc_hd__decap_12
XFILLER_55_1342 VPWR VGND VPWR VGND sky130_ef_sc_hd__decap_12
XFILLER_205_1033 VPWR VGND VPWR VGND sky130_ef_sc_hd__decap_12
XFILLER_201_629 VPWR VGND VPWR VGND sky130_ef_sc_hd__decap_12
XFILLER_187_27 VPWR VGND VPWR VGND sky130_ef_sc_hd__decap_12
XFILLER_146_1470 VPWR VGND VPWR VGND sky130_ef_sc_hd__decap_12
XTAP_TAPCELL_ROW_126_2_3796 VGND VPWR sky130_fd_sc_hd__tapvpwrvgnd_1
XFILLER_90_1244 VGND VGND VPWR VPWR sky130_fd_sc_hd__fill_1
XFILLER_16_1326 VPWR VGND VPWR VGND sky130_ef_sc_hd__decap_12
XFILLER_205_1077 VPWR VGND VPWR VGND sky130_ef_sc_hd__decap_12
XFILLER_200_139 VGND VGND VPWR VPWR sky130_fd_sc_hd__fill_1
XFILLER_166_533 VPWR VGND VPWR VGND sky130_ef_sc_hd__decap_12
XFILLER_142_1356 VGND VGND VPWR VPWR sky130_fd_sc_hd__fill_1
XFILLER_107_1454 VPWR VGND VPWR VGND sky130_ef_sc_hd__decap_12
XFILLER_55_1386 VPWR VGND VPWR VGND sky130_ef_sc_hd__decap_12
XFILLER_181_503 VGND VGND VPWR VPWR sky130_fd_sc_hd__fill_1
XFILLER_107_1498 VPWR VGND VPWR VGND sky130_ef_sc_hd__decap_12
XFILLER_193_385 VGND VGND VPWR VPWR sky130_fd_sc_hd__decap_6
XTAP_TAPCELL_ROW_173_1671 VGND VPWR sky130_fd_sc_hd__tapvpwrvgnd_1
XTAP_TAPCELL_ROW_173_1660 VGND VPWR sky130_fd_sc_hd__tapvpwrvgnd_1
XPHY_EDGE_ROW_136_1_Left_355 VGND VGND VPWR VPWR sky130_fd_sc_hd__decap_3
XFILLER_5_716 VGND VGND VPWR VPWR sky130_fd_sc_hd__decap_3
XFILLER_175_1121 VPWR VGND VPWR VGND sky130_ef_sc_hd__decap_12
XTAP_TAPCELL_ROW_173_1682 VGND VPWR sky130_fd_sc_hd__tapvpwrvgnd_1
XPHY_EDGE_ROW_140_2_Right_197 VGND VGND VPWR VPWR sky130_fd_sc_hd__decap_3
XFILLER_106_121 VGND VGND VPWR VPWR sky130_fd_sc_hd__decap_6
XFILLER_105_3 VPWR VGND VPWR VGND sky130_ef_sc_hd__decap_12
XFILLER_5_749 VGND VGND VPWR VPWR sky130_fd_sc_hd__fill_2
XFILLER_218_1427 VGND VGND VPWR VPWR sky130_fd_sc_hd__fill_1
XFILLER_136_53 VPWR VGND VPWR VGND sky130_ef_sc_hd__decap_12
XTAP_TAPCELL_ROW_74_2_3461 VGND VPWR sky130_fd_sc_hd__tapvpwrvgnd_1
XFILLER_1_911 VPWR VGND VPWR VGND sky130_ef_sc_hd__decap_12
XFILLER_171_1007 VGND VGND VPWR VPWR sky130_fd_sc_hd__fill_1
XFILLER_121_113 VPWR VGND VPWR VGND sky130_ef_sc_hd__decap_12
XANTENNA__572__CLK clknet_3_2_0_clk VGND VGND VPWR VPWR sky130_fd_sc_hd__diode_2
XFILLER_27_1422 VPWR VGND VPWR VGND sky130_ef_sc_hd__decap_12
XFILLER_62_1302 VPWR VGND VPWR VGND sky130_ef_sc_hd__decap_12
XFILLER_216_1173 VPWR VGND VPWR VGND sky130_ef_sc_hd__decap_12
XFILLER_136_97 VPWR VGND VPWR VGND sky130_ef_sc_hd__decap_12
XFILLER_118_1550 VPWR VGND VPWR VGND sky130_ef_sc_hd__decap_12
XFILLER_66_1482 VPWR VGND VPWR VGND sky130_ef_sc_hd__decap_12
XFILLER_1_977 VPWR VGND VPWR VGND sky130_ef_sc_hd__decap_12
XFILLER_212_1037 VPWR VGND VPWR VGND sky130_ef_sc_hd__decap_12
XTAP_TAPCELL_ROW_182_1918 VGND VPWR sky130_fd_sc_hd__tapvpwrvgnd_1
XFILLER_153_1496 VGND VGND VPWR VPWR sky130_fd_sc_hd__fill_1
XFILLER_118_1594 VGND VGND VPWR VPWR sky130_fd_sc_hd__decap_8
XFILLER_114_1414 VPWR VGND VPWR VGND sky130_ef_sc_hd__decap_12
XFILLER_0_465 VGND VGND VPWR VPWR sky130_fd_sc_hd__decap_4
XFILLER_27_1466 VPWR VGND VPWR VGND sky130_ef_sc_hd__decap_12
XFILLER_209_729 VPWR VGND VPWR VGND sky130_ef_sc_hd__decap_12
XTAP_TAPCELL_ROW_182_1929 VGND VPWR sky130_fd_sc_hd__tapvpwrvgnd_1
XTAP_TAPCELL_ROW_167_1497 VGND VPWR sky130_fd_sc_hd__tapvpwrvgnd_1
XTAP_TAPCELL_ROW_167_1486 VGND VPWR sky130_fd_sc_hd__tapvpwrvgnd_1
XFILLER_152_41 VPWR VGND VPWR VGND sky130_ef_sc_hd__decap_12
XANTENNA_input25_A func_wdata[21] VGND VGND VPWR VPWR sky130_fd_sc_hd__diode_2
XFILLER_29_73 VGND VGND VPWR VPWR sky130_fd_sc_hd__fill_1
XFILLER_152_85 VPWR VGND VPWR VGND sky130_ef_sc_hd__decap_12
XTAP_TAPCELL_ROW_66_2_3409 VGND VPWR sky130_fd_sc_hd__tapvpwrvgnd_1
XFILLER_204_401 VPWR VGND VPWR VGND sky130_ef_sc_hd__decap_12
XFILLER_204_445 VPWR VGND VPWR VGND sky130_ef_sc_hd__decap_12
XFILLER_186_1261 VPWR VGND VPWR VGND sky130_ef_sc_hd__decap_12
X_595_ clknet_3_4_0_clk _029_ VGND VGND VPWR VPWR net82 sky130_fd_sc_hd__dfxtp_1
XFILLER_182_1147 VGND VGND VPWR VPWR sky130_fd_sc_hd__fill_1
XFILLER_177_809 VPWR VGND VPWR VGND sky130_ef_sc_hd__decap_12
XFILLER_147_1256 VPWR VGND VPWR VGND sky130_ef_sc_hd__decap_12
XFILLER_204_489 VPWR VGND VPWR VGND sky130_ef_sc_hd__decap_12
XFILLER_160_1412 VGND VGND VPWR VPWR sky130_fd_sc_hd__fill_1
XFILLER_125_1510 VPWR VGND VPWR VGND sky130_ef_sc_hd__decap_12
XFILLER_73_1442 VPWR VGND VPWR VGND sky130_ef_sc_hd__decap_12
XFILLER_34_1426 VPWR VGND VPWR VGND sky130_ef_sc_hd__decap_12
XFILLER_38_1562 VPWR VGND VPWR VGND sky130_ef_sc_hd__decap_12
XFILLER_185_853 VPWR VGND VPWR VGND sky130_ef_sc_hd__decap_12
XFILLER_169_393 VPWR VGND VPWR VGND sky130_ef_sc_hd__decap_12
XFILLER_125_1554 VPWR VGND VPWR VGND sky130_ef_sc_hd__decap_12
XTAP_TAPCELL_ROW_15_2_3076 VGND VPWR sky130_fd_sc_hd__tapvpwrvgnd_1
XFILLER_184_363 VGND VGND VPWR VPWR sky130_fd_sc_hd__fill_1
XPHY_EDGE_ROW_68_1_Left_287 VGND VGND VPWR VPWR sky130_fd_sc_hd__decap_3
XFILLER_61_93 VPWR VGND VPWR VGND sky130_ef_sc_hd__decap_12
XFILLER_185_897 VPWR VGND VPWR VGND sky130_ef_sc_hd__decap_12
XFILLER_177_93 VPWR VGND VPWR VGND sky130_ef_sc_hd__decap_12
XFILLER_172_525 VGND VGND VPWR VPWR sky130_fd_sc_hd__decap_6
XFILLER_172_569 VPWR VGND VPWR VGND sky130_ef_sc_hd__decap_12
XANTENNA__550__S net122 VGND VGND VPWR VPWR sky130_fd_sc_hd__diode_2
XFILLER_10_1470 VPWR VGND VPWR VGND sky130_ef_sc_hd__decap_12
XFILLER_193_1287 VGND VGND VPWR VPWR sky130_fd_sc_hd__fill_1
XFILLER_193_81 VPWR VGND VPWR VGND sky130_ef_sc_hd__decap_12
XFILLER_67_1268 VGND VGND VPWR VPWR sky130_fd_sc_hd__decap_4
XFILLER_3_281 VPWR VGND VPWR VGND sky130_ef_sc_hd__decap_12
XFILLER_84_1582 VPWR VGND VPWR VGND sky130_ef_sc_hd__decap_12
XFILLER_45_1522 VPWR VGND VPWR VGND sky130_ef_sc_hd__decap_12
XFILLER_80_1468 VGND VGND VPWR VPWR sky130_fd_sc_hd__fill_1
XTAP_TAPCELL_ROW_7_1010 VGND VPWR sky130_fd_sc_hd__tapvpwrvgnd_1
XFILLER_6_1037 VPWR VGND VPWR VGND sky130_ef_sc_hd__decap_12
XFILLER_20_3 VPWR VGND VPWR VGND sky130_ef_sc_hd__decap_12
XFILLER_45_1566 VPWR VGND VPWR VGND sky130_ef_sc_hd__decap_12
XTAP_TAPCELL_ROW_7_1021 VGND VPWR sky130_fd_sc_hd__tapvpwrvgnd_1
XTAP_TAPCELL_ROW_7_1032 VGND VPWR sky130_fd_sc_hd__tapvpwrvgnd_1
XFILLER_214_209 VPWR VGND VPWR VGND sky130_ef_sc_hd__decap_12
XFILLER_207_261 VPWR VGND VPWR VGND sky130_ef_sc_hd__decap_12
XTAP_TAPCELL_ROW_204_2560 VGND VPWR sky130_fd_sc_hd__tapvpwrvgnd_1
XFILLER_165_1301 VPWR VGND VPWR VGND sky130_ef_sc_hd__decap_12
XFILLER_130_1282 VPWR VGND VPWR VGND sky130_ef_sc_hd__decap_12
XFILLER_212_77 VGND VGND VPWR VPWR sky130_fd_sc_hd__decap_6
XTAP_TAPCELL_ROW_200_2435 VGND VPWR sky130_fd_sc_hd__tapvpwrvgnd_1
XFILLER_179_113 VPWR VGND VPWR VGND sky130_ef_sc_hd__decap_12
XFILLER_169_1481 VPWR VGND VPWR VGND sky130_ef_sc_hd__decap_12
XTAP_TAPCELL_ROW_200_2446 VGND VPWR sky130_fd_sc_hd__tapvpwrvgnd_1
XFILLER_165_1345 VPWR VGND VPWR VGND sky130_ef_sc_hd__decap_12
XFILLER_195_617 VPWR VGND VPWR VGND sky130_ef_sc_hd__decap_12
XTAP_TAPCELL_ROW_192_2225 VGND VPWR sky130_fd_sc_hd__tapvpwrvgnd_1
XTAP_TAPCELL_ROW_192_2214 VGND VPWR sky130_fd_sc_hd__tapvpwrvgnd_1
XTAP_TAPCELL_ROW_192_2203 VGND VPWR sky130_fd_sc_hd__tapvpwrvgnd_1
XFILLER_17_1602 VGND VGND VPWR VPWR sky130_fd_sc_hd__decap_3
XTAP_TAPCELL_ROW_217_2932 VGND VPWR sky130_fd_sc_hd__tapvpwrvgnd_1
XTAP_TAPCELL_ROW_217_2921 VGND VPWR sky130_fd_sc_hd__tapvpwrvgnd_1
XFILLER_206_1353 VPWR VGND VPWR VGND sky130_ef_sc_hd__decap_12
XFILLER_52_1526 VPWR VGND VPWR VGND sky130_ef_sc_hd__decap_12
XTAP_TAPCELL_ROW_213_2807 VGND VPWR sky130_fd_sc_hd__tapvpwrvgnd_1
XFILLER_206_1397 VPWR VGND VPWR VGND sky130_ef_sc_hd__decap_12
XFILLER_202_1217 VPWR VGND VPWR VGND sky130_ef_sc_hd__decap_12
XTAP_TAPCELL_ROW_213_2818 VGND VPWR sky130_fd_sc_hd__tapvpwrvgnd_1
XFILLER_175_385 VGND VGND VPWR VPWR sky130_fd_sc_hd__decap_6
XFILLER_194_1029 VGND VGND VPWR VPWR sky130_fd_sc_hd__decap_6
XFILLER_190_333 VPWR VGND VPWR VGND sky130_ef_sc_hd__decap_12
XFILLER_11_1256 VPWR VGND VPWR VGND sky130_ef_sc_hd__decap_12
XFILLER_50_1294 VGND VGND VPWR VPWR sky130_fd_sc_hd__decap_6
XTAP_TAPCELL_ROW_59_2_3363 VGND VPWR sky130_fd_sc_hd__tapvpwrvgnd_1
XFILLER_191_889 VGND VGND VPWR VPWR sky130_fd_sc_hd__decap_6
XFILLER_190_377 VPWR VGND VPWR VGND sky130_ef_sc_hd__decap_12
XFILLER_176_1441 VPWR VGND VPWR VGND sky130_ef_sc_hd__decap_12
XTAP_TAPCELL_ROW_78_1_1173 VGND VPWR sky130_fd_sc_hd__tapvpwrvgnd_1
XTAP_TAPCELL_ROW_186_2029 VGND VPWR sky130_fd_sc_hd__tapvpwrvgnd_1
XFILLER_176_1485 VPWR VGND VPWR VGND sky130_ef_sc_hd__decap_12
XFILLER_103_113 VPWR VGND VPWR VGND sky130_ef_sc_hd__decap_12
XPHY_EDGE_ROW_60_1_Right_646 VGND VGND VPWR VPWR sky130_fd_sc_hd__decap_3
XFILLER_217_1493 VPWR VGND VPWR VGND sky130_ef_sc_hd__decap_12
XFILLER_213_1313 VPWR VGND VPWR VGND sky130_ef_sc_hd__decap_12
XFILLER_66_27 VGND VGND VPWR VPWR sky130_fd_sc_hd__fill_1
XFILLER_213_1357 VPWR VGND VPWR VGND sky130_ef_sc_hd__decap_12
XFILLER_170_1073 VPWR VGND VPWR VGND sky130_ef_sc_hd__decap_12
XTAP_TAPCELL_ROW_52_2_3317 VGND VPWR sky130_fd_sc_hd__tapvpwrvgnd_1
XFILLER_199_945 VGND VGND VPWR VPWR sky130_fd_sc_hd__decap_6
XFILLER_187_1581 VPWR VGND VPWR VGND sky130_ef_sc_hd__decap_12
XFILLER_183_1401 VPWR VGND VPWR VGND sky130_ef_sc_hd__decap_12
XFILLER_122_77 VGND VGND VPWR VPWR sky130_fd_sc_hd__decap_6
XFILLER_82_15 VPWR VGND VPWR VGND sky130_ef_sc_hd__decap_12
XFILLER_202_905 VPWR VGND VPWR VGND sky130_ef_sc_hd__decap_12
XFILLER_198_433 VPWR VGND VPWR VGND sky130_ef_sc_hd__decap_12
XFILLER_198_15 VPWR VGND VPWR VGND sky130_ef_sc_hd__decap_12
X_380_ _118_ _119_ net156 VGND VGND VPWR VPWR _018_ sky130_fd_sc_hd__o21a_1
XFILLER_202_949 VPWR VGND VPWR VGND sky130_ef_sc_hd__decap_12
XFILLER_199_989 VPWR VGND VPWR VGND sky130_ef_sc_hd__decap_12
XFILLER_198_477 VPWR VGND VPWR VGND sky130_ef_sc_hd__decap_12
XFILLER_185_105 VGND VGND VPWR VPWR sky130_fd_sc_hd__decap_6
XTAP_TAPCELL_ROW_175_1722 VGND VPWR sky130_fd_sc_hd__tapvpwrvgnd_1
XFILLER_210_993 VPWR VGND VPWR VGND sky130_ef_sc_hd__decap_12
XFILLER_185_149 VPWR VGND VPWR VGND sky130_ef_sc_hd__decap_12
XTAP_TAPCELL_ROW_175_1733 VGND VPWR sky130_fd_sc_hd__tapvpwrvgnd_1
XFILLER_167_853 VPWR VGND VPWR VGND sky130_ef_sc_hd__decap_12
XTAP_TAPCELL_ROW_171_1619 VGND VPWR sky130_fd_sc_hd__tapvpwrvgnd_1
XTAP_TAPCELL_ROW_171_1608 VGND VPWR sky130_fd_sc_hd__tapvpwrvgnd_1
XFILLER_167_897 VPWR VGND VPWR VGND sky130_ef_sc_hd__decap_12
XFILLER_166_363 VGND VGND VPWR VPWR sky130_fd_sc_hd__fill_1
XTAP_TAPCELL_ROW_156_2_3991 VGND VPWR sky130_fd_sc_hd__tapvpwrvgnd_1
XFILLER_31_52 VGND VGND VPWR VPWR sky130_fd_sc_hd__decap_4
XFILLER_193_193 VPWR VGND VPWR VGND sky130_ef_sc_hd__decap_12
XFILLER_182_867 VGND VGND VPWR VPWR sky130_fd_sc_hd__fill_1
XFILLER_120_1462 VGND VGND VPWR VPWR sky130_fd_sc_hd__decap_6
XFILLER_194_1541 VPWR VGND VPWR VGND sky130_ef_sc_hd__decap_12
XFILLER_5_579 VGND VGND VPWR VPWR sky130_fd_sc_hd__decap_8
XFILLER_190_1427 VGND VGND VPWR VPWR sky130_fd_sc_hd__fill_1
XPHY_EDGE_ROW_141_2_Right_198 VGND VGND VPWR VPWR sky130_fd_sc_hd__decap_3
Xoutput52 net52 VGND VGND VPWR VPWR bist_fail_addr[3] sky130_fd_sc_hd__buf_2
XTAP_TAPCELL_ROW_169_1548 VGND VPWR sky130_fd_sc_hd__tapvpwrvgnd_1
Xoutput63 net63 VGND VGND VPWR VPWR bist_fail_bits[15] sky130_fd_sc_hd__buf_2
Xoutput74 net74 VGND VGND VPWR VPWR bist_fail_bits[25] sky130_fd_sc_hd__buf_2
Xoutput85 net85 VGND VGND VPWR VPWR bist_fail_bits[6] sky130_fd_sc_hd__buf_2
XTAP_TAPCELL_ROW_169_1559 VGND VPWR sky130_fd_sc_hd__tapvpwrvgnd_1
XFILLER_153_1271 VGND VGND VPWR VPWR sky130_fd_sc_hd__fill_2
XTAP_TAPCELL_ROW_148_2_3939 VGND VPWR sky130_fd_sc_hd__tapvpwrvgnd_1
XFILLER_1_785 VGND VGND VPWR VPWR sky130_fd_sc_hd__fill_1
Xoutput96 net96 VGND VGND VPWR VPWR func_rdata[16] sky130_fd_sc_hd__buf_2
XFILLER_0_262 VGND VGND VPWR VPWR sky130_fd_sc_hd__decap_4
XFILLER_7_1313 VGND VGND VPWR VPWR sky130_fd_sc_hd__decap_3
XFILLER_27_1274 VPWR VGND VPWR VGND sky130_ef_sc_hd__decap_12
XFILLER_114_1244 VGND VGND VPWR VPWR sky130_fd_sc_hd__fill_1
XFILLER_7_1357 VPWR VGND VPWR VGND sky130_ef_sc_hd__decap_12
XFILLER_209_559 VGND VGND VPWR VPWR sky130_fd_sc_hd__fill_1
XFILLER_205_721 VGND VGND VPWR VPWR sky130_fd_sc_hd__decap_6
XTAP_TAPCELL_ROW_96_2_3604 VGND VPWR sky130_fd_sc_hd__tapvpwrvgnd_1
XFILLER_205_765 VPWR VGND VPWR VGND sky130_ef_sc_hd__decap_12
XFILLER_204_253 VPWR VGND VPWR VGND sky130_ef_sc_hd__decap_12
XFILLER_186_1091 VGND VGND VPWR VPWR sky130_fd_sc_hd__fill_1
X_578_ clknet_3_0_0_clk _002_ VGND VGND VPWR VPWR b_ce sky130_fd_sc_hd__dfxtp_1
XFILLER_177_617 VPWR VGND VPWR VGND sky130_ef_sc_hd__decap_12
XFILLER_162_1518 VGND VGND VPWR VPWR sky130_fd_sc_hd__decap_6
XFILLER_31_122 VGND VGND VPWR VPWR sky130_fd_sc_hd__fill_1
XFILLER_160_1220 VPWR VGND VPWR VGND sky130_ef_sc_hd__decap_12
XFILLER_73_1272 VGND VGND VPWR VPWR sky130_fd_sc_hd__fill_1
XFILLER_38_1370 VPWR VGND VPWR VGND sky130_ef_sc_hd__decap_12
XFILLER_203_1537 VPWR VGND VPWR VGND sky130_ef_sc_hd__decap_12
XFILLER_125_1384 VGND VGND VPWR VPWR sky130_fd_sc_hd__fill_1
XTAP_TAPCELL_ROW_45_2_3271 VGND VPWR sky130_fd_sc_hd__tapvpwrvgnd_1
XFILLER_172_333 VPWR VGND VPWR VGND sky130_ef_sc_hd__decap_12
XFILLER_68_3 VPWR VGND VPWR VGND sky130_ef_sc_hd__decap_12
XFILLER_173_889 VGND VGND VPWR VPWR sky130_fd_sc_hd__decap_6
XFILLER_172_377 VPWR VGND VPWR VGND sky130_ef_sc_hd__decap_12
XFILLER_207_55 VGND VGND VPWR VPWR sky130_fd_sc_hd__fill_1
XFILLER_45_1330 VPWR VGND VPWR VGND sky130_ef_sc_hd__decap_12
XFILLER_132_1300 VGND VGND VPWR VPWR sky130_fd_sc_hd__fill_1
XFILLER_80_1232 VPWR VGND VPWR VGND sky130_ef_sc_hd__decap_12
XTAP_TAPCELL_ROW_37_2_3219 VGND VPWR sky130_fd_sc_hd__tapvpwrvgnd_1
.ends
